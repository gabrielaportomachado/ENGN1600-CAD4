* NGSPICE file created from ALU.ext - technology: gf180mcuD

.subckt MUX21 a_1472_63# a_157_63# a_25_271# a_909_n37# a_650_n277# a_517_n37# a_718_407#
+ m2_540_79# via_dev$11_4/VSUBS a_846_955# w_n310_281#
X0 a_1472_63# m2_540_79# via_dev$11_4/VSUBS via_dev$11_4/VSUBS nfet_03v3 ad=0.2625p pd=2.05u as=0.265p ps=2.06u w=0.5u l=0.28u
X1 a_157_63# a_25_271# w_n310_281# w_n310_281# pfet_03v3 ad=0.65p pd=3.3u as=0.635p ps=3.27u w=1u l=0.28u
X2 a_718_407# a_650_n277# m2_540_79# w_n310_281# pfet_03v3 ad=0.675p pd=2.675u as=0.725p ps=2.725u w=2u l=0.28u
X3 a_517_n37# a_25_271# via_dev$11_4/VSUBS via_dev$11_4/VSUBS nfet_03v3 ad=0.3625p pd=1.725u as=0.54p ps=3.08u w=1u l=0.28u
X4 via_dev$11_4/VSUBS a_157_63# a_909_n37# via_dev$11_4/VSUBS nfet_03v3 ad=0.65p pd=3.3u as=0.3625p ps=1.725u w=1u l=0.28u
X5 m2_540_79# a_25_271# a_718_407# w_n310_281# pfet_03v3 ad=0.725p pd=2.725u as=1.09p ps=5.09u w=2u l=0.28u
X6 a_157_63# a_25_271# via_dev$11_4/VSUBS via_dev$11_4/VSUBS nfet_03v3 ad=0.315p pd=2.26u as=0.3175p ps=2.27u w=0.5u l=0.28u
X7 a_718_407# a_157_63# w_n310_281# w_n310_281# pfet_03v3 ad=1.3p pd=5.3u as=0.725p ps=2.725u w=2u l=0.28u
X8 a_909_n37# a_846_955# m2_540_79# via_dev$11_4/VSUBS nfet_03v3 ad=0.3625p pd=1.725u as=0.3375p ps=1.675u w=1u l=0.28u
X9 w_n310_281# a_846_955# a_718_407# w_n310_281# pfet_03v3 ad=0.725p pd=2.725u as=0.675p ps=2.675u w=2u l=0.28u
X10 a_1472_63# m2_540_79# w_n310_281# w_n310_281# pfet_03v3 ad=0.545p pd=3.09u as=0.53p ps=3.06u w=1u l=0.28u
X11 m2_540_79# a_650_n277# a_517_n37# via_dev$11_4/VSUBS nfet_03v3 ad=0.3375p pd=1.675u as=0.3625p ps=1.725u w=1u l=0.28u
C0 w_n310_281# a_25_271# 0.47695f
C1 a_25_271# a_718_407# 0.03028f
C2 a_846_955# m2_540_79# 0.017f
C3 a_650_n277# a_157_63# 0.02096f
C4 a_157_63# a_1472_63# 0.0156f
C5 w_n310_281# a_718_407# 0.7633f
C6 a_909_n37# m2_540_79# 0.01048f
C7 a_25_271# a_650_n277# 0.03814f
C8 a_846_955# a_157_63# 0.07151f
C9 a_25_271# a_1472_63# 0
C10 a_157_63# m2_540_79# 0.36591f
C11 a_517_n37# m2_540_79# 0.01733f
C12 w_n310_281# a_650_n277# 0.11257f
C13 w_n310_281# a_1472_63# 0.08569f
C14 a_650_n277# a_718_407# 0.01687f
C15 a_157_63# a_909_n37# 0.01329f
C16 a_25_271# m2_540_79# 0.03352f
C17 a_1472_63# a_718_407# 0.01268f
C18 w_n310_281# a_846_955# 0.19275f
C19 a_846_955# a_718_407# 0.01845f
C20 a_157_63# a_517_n37# 0.00935f
C21 w_n310_281# m2_540_79# 0.45246f
C22 a_718_407# m2_540_79# 0.49779f
C23 a_25_271# a_157_63# 0.11031f
C24 a_650_n277# a_1472_63# 0
C25 a_846_955# a_650_n277# 0.04128f
C26 w_n310_281# a_157_63# 0.32873f
C27 a_846_955# a_1472_63# 0
C28 a_650_n277# m2_540_79# 0.03687f
C29 a_157_63# a_718_407# 0.14486f
C30 a_517_n37# a_718_407# 0
C31 a_1472_63# m2_540_79# 0.0785f
C32 m2_540_79# via_dev$11_4/VSUBS 0.94619f
C33 a_718_407# via_dev$11_4/VSUBS 0.15332f
C34 a_909_n37# via_dev$11_4/VSUBS 0.01743f
C35 a_517_n37# via_dev$11_4/VSUBS 0.007f
C36 a_1472_63# via_dev$11_4/VSUBS 0.18031f
C37 a_157_63# via_dev$11_4/VSUBS 0.63396f
C38 a_650_n277# via_dev$11_4/VSUBS 0.37069f
C39 a_25_271# via_dev$11_4/VSUBS 0.66513f
C40 a_846_955# via_dev$11_4/VSUBS 0.36058f
C41 w_n310_281# via_dev$11_4/VSUBS 4.18493f
.ends

.subckt x1bitblock$2 a_2861_3# a_8361_407# a_6520_n37# a_1262_n37# a_2861_391# a_1845_466#
+ a_10906_n37# a_510_63# a_870_n37# a_6721_407# a_9800_n37# a_11480_63# a_6128_n37#
+ a_5768_63# a_8919_367# m2_6151_79# a_11922_391# a_5042_n37# a_9408_n37# a_9609_407#
+ a_5042_407# a_8160_n37# a_4158_271# a_11922_3# a_2419_63# m2_9431_79# a_10906_466#
+ a_4650_n37# a_9050_63# a_5243_407# a_7768_n37# a_3940_63# m2_7791_79# a_10363_63#
+ a_160_63# a_4290_63# a_7083_63# a_705_407# a_12559_3# a_7410_63# m2_5700_324# a_1845_n37#
+ via_dev$5$2_9/VSUBS m2_1295_79# a_8723_63# a_378_271# a_3498_3# w_n310_281# m2_24_342#
X0 a_2419_63# a_1845_466# via_dev$5$2_9/VSUBS via_dev$5$2_9/VSUBS nfet_03v3 ad=0.315p pd=2.26u as=0.2425p ps=1.97u w=0.5u l=0.28u
X1 a_1845_466# m2_24_342# a_1845_n37# via_dev$5$2_9/VSUBS nfet_03v3 ad=0.65p pd=3.3u as=0.42p ps=1.84u w=1u l=0.28u
X2 a_3940_63# m2_1295_79# w_n310_281# w_n310_281# pfet_03v3 ad=0.63p pd=3.26u as=0.65p ps=3.3u w=1u l=0.28u
X3 via_dev$5$2_9/VSUBS a_510_63# a_1262_n37# via_dev$5$2_9/VSUBS nfet_03v3 ad=0.65p pd=3.3u as=0.3625p ps=1.725u w=1u l=0.28u
X4 a_5243_407# a_4290_63# a_5042_407# w_n310_281# pfet_03v3 ad=1.3p pd=5.3u as=0.725p ps=2.725u w=2u l=0.28u
X5 a_6721_407# a_2419_63# m2_6151_79# w_n310_281# pfet_03v3 ad=0.675p pd=2.675u as=0.725p ps=2.725u w=2u l=0.28u
X6 a_10906_466# a_4158_271# w_n310_281# w_n310_281# pfet_03v3 ad=0.42p pd=1.84u as=0.65p ps=3.3u w=1u l=0.28u
X7 a_4290_63# a_4158_271# via_dev$5$2_9/VSUBS via_dev$5$2_9/VSUBS nfet_03v3 ad=0.315p pd=2.26u as=0.28p ps=2.12u w=0.5u l=0.28u
X8 w_n310_281# a_378_271# a_705_407# w_n310_281# pfet_03v3 ad=0.725p pd=2.725u as=1.09p ps=5.09u w=2u l=0.28u
X9 a_2861_3# m2_1295_79# via_dev$5$2_9/VSUBS via_dev$5$2_9/VSUBS nfet_03v3 ad=0.18125p pd=1.225u as=0.325p ps=2.3u w=0.5u l=0.28u
X10 via_dev$5$2_9/VSUBS a_2419_63# a_2861_3# via_dev$5$2_9/VSUBS nfet_03v3 ad=0.315p pd=2.26u as=0.18125p ps=1.225u w=0.5u l=0.28u
X11 m2_7791_79# m2_1295_79# a_7768_n37# via_dev$5$2_9/VSUBS nfet_03v3 ad=0.3375p pd=1.675u as=0.3625p ps=1.725u w=1u l=0.28u
X12 a_10906_n37# a_4158_271# via_dev$5$2_9/VSUBS via_dev$5$2_9/VSUBS nfet_03v3 ad=0.42p pd=1.84u as=0.63p ps=3.26u w=1u l=0.28u
X13 a_9050_63# a_8919_367# via_dev$5$2_9/VSUBS via_dev$5$2_9/VSUBS nfet_03v3 ad=0.31p pd=2.24u as=0.24p ps=1.96u w=0.5u l=0.28u
X14 a_11922_3# a_11480_63# via_dev$5$2_9/VSUBS via_dev$5$2_9/VSUBS nfet_03v3 ad=0.18125p pd=1.225u as=0.325p ps=2.3u w=0.5u l=0.28u
X15 via_dev$5$2_9/VSUBS a_2419_63# a_11922_3# via_dev$5$2_9/VSUBS nfet_03v3 ad=0.315p pd=2.26u as=0.18125p ps=1.225u w=0.5u l=0.28u
X16 a_705_407# a_510_63# m2_1295_79# w_n310_281# pfet_03v3 ad=1.3p pd=5.3u as=0.725p ps=2.725u w=2u l=0.28u
X17 a_4650_n37# a_4158_271# via_dev$5$2_9/VSUBS via_dev$5$2_9/VSUBS nfet_03v3 ad=0.3625p pd=1.725u as=0.54p ps=3.08u w=1u l=0.28u
X18 a_2861_3# a_2419_63# a_2861_391# w_n310_281# pfet_03v3 ad=1.3p pd=5.3u as=0.725p ps=2.725u w=2u l=0.28u
X19 a_5768_63# m2_5700_324# via_dev$5$2_9/VSUBS via_dev$5$2_9/VSUBS nfet_03v3 ad=0.315p pd=2.26u as=0.3175p ps=2.27u w=0.5u l=0.28u
X20 via_dev$5$2_9/VSUBS a_9050_63# a_9800_n37# via_dev$5$2_9/VSUBS nfet_03v3 ad=0.65p pd=3.3u as=0.3625p ps=1.725u w=1u l=0.28u
X21 a_8361_407# m2_1295_79# m2_7791_79# w_n310_281# pfet_03v3 ad=0.675p pd=2.675u as=0.725p ps=2.725u w=2u l=0.28u
X22 a_9408_n37# a_8919_367# via_dev$5$2_9/VSUBS via_dev$5$2_9/VSUBS nfet_03v3 ad=0.3625p pd=1.725u as=0.54p ps=3.08u w=1u l=0.28u
X23 a_3498_3# a_2861_3# w_n310_281# w_n310_281# pfet_03v3 ad=0.65p pd=3.3u as=0.675p ps=3.35u w=1u l=0.28u
X24 a_7410_63# m2_5700_324# via_dev$5$2_9/VSUBS via_dev$5$2_9/VSUBS nfet_03v3 ad=0.31p pd=2.24u as=0.24p ps=1.96u w=0.5u l=0.28u
X25 via_dev$5$2_9/VSUBS a_7410_63# a_8160_n37# via_dev$5$2_9/VSUBS nfet_03v3 ad=0.65p pd=3.3u as=0.3625p ps=1.725u w=1u l=0.28u
X26 a_8723_63# m2_7791_79# via_dev$5$2_9/VSUBS via_dev$5$2_9/VSUBS nfet_03v3 ad=0.2625p pd=2.05u as=0.265p ps=2.06u w=0.5u l=0.28u
X27 w_n310_281# a_4158_271# a_5243_407# w_n310_281# pfet_03v3 ad=0.725p pd=2.725u as=1.09p ps=5.09u w=2u l=0.28u
X28 a_5768_63# m2_5700_324# w_n310_281# w_n310_281# pfet_03v3 ad=0.65p pd=3.3u as=0.635p ps=3.27u w=1u l=0.28u
X29 a_9050_63# a_8919_367# w_n310_281# w_n310_281# pfet_03v3 ad=0.64p pd=3.28u as=0.48p ps=2.96u w=1u l=0.28u
X30 a_11922_391# a_11480_63# w_n310_281# w_n310_281# pfet_03v3 ad=0.725p pd=2.725u as=1.3p ps=5.3u w=2u l=0.28u
X31 a_160_63# m2_24_342# via_dev$5$2_9/VSUBS via_dev$5$2_9/VSUBS nfet_03v3 ad=0.315p pd=2.26u as=0.325p ps=2.3u w=0.5u l=0.28u
X32 a_9609_407# a_9050_63# w_n310_281# w_n310_281# pfet_03v3 ad=1.3p pd=5.3u as=0.725p ps=2.725u w=2u l=0.28u
X33 a_6128_n37# m2_5700_324# via_dev$5$2_9/VSUBS via_dev$5$2_9/VSUBS nfet_03v3 ad=0.3625p pd=1.725u as=0.54p ps=3.08u w=1u l=0.28u
X34 via_dev$5$2_9/VSUBS a_5768_63# a_6520_n37# via_dev$5$2_9/VSUBS nfet_03v3 ad=0.65p pd=3.3u as=0.3625p ps=1.725u w=1u l=0.28u
X35 a_7410_63# m2_5700_324# w_n310_281# w_n310_281# pfet_03v3 ad=0.64p pd=3.28u as=0.48p ps=2.96u w=1u l=0.28u
X36 m2_9431_79# a_8919_367# a_9609_407# w_n310_281# pfet_03v3 ad=0.725p pd=2.725u as=1.09p ps=5.09u w=2u l=0.28u
X37 a_11480_63# a_10906_466# via_dev$5$2_9/VSUBS via_dev$5$2_9/VSUBS nfet_03v3 ad=0.315p pd=2.26u as=0.2425p ps=1.97u w=0.5u l=0.28u
X38 a_1845_466# a_378_271# w_n310_281# w_n310_281# pfet_03v3 ad=0.42p pd=1.84u as=0.65p ps=3.3u w=1u l=0.28u
X39 a_8361_407# a_7410_63# w_n310_281# w_n310_281# pfet_03v3 ad=1.3p pd=5.3u as=0.725p ps=2.725u w=2u l=0.28u
X40 w_n310_281# m2_1295_79# a_10906_466# w_n310_281# pfet_03v3 ad=0.735p pd=2.47u as=0.42p ps=1.84u w=1u l=0.28u
X41 a_7083_63# m2_6151_79# via_dev$5$2_9/VSUBS via_dev$5$2_9/VSUBS nfet_03v3 ad=0.2625p pd=2.05u as=0.265p ps=2.06u w=0.5u l=0.28u
X42 a_510_63# a_378_271# w_n310_281# w_n310_281# pfet_03v3 ad=0.65p pd=3.3u as=0.56p ps=3.12u w=1u l=0.28u
X43 a_10363_63# m2_9431_79# w_n310_281# w_n310_281# pfet_03v3 ad=0.715p pd=3.43u as=0.53p ps=3.06u w=1u l=0.28u
X44 a_510_63# a_378_271# via_dev$5$2_9/VSUBS via_dev$5$2_9/VSUBS nfet_03v3 ad=0.315p pd=2.26u as=0.28p ps=2.12u w=0.5u l=0.28u
X45 a_1262_n37# a_160_63# m2_1295_79# via_dev$5$2_9/VSUBS nfet_03v3 ad=0.3625p pd=1.725u as=0.3375p ps=1.675u w=1u l=0.28u
X46 a_1845_n37# a_378_271# via_dev$5$2_9/VSUBS via_dev$5$2_9/VSUBS nfet_03v3 ad=0.42p pd=1.84u as=0.63p ps=3.26u w=1u l=0.28u
X47 m2_6151_79# m2_5700_324# a_6721_407# w_n310_281# pfet_03v3 ad=0.725p pd=2.725u as=1.09p ps=5.09u w=2u l=0.28u
X48 a_6721_407# a_5768_63# w_n310_281# w_n310_281# pfet_03v3 ad=1.3p pd=5.3u as=0.725p ps=2.725u w=2u l=0.28u
X49 a_10363_63# m2_9431_79# via_dev$5$2_9/VSUBS via_dev$5$2_9/VSUBS nfet_03v3 ad=0.3575p pd=2.43u as=0.265p ps=2.06u w=0.5u l=0.28u
X50 a_10906_466# m2_1295_79# a_10906_n37# via_dev$5$2_9/VSUBS nfet_03v3 ad=0.65p pd=3.3u as=0.42p ps=1.84u w=1u l=0.28u
X51 a_8723_63# m2_7791_79# w_n310_281# w_n310_281# pfet_03v3 ad=0.545p pd=3.09u as=0.53p ps=3.06u w=1u l=0.28u
X52 a_11480_63# a_10906_466# w_n310_281# w_n310_281# pfet_03v3 ad=0.65p pd=3.3u as=0.735p ps=2.47u w=1u l=0.28u
X53 a_12559_3# a_11922_3# via_dev$5$2_9/VSUBS via_dev$5$2_9/VSUBS nfet_03v3 ad=0.315p pd=2.26u as=0.325p ps=2.3u w=0.5u l=0.28u
X54 a_7083_63# m2_6151_79# w_n310_281# w_n310_281# pfet_03v3 ad=0.545p pd=3.09u as=0.53p ps=3.06u w=1u l=0.28u
X55 a_7768_n37# m2_5700_324# via_dev$5$2_9/VSUBS via_dev$5$2_9/VSUBS nfet_03v3 ad=0.3625p pd=1.725u as=0.54p ps=3.08u w=1u l=0.28u
X56 a_160_63# m2_24_342# w_n310_281# w_n310_281# pfet_03v3 ad=0.63p pd=3.26u as=0.65p ps=3.3u w=1u l=0.28u
X57 m2_1295_79# a_160_63# a_705_407# w_n310_281# pfet_03v3 ad=0.725p pd=2.725u as=0.675p ps=2.675u w=2u l=0.28u
X58 a_5042_n37# a_3940_63# a_5042_407# via_dev$5$2_9/VSUBS nfet_03v3 ad=0.3625p pd=1.725u as=0.3375p ps=1.675u w=1u l=0.28u
X59 m2_1295_79# m2_24_342# a_870_n37# via_dev$5$2_9/VSUBS nfet_03v3 ad=0.3375p pd=1.675u as=0.3625p ps=1.725u w=1u l=0.28u
X60 a_11922_3# a_2419_63# a_11922_391# w_n310_281# pfet_03v3 ad=1.3p pd=5.3u as=0.725p ps=2.725u w=2u l=0.28u
X61 a_9800_n37# a_7083_63# m2_9431_79# via_dev$5$2_9/VSUBS nfet_03v3 ad=0.3625p pd=1.725u as=0.3375p ps=1.675u w=1u l=0.28u
X62 m2_7791_79# m2_5700_324# a_8361_407# w_n310_281# pfet_03v3 ad=0.725p pd=2.725u as=1.09p ps=5.09u w=2u l=0.28u
X63 a_5042_407# a_3940_63# a_5243_407# w_n310_281# pfet_03v3 ad=0.725p pd=2.725u as=0.675p ps=2.675u w=2u l=0.28u
X64 a_3940_63# m2_1295_79# via_dev$5$2_9/VSUBS via_dev$5$2_9/VSUBS nfet_03v3 ad=0.315p pd=2.26u as=0.325p ps=2.3u w=0.5u l=0.28u
X65 a_8160_n37# a_3498_3# m2_7791_79# via_dev$5$2_9/VSUBS nfet_03v3 ad=0.3625p pd=1.725u as=0.3375p ps=1.675u w=1u l=0.28u
X66 a_705_407# m2_24_342# w_n310_281# w_n310_281# pfet_03v3 ad=0.675p pd=2.675u as=0.725p ps=2.725u w=2u l=0.28u
X67 a_5042_407# m2_1295_79# a_4650_n37# via_dev$5$2_9/VSUBS nfet_03v3 ad=0.3375p pd=1.675u as=0.3625p ps=1.725u w=1u l=0.28u
X68 a_6520_n37# a_5042_407# m2_6151_79# via_dev$5$2_9/VSUBS nfet_03v3 ad=0.3625p pd=1.725u as=0.3375p ps=1.675u w=1u l=0.28u
X69 w_n310_281# a_7083_63# a_9609_407# w_n310_281# pfet_03v3 ad=0.725p pd=2.725u as=0.675p ps=2.675u w=2u l=0.28u
X70 a_2419_63# a_1845_466# w_n310_281# w_n310_281# pfet_03v3 ad=0.65p pd=3.3u as=0.735p ps=2.47u w=1u l=0.28u
X71 m2_9431_79# a_8723_63# a_9408_n37# via_dev$5$2_9/VSUBS nfet_03v3 ad=0.3375p pd=1.675u as=0.3625p ps=1.725u w=1u l=0.28u
X72 w_n310_281# a_3498_3# a_8361_407# w_n310_281# pfet_03v3 ad=0.725p pd=2.725u as=0.675p ps=2.675u w=2u l=0.28u
X73 a_2861_391# m2_1295_79# w_n310_281# w_n310_281# pfet_03v3 ad=0.725p pd=2.725u as=1.3p ps=5.3u w=2u l=0.28u
X74 a_4290_63# a_4158_271# w_n310_281# w_n310_281# pfet_03v3 ad=0.65p pd=3.3u as=0.56p ps=3.12u w=1u l=0.28u
X75 a_5243_407# m2_1295_79# w_n310_281# w_n310_281# pfet_03v3 ad=0.675p pd=2.675u as=0.725p ps=2.725u w=2u l=0.28u
X76 w_n310_281# a_5042_407# a_6721_407# w_n310_281# pfet_03v3 ad=0.725p pd=2.725u as=0.675p ps=2.675u w=2u l=0.28u
X77 a_3498_3# a_2861_3# via_dev$5$2_9/VSUBS via_dev$5$2_9/VSUBS nfet_03v3 ad=0.315p pd=2.26u as=0.325p ps=2.3u w=0.5u l=0.28u
X78 a_9609_407# a_8723_63# m2_9431_79# w_n310_281# pfet_03v3 ad=0.675p pd=2.675u as=0.725p ps=2.725u w=2u l=0.28u
X79 via_dev$5$2_9/VSUBS a_4290_63# a_5042_n37# via_dev$5$2_9/VSUBS nfet_03v3 ad=0.65p pd=3.3u as=0.3625p ps=1.725u w=1u l=0.28u
X80 m2_6151_79# a_2419_63# a_6128_n37# via_dev$5$2_9/VSUBS nfet_03v3 ad=0.3375p pd=1.675u as=0.3625p ps=1.725u w=1u l=0.28u
X81 w_n310_281# m2_24_342# a_1845_466# w_n310_281# pfet_03v3 ad=0.735p pd=2.47u as=0.42p ps=1.84u w=1u l=0.28u
X82 a_870_n37# a_378_271# via_dev$5$2_9/VSUBS via_dev$5$2_9/VSUBS nfet_03v3 ad=0.3625p pd=1.725u as=0.54p ps=3.08u w=1u l=0.28u
X83 a_12559_3# a_11922_3# w_n310_281# w_n310_281# pfet_03v3 ad=0.65p pd=3.3u as=0.675p ps=3.35u w=1u l=0.28u
C0 w_n310_281# a_2419_63# 0.75129f
C1 w_n310_281# a_160_63# 0.30515f
C2 w_n310_281# a_6721_407# 0.72579f
C3 a_7410_63# a_8361_407# 0.1423f
C4 a_4290_63# m2_1295_79# 0.13519f
C5 a_5042_n37# a_4158_271# 0
C6 w_n310_281# m2_9431_79# 0.46254f
C7 w_n310_281# a_10906_n37# 0
C8 a_7410_63# a_7083_63# 0.07718f
C9 a_2419_63# a_8919_367# 0.01445f
C10 a_7410_63# m2_1295_79# 0.07614f
C11 a_6128_n37# m2_6151_79# 0.01733f
C12 w_n310_281# a_5042_407# 0.29911f
C13 w_n310_281# a_11480_63# 0.37298f
C14 a_7410_63# a_8723_63# 0.01398f
C15 a_8919_367# m2_9431_79# 0.03216f
C16 a_378_271# a_705_407# 0.02817f
C17 w_n310_281# a_3940_63# 0.30087f
C18 a_6128_n37# a_6721_407# 0
C19 w_n310_281# a_12559_3# 0.08598f
C20 w_n310_281# a_2861_391# 0.03535f
C21 a_378_271# a_160_63# 0.09182f
C22 a_4290_63# a_4650_n37# 0.01502f
C23 a_6128_n37# a_5042_407# 0.00376f
C24 a_2419_63# a_9050_63# 0.00801f
C25 a_2861_3# a_4290_63# 0
C26 a_9050_63# m2_9431_79# 0.328f
C27 m2_5700_324# w_n310_281# 1.65678f
C28 a_510_63# a_1845_466# 0.01433f
C29 a_6520_n37# m2_6151_79# 0.00766f
C30 a_510_63# m2_1295_79# 0.39896f
C31 m2_5700_324# a_8919_367# 0
C32 a_7768_n37# m2_7791_79# 0.01733f
C33 a_4290_63# a_5042_n37# 0.00898f
C34 a_6520_n37# a_5042_407# 0.00483f
C35 a_870_n37# m2_1295_79# 0.00639f
C36 a_1845_466# a_870_n37# 0
C37 a_7768_n37# a_8361_407# 0
C38 a_7768_n37# a_7083_63# 0.0028f
C39 w_n310_281# a_8919_367# 0.49838f
C40 a_8160_n37# m2_7791_79# 0.01048f
C41 m2_24_342# a_705_407# 0.10607f
C42 a_1845_466# a_1262_n37# 0
C43 a_1262_n37# m2_1295_79# 0.01607f
C44 w_n310_281# a_378_271# 0.6337f
C45 w_n310_281# a_9050_63# 0.28931f
C46 m2_24_342# a_3498_3# 0
C47 m2_24_342# a_2419_63# 0.00234f
C48 m2_24_342# a_160_63# 0.42316f
C49 a_8160_n37# a_7083_63# 0.00507f
C50 a_8919_367# a_9050_63# 0.10006f
C51 a_9408_n37# m2_9431_79# 0.01733f
C52 a_7410_63# a_7768_n37# 0.00935f
C53 a_5768_63# m2_6151_79# 0.35511f
C54 m2_6151_79# m2_7791_79# 0.00114f
C55 a_5768_63# a_3498_3# 0
C56 a_3498_3# m2_7791_79# 0.0296f
C57 a_2419_63# a_5768_63# 0.07749f
C58 a_2419_63# m2_7791_79# 0.00843f
C59 a_3498_3# a_5243_407# 0.16427f
C60 a_5768_63# a_6721_407# 0.14017f
C61 a_2419_63# a_5243_407# 0
C62 a_510_63# a_870_n37# 0.01502f
C63 m2_6151_79# a_4158_271# 0.04334f
C64 m2_7791_79# m2_9431_79# 0.01571f
C65 a_9800_n37# m2_9431_79# 0.0074f
C66 a_2419_63# a_9609_407# 0
C67 a_3498_3# a_4158_271# 0.00829f
C68 a_5768_63# a_5042_407# 0.22596f
C69 a_2419_63# a_4158_271# 0.14782f
C70 a_5042_407# m2_7791_79# 0.00555f
C71 a_1845_466# a_705_407# 0.0126f
C72 a_705_407# m2_1295_79# 0.30816f
C73 m2_6151_79# a_7083_63# 0.08089f
C74 a_9609_407# m2_9431_79# 0.49779f
C75 a_5243_407# a_5042_407# 0.29512f
C76 a_3498_3# a_8361_407# 0.12093f
C77 a_2419_63# a_10363_63# 0.00126f
C78 a_7410_63# a_8160_n37# 0.01329f
C79 a_2419_63# a_8361_407# 0
C80 m2_9431_79# a_4158_271# 0.05572f
C81 a_10906_n37# a_4158_271# 0.00824f
C82 m2_1295_79# m2_6151_79# 0.00667f
C83 a_3498_3# a_7083_63# 0.01356f
C84 a_2419_63# a_11922_3# 0.16984f
C85 a_5768_63# a_3940_63# 0
C86 a_2419_63# a_7083_63# 0.01345f
C87 a_1845_466# a_3498_3# 0.00105f
C88 a_3498_3# m2_1295_79# 0.3391f
C89 a_10363_63# m2_9431_79# 0.07766f
C90 a_11480_63# a_9609_407# 0
C91 a_10363_63# a_10906_n37# 0
C92 a_2419_63# a_1845_466# 0.10509f
C93 w_n310_281# a_1845_n37# 0
C94 a_5042_407# a_4158_271# 0.63867f
C95 a_8361_407# m2_9431_79# 0
C96 a_6721_407# a_7083_63# 0.01268f
C97 a_1845_466# a_160_63# 0
C98 a_2419_63# m2_1295_79# 0.32461f
C99 a_160_63# m2_1295_79# 0.09339f
C100 a_5243_407# a_3940_63# 0.06737f
C101 a_11480_63# a_4158_271# 0.00295f
C102 m2_9431_79# a_7083_63# 0.19293f
C103 a_3498_3# a_8723_63# 0.00575f
C104 m2_1295_79# a_6721_407# 0.00452f
C105 a_2419_63# a_11922_391# 0.00754f
C106 a_10363_63# a_11480_63# 0
C107 a_2419_63# a_8723_63# 0.00661f
C108 m2_1295_79# m2_9431_79# 0.0078f
C109 a_11480_63# a_11922_3# 0.04054f
C110 m2_24_342# w_n310_281# 0.66878f
C111 a_3940_63# a_4158_271# 0.16366f
C112 a_5042_407# a_7083_63# 0.02611f
C113 a_510_63# a_1262_n37# 0.00898f
C114 m2_9431_79# a_8723_63# 0.13485f
C115 m2_1295_79# a_5042_407# 0.03487f
C116 a_2419_63# a_10906_466# 0.00833f
C117 a_11480_63# m2_1295_79# 0.00126f
C118 m2_5700_324# a_5768_63# 0.16447f
C119 m2_5700_324# m2_7791_79# 0.05245f
C120 a_11480_63# a_11922_391# 0.00152f
C121 m2_5700_324# a_5243_407# 0.01927f
C122 a_2861_3# a_705_407# 0
C123 a_10906_466# m2_9431_79# 0.00167f
C124 a_10906_466# a_10906_n37# 0.01333f
C125 a_11922_3# a_12559_3# 0.0899f
C126 a_1845_466# a_3940_63# 0
C127 m2_1295_79# a_3940_63# 0.46061f
C128 a_11480_63# a_10906_466# 0.1131f
C129 m2_5700_324# a_4158_271# 0.00861f
C130 a_2861_3# a_3498_3# 0.09846f
C131 a_2419_63# a_2861_3# 0.21478f
C132 a_2861_391# m2_1295_79# 0.00841f
C133 m2_5700_324# a_8361_407# 0.05956f
C134 m2_5700_324# a_7083_63# 0.12051f
C135 a_4290_63# m2_6151_79# 0
C136 a_4650_n37# a_5042_407# 0.00712f
C137 a_10906_466# a_12559_3# 0
C138 m2_24_342# a_378_271# 0.56715f
C139 m2_5700_324# m2_1295_79# 0.07849f
C140 a_4290_63# a_3498_3# 0.00876f
C141 a_7410_63# m2_6151_79# 0
C142 a_2419_63# a_4290_63# 0.00652f
C143 w_n310_281# a_5768_63# 0.31314f
C144 a_2861_3# a_5042_407# 0
C145 w_n310_281# m2_7791_79# 0.45139f
C146 a_9050_63# a_9408_n37# 0.00935f
C147 a_7410_63# a_3498_3# 0.11774f
C148 m2_5700_324# a_8723_63# 0
C149 w_n310_281# a_5243_407# 0.78984f
C150 a_4650_n37# a_3940_63# 0.00441f
C151 a_2419_63# a_7410_63# 0.00801f
C152 a_5042_n37# m2_6151_79# 0
C153 a_2861_3# a_3940_63# 0
C154 w_n310_281# a_9609_407# 0.7653f
C155 a_7410_63# m2_9431_79# 0.00105f
C156 a_8919_367# m2_7791_79# 0.02774f
C157 a_4290_63# a_5042_407# 0.38112f
C158 w_n310_281# a_4158_271# 0.66883f
C159 w_n310_281# a_10363_63# 0.15741f
C160 a_7410_63# a_5042_407# 0
C161 a_2861_391# a_2861_3# 0.01616f
C162 a_5768_63# a_6128_n37# 0.00935f
C163 w_n310_281# a_8361_407# 0.75753f
C164 w_n310_281# a_11922_3# 0.46598f
C165 a_8919_367# a_9609_407# 0.02942f
C166 a_4290_63# a_3940_63# 0.28903f
C167 w_n310_281# a_7083_63# 0.31663f
C168 a_8919_367# a_4158_271# 0.001f
C169 w_n310_281# a_1845_466# 0.44517f
C170 a_510_63# a_705_407# 0.13828f
C171 w_n310_281# m2_1295_79# 2.3522f
C172 a_5042_n37# a_5042_407# 0.01726f
C173 a_8919_367# a_10363_63# 0
C174 w_n310_281# a_11922_391# 0.03535f
C175 a_8919_367# a_8361_407# 0
C176 w_n310_281# a_8723_63# 0.33584f
C177 a_9050_63# m2_7791_79# 0.00127f
C178 a_8919_367# a_7083_63# 0.01057f
C179 a_9050_63# a_9800_n37# 0.01329f
C180 a_8919_367# m2_1295_79# 0.01372f
C181 a_510_63# a_160_63# 0.28903f
C182 w_n310_281# a_10906_466# 0.44509f
C183 m2_5700_324# a_4290_63# 0.01531f
C184 a_8919_367# a_8723_63# 0.12587f
C185 a_9050_63# a_9609_407# 0.1261f
C186 m2_5700_324# a_7410_63# 0.14432f
C187 a_9050_63# a_4158_271# 0.00717f
C188 a_5768_63# a_6520_n37# 0.01329f
C189 a_9050_63# a_10363_63# 0.01385f
C190 a_9050_63# a_8361_407# 0
C191 a_9050_63# a_7083_63# 0.21474f
C192 a_378_271# a_1845_466# 0.01278f
C193 w_n310_281# a_2861_3# 0.4655f
C194 a_378_271# m2_1295_79# 0.02669f
C195 a_9050_63# m2_1295_79# 0.00716f
C196 a_870_n37# a_160_63# 0.00441f
C197 a_6520_n37# a_4158_271# 0.00406f
C198 a_9050_63# a_8723_63# 0.53121f
C199 w_n310_281# a_4290_63# 0.2819f
C200 a_6520_n37# a_7083_63# 0.00272f
C201 w_n310_281# a_7410_63# 0.31086f
C202 a_1262_n37# a_705_407# 0
C203 a_7768_n37# m2_9431_79# 0
C204 a_7410_63# a_8919_367# 0
C205 w_n310_281# a_510_63# 0.28255f
C206 a_9408_n37# m2_7791_79# 0
C207 a_8160_n37# m2_9431_79# 0
C208 a_9408_n37# a_9609_407# 0
C209 a_1845_466# a_1845_n37# 0.01333f
C210 a_1845_n37# m2_1295_79# 0.00942f
C211 m2_24_342# a_1845_466# 0.06999f
C212 m2_24_342# m2_1295_79# 0.04399f
C213 a_9408_n37# a_7083_63# 0.00336f
C214 a_378_271# a_510_63# 0.14298f
C215 a_5768_63# m2_7791_79# 0
C216 a_5768_63# a_5243_407# 0.00722f
C217 a_2419_63# a_705_407# 0
C218 a_705_407# a_160_63# 0.06737f
C219 a_9609_407# m2_7791_79# 0
C220 a_3498_3# m2_6151_79# 0
C221 a_5768_63# a_4158_271# 0.00573f
C222 m2_7791_79# a_4158_271# 0
C223 a_2419_63# m2_6151_79# 0.05852f
C224 a_9800_n37# a_4158_271# 0.00497f
C225 a_5243_407# a_4158_271# 0.02964f
C226 a_6721_407# m2_6151_79# 0.4935f
C227 a_2419_63# a_3498_3# 0.01177f
C228 a_8361_407# m2_7791_79# 0.49779f
C229 a_3498_3# a_6721_407# 0
C230 a_5768_63# a_7083_63# 0.01494f
C231 m2_7791_79# a_7083_63# 0.14708f
C232 a_9609_407# a_4158_271# 0
C233 a_2419_63# a_6721_407# 0.01825f
C234 a_9800_n37# a_7083_63# 0.00527f
C235 a_3498_3# m2_9431_79# 0
C236 a_5768_63# m2_1295_79# 0.00766f
C237 a_2419_63# m2_9431_79# 0.00832f
C238 a_5042_407# m2_6151_79# 0.20459f
C239 m2_1295_79# m2_7791_79# 0.05731f
C240 a_10363_63# a_9609_407# 0.01306f
C241 a_8361_407# a_9609_407# 0.00466f
C242 a_3498_3# a_5042_407# 0.02015f
C243 a_5243_407# m2_1295_79# 0.10989f
C244 a_10363_63# a_4158_271# 0.02222f
C245 m2_7791_79# a_8723_63# 0.08396f
C246 a_9609_407# a_7083_63# 0.0285f
C247 a_2419_63# a_5042_407# 0.08051f
C248 a_11922_3# a_4158_271# 0.0013f
C249 a_2419_63# a_11480_63# 0.0769f
C250 a_7083_63# a_4158_271# 1.09133f
C251 a_5042_407# a_6721_407# 0.03265f
C252 m2_1295_79# a_9609_407# 0.0093f
C253 m2_1295_79# a_4158_271# 0.16058f
C254 a_2861_391# a_705_407# 0
C255 a_3498_3# a_3940_63# 0.04602f
C256 a_10363_63# a_7083_63# 0.00582f
C257 a_11480_63# m2_9431_79# 0
C258 a_2419_63# a_3940_63# 0.00879f
C259 a_8361_407# a_7083_63# 0.01453f
C260 a_9609_407# a_8723_63# 0.0593f
C261 a_10363_63# m2_1295_79# 0.00179f
C262 a_8723_63# a_4158_271# 0
C263 m2_1295_79# a_8361_407# 0.02509f
C264 a_2419_63# a_12559_3# 0
C265 a_11922_3# m2_1295_79# 0
C266 a_2861_391# a_3498_3# 0.00454f
C267 m2_1295_79# a_7083_63# 0.01071f
C268 a_10363_63# a_8723_63# 0
C269 a_10906_466# a_9609_407# 0
C270 a_11922_391# a_11922_3# 0.01891f
C271 a_2419_63# a_2861_391# 0.0163f
C272 a_8361_407# a_8723_63# 0.01268f
C273 a_1845_466# m2_1295_79# 0.09644f
C274 a_10906_466# a_4158_271# 0.03873f
C275 a_8723_63# a_7083_63# 0.15796f
C276 m2_5700_324# m2_6151_79# 0.14941f
C277 a_3940_63# a_5042_407# 0.0941f
C278 a_10363_63# a_10906_466# 0.02047f
C279 m2_5700_324# a_3498_3# 0.55174f
C280 m2_1295_79# a_8723_63# 0.00803f
C281 a_10906_466# a_11922_3# 0
C282 m2_5700_324# a_2419_63# 0.074f
C283 a_2861_3# a_5243_407# 0
C284 a_10906_466# a_7083_63# 0
C285 a_510_63# a_1845_n37# 0.0011f
C286 m2_5700_324# a_6721_407# 0.50857f
C287 a_4650_n37# a_4158_271# 0.00383f
C288 a_10906_466# m2_1295_79# 0.0692f
C289 a_4290_63# a_5768_63# 0.01093f
C290 m2_24_342# a_510_63# 0.13025f
C291 a_4290_63# a_5243_407# 0.14023f
C292 m2_5700_324# a_5042_407# 0.06917f
C293 a_7410_63# m2_7791_79# 0.36168f
C294 w_n310_281# a_705_407# 0.79414f
C295 a_1845_466# a_2861_3# 0
C296 a_4290_63# a_4158_271# 0.11363f
C297 m2_5700_324# a_3940_63# 0.00132f
C298 a_2861_3# m2_1295_79# 0.15381f
C299 w_n310_281# m2_6151_79# 0.44301f
C300 w_n310_281# a_3498_3# 1.03377f
C301 a_5042_n37# a_5243_407# 0
C302 a_7410_63# a_4158_271# 0
C303 a_4158_271# via_dev$5$2_9/VSUBS 2.63898f
C304 a_7083_63# via_dev$5$2_9/VSUBS 0.86585f
C305 a_8723_63# via_dev$5$2_9/VSUBS 0.41121f
C306 m2_9431_79# via_dev$5$2_9/VSUBS 0.75255f
C307 m2_7791_79# via_dev$5$2_9/VSUBS 0.74612f
C308 a_9609_407# via_dev$5$2_9/VSUBS 0.11967f
C309 a_8361_407# via_dev$5$2_9/VSUBS 0.05216f
C310 m2_6151_79# via_dev$5$2_9/VSUBS 0.72815f
C311 a_6721_407# via_dev$5$2_9/VSUBS 0.01698f
C312 a_5042_407# via_dev$5$2_9/VSUBS 0.88916f
C313 a_3940_63# via_dev$5$2_9/VSUBS 0.46864f
C314 m2_1295_79# via_dev$5$2_9/VSUBS 3.37184f
C315 a_160_63# via_dev$5$2_9/VSUBS 0.5921f
C316 a_5243_407# via_dev$5$2_9/VSUBS 0.01661f
C317 a_705_407# via_dev$5$2_9/VSUBS 0.13677f
C318 a_3498_3# via_dev$5$2_9/VSUBS 1.27724f
C319 a_10906_n37# via_dev$5$2_9/VSUBS 0.02232f
C320 a_9800_n37# via_dev$5$2_9/VSUBS 0.01742f
C321 a_9408_n37# via_dev$5$2_9/VSUBS 0.007f
C322 a_8160_n37# via_dev$5$2_9/VSUBS 0.01743f
C323 a_7768_n37# via_dev$5$2_9/VSUBS 0.007f
C324 a_6520_n37# via_dev$5$2_9/VSUBS 0.01743f
C325 a_6128_n37# via_dev$5$2_9/VSUBS 0.007f
C326 a_5042_n37# via_dev$5$2_9/VSUBS 0.00833f
C327 a_4650_n37# via_dev$5$2_9/VSUBS 0.01565f
C328 a_12559_3# via_dev$5$2_9/VSUBS 0.19481f
C329 a_11922_3# via_dev$5$2_9/VSUBS 0.64569f
C330 a_11922_391# via_dev$5$2_9/VSUBS 0.00119f
C331 a_10906_466# via_dev$5$2_9/VSUBS 0.59796f
C332 a_11480_63# via_dev$5$2_9/VSUBS 0.42359f
C333 a_10363_63# via_dev$5$2_9/VSUBS 0.13924f
C334 a_9050_63# via_dev$5$2_9/VSUBS 0.53264f
C335 a_8919_367# via_dev$5$2_9/VSUBS 0.51866f
C336 a_7410_63# via_dev$5$2_9/VSUBS 0.53731f
C337 a_5768_63# via_dev$5$2_9/VSUBS 0.54f
C338 a_1845_n37# via_dev$5$2_9/VSUBS 0.01974f
C339 a_1262_n37# via_dev$5$2_9/VSUBS 0.0069f
C340 a_870_n37# via_dev$5$2_9/VSUBS 0.01517f
C341 a_4290_63# via_dev$5$2_9/VSUBS 0.57048f
C342 a_2861_3# via_dev$5$2_9/VSUBS 0.62907f
C343 a_1845_466# via_dev$5$2_9/VSUBS 0.59853f
C344 a_2419_63# via_dev$5$2_9/VSUBS 6.64114f
C345 a_510_63# via_dev$5$2_9/VSUBS 0.55998f
C346 a_378_271# via_dev$5$2_9/VSUBS 1.37769f
C347 w_n310_281# via_dev$5$2_9/VSUBS 27.01716f
C348 m2_24_342# via_dev$5$2_9/VSUBS 1.98211f
C349 m2_5700_324# via_dev$5$2_9/VSUBS 1.14834f
.ends

.subckt AND4 w_237_91# a_992_79# a_372_n441# a_1200_79# a_1686_n317# a_784_79# a_704_n441#
+ a_576_79# a_912_n441# a_518_229# a_1120_n441#
X0 w_237_91# a_992_79# a_518_229# w_237_91# pfet_03v3 ad=0.38p pd=1.76u as=0.38p ps=1.76u w=1u l=0.28u
X1 a_518_229# a_784_79# w_237_91# w_237_91# pfet_03v3 ad=0.38p pd=1.76u as=0.38p ps=1.76u w=1u l=0.28u
X2 a_1686_n317# a_518_229# w_237_91# w_237_91# pfet_03v3 ad=0.65p pd=3.3u as=0.65p ps=3.3u w=1u l=0.28u
X3 a_912_n441# a_784_79# a_704_n441# a_372_n441# nfet_03v3 ad=0.76p pd=2.76u as=0.76p ps=2.76u w=2u l=0.28u
X4 w_237_91# a_576_79# a_518_229# w_237_91# pfet_03v3 ad=0.38p pd=1.76u as=0.65p ps=3.3u w=1u l=0.28u
X5 a_704_n441# a_576_79# a_372_n441# a_372_n441# nfet_03v3 ad=0.76p pd=2.76u as=1.34p ps=5.34u w=2u l=0.28u
X6 a_518_229# a_1200_79# a_1120_n441# a_372_n441# nfet_03v3 ad=1.14p pd=5.14u as=0.76p ps=2.76u w=2u l=0.28u
X7 a_1686_n317# a_518_229# a_372_n441# a_372_n441# nfet_03v3 ad=0.315p pd=2.26u as=0.295p ps=2.18u w=0.5u l=0.28u
X8 a_518_229# a_1200_79# w_237_91# w_237_91# pfet_03v3 ad=0.55p pd=3.1u as=0.38p ps=1.76u w=1u l=0.28u
X9 a_1120_n441# a_992_79# a_912_n441# a_372_n441# nfet_03v3 ad=0.76p pd=2.76u as=0.76p ps=2.76u w=2u l=0.28u
C0 a_1686_n317# a_518_229# 0.12995f
C1 a_1120_n441# a_518_229# 0.02253f
C2 a_1200_79# a_518_229# 0.20239f
C3 a_1200_79# a_1120_n441# 0.00663f
C4 a_912_n441# a_992_79# 0.00663f
C5 a_704_n441# a_518_229# 0.01032f
C6 a_784_79# a_992_79# 0.06396f
C7 w_237_91# a_784_79# 0.14715f
C8 a_784_79# a_576_79# 0.06396f
C9 a_912_n441# a_518_229# 0.01471f
C10 a_784_79# a_518_229# 0.11673f
C11 w_237_91# a_992_79# 0.1469f
C12 w_237_91# a_576_79# 0.16514f
C13 a_704_n441# a_784_79# 0.00663f
C14 w_237_91# a_1686_n317# 0.1612f
C15 a_518_229# a_992_79# 0.12168f
C16 w_237_91# a_518_229# 1.12672f
C17 a_1200_79# a_992_79# 0.06396f
C18 w_237_91# a_1200_79# 0.15686f
C19 a_518_229# a_576_79# 0.11544f
C20 a_1120_n441# a_372_n441# 0.02626f
C21 a_912_n441# a_372_n441# 0.02949f
C22 a_704_n441# a_372_n441# 0.03642f
C23 a_1686_n317# a_372_n441# 0.20646f
C24 a_518_229# a_372_n441# 0.81795f
C25 a_1200_79# a_372_n441# 0.2334f
C26 a_992_79# a_372_n441# 0.22559f
C27 a_784_79# a_372_n441# 0.22803f
C28 a_576_79# a_372_n441# 0.27946f
C29 w_237_91# a_372_n441# 2.88366f
.ends

.subckt x1bitblock$3 a_2861_3# a_8361_407# a_6520_n37# a_1262_n37# a_2861_391# a_1845_466#
+ a_10906_n37# a_510_63# a_870_n37# a_6721_407# a_9800_n37# a_11480_63# a_6128_n37#
+ a_5768_63# m2_6151_79# a_11922_391# a_5042_n37# a_9408_n37# a_9609_407# a_5042_407#
+ a_8160_n37# a_4158_271# a_11922_3# a_8918_358# a_2419_63# m2_9431_79# a_10906_466#
+ a_4650_n37# a_9050_63# a_5243_407# a_7768_n37# a_3940_63# m2_7791_79# a_10363_63#
+ a_160_63# a_4290_63# a_7083_63# a_705_407# a_12559_3# a_7410_63# a_1845_n37# m2_5700_324#
+ via_dev$5$3_9/VSUBS a_3498_3# m2_1295_79# a_8723_63# a_378_271# w_n310_281# m2_24_342#
X0 a_2419_63# a_1845_466# via_dev$5$3_9/VSUBS via_dev$5$3_9/VSUBS nfet_03v3 ad=0.315p pd=2.26u as=0.2425p ps=1.97u w=0.5u l=0.28u
X1 a_1845_466# m2_24_342# a_1845_n37# via_dev$5$3_9/VSUBS nfet_03v3 ad=0.65p pd=3.3u as=0.42p ps=1.84u w=1u l=0.28u
X2 a_3940_63# m2_1295_79# w_n310_281# w_n310_281# pfet_03v3 ad=0.63p pd=3.26u as=0.65p ps=3.3u w=1u l=0.28u
X3 via_dev$5$3_9/VSUBS a_510_63# a_1262_n37# via_dev$5$3_9/VSUBS nfet_03v3 ad=0.65p pd=3.3u as=0.3625p ps=1.725u w=1u l=0.28u
X4 a_5243_407# a_4290_63# a_5042_407# w_n310_281# pfet_03v3 ad=1.3p pd=5.3u as=0.725p ps=2.725u w=2u l=0.28u
X5 a_6721_407# a_2419_63# m2_6151_79# w_n310_281# pfet_03v3 ad=0.675p pd=2.675u as=0.725p ps=2.725u w=2u l=0.28u
X6 a_10906_466# a_4158_271# w_n310_281# w_n310_281# pfet_03v3 ad=0.42p pd=1.84u as=0.65p ps=3.3u w=1u l=0.28u
X7 a_4290_63# a_4158_271# via_dev$5$3_9/VSUBS via_dev$5$3_9/VSUBS nfet_03v3 ad=0.315p pd=2.26u as=0.28p ps=2.12u w=0.5u l=0.28u
X8 w_n310_281# a_378_271# a_705_407# w_n310_281# pfet_03v3 ad=0.725p pd=2.725u as=1.09p ps=5.09u w=2u l=0.28u
X9 a_2861_3# m2_1295_79# via_dev$5$3_9/VSUBS via_dev$5$3_9/VSUBS nfet_03v3 ad=0.18125p pd=1.225u as=0.325p ps=2.3u w=0.5u l=0.28u
X10 via_dev$5$3_9/VSUBS a_2419_63# a_2861_3# via_dev$5$3_9/VSUBS nfet_03v3 ad=0.315p pd=2.26u as=0.18125p ps=1.225u w=0.5u l=0.28u
X11 m2_7791_79# m2_1295_79# a_7768_n37# via_dev$5$3_9/VSUBS nfet_03v3 ad=0.3375p pd=1.675u as=0.3625p ps=1.725u w=1u l=0.28u
X12 a_10906_n37# a_4158_271# via_dev$5$3_9/VSUBS via_dev$5$3_9/VSUBS nfet_03v3 ad=0.42p pd=1.84u as=0.63p ps=3.26u w=1u l=0.28u
X13 a_9050_63# a_8918_358# via_dev$5$3_9/VSUBS via_dev$5$3_9/VSUBS nfet_03v3 ad=0.31p pd=2.24u as=0.24p ps=1.96u w=0.5u l=0.28u
X14 a_11922_3# a_11480_63# via_dev$5$3_9/VSUBS via_dev$5$3_9/VSUBS nfet_03v3 ad=0.18125p pd=1.225u as=0.325p ps=2.3u w=0.5u l=0.28u
X15 via_dev$5$3_9/VSUBS a_2419_63# a_11922_3# via_dev$5$3_9/VSUBS nfet_03v3 ad=0.315p pd=2.26u as=0.18125p ps=1.225u w=0.5u l=0.28u
X16 a_705_407# a_510_63# m2_1295_79# w_n310_281# pfet_03v3 ad=1.3p pd=5.3u as=0.725p ps=2.725u w=2u l=0.28u
X17 a_4650_n37# a_4158_271# via_dev$5$3_9/VSUBS via_dev$5$3_9/VSUBS nfet_03v3 ad=0.3625p pd=1.725u as=0.54p ps=3.08u w=1u l=0.28u
X18 a_2861_3# a_2419_63# a_2861_391# w_n310_281# pfet_03v3 ad=1.3p pd=5.3u as=0.725p ps=2.725u w=2u l=0.28u
X19 a_5768_63# m2_5700_324# via_dev$5$3_9/VSUBS via_dev$5$3_9/VSUBS nfet_03v3 ad=0.315p pd=2.26u as=0.3175p ps=2.27u w=0.5u l=0.28u
X20 via_dev$5$3_9/VSUBS a_9050_63# a_9800_n37# via_dev$5$3_9/VSUBS nfet_03v3 ad=0.65p pd=3.3u as=0.3625p ps=1.725u w=1u l=0.28u
X21 a_8361_407# m2_1295_79# m2_7791_79# w_n310_281# pfet_03v3 ad=0.675p pd=2.675u as=0.725p ps=2.725u w=2u l=0.28u
X22 a_9408_n37# a_8918_358# via_dev$5$3_9/VSUBS via_dev$5$3_9/VSUBS nfet_03v3 ad=0.3625p pd=1.725u as=0.54p ps=3.08u w=1u l=0.28u
X23 a_3498_3# a_2861_3# w_n310_281# w_n310_281# pfet_03v3 ad=0.65p pd=3.3u as=0.675p ps=3.35u w=1u l=0.28u
X24 a_7410_63# m2_5700_324# via_dev$5$3_9/VSUBS via_dev$5$3_9/VSUBS nfet_03v3 ad=0.31p pd=2.24u as=0.24p ps=1.96u w=0.5u l=0.28u
X25 via_dev$5$3_9/VSUBS a_7410_63# a_8160_n37# via_dev$5$3_9/VSUBS nfet_03v3 ad=0.65p pd=3.3u as=0.3625p ps=1.725u w=1u l=0.28u
X26 a_8723_63# m2_7791_79# via_dev$5$3_9/VSUBS via_dev$5$3_9/VSUBS nfet_03v3 ad=0.2625p pd=2.05u as=0.265p ps=2.06u w=0.5u l=0.28u
X27 w_n310_281# a_4158_271# a_5243_407# w_n310_281# pfet_03v3 ad=0.725p pd=2.725u as=1.09p ps=5.09u w=2u l=0.28u
X28 a_5768_63# m2_5700_324# w_n310_281# w_n310_281# pfet_03v3 ad=0.65p pd=3.3u as=0.635p ps=3.27u w=1u l=0.28u
X29 a_9050_63# a_8918_358# w_n310_281# w_n310_281# pfet_03v3 ad=0.64p pd=3.28u as=0.48p ps=2.96u w=1u l=0.28u
X30 a_11922_391# a_11480_63# w_n310_281# w_n310_281# pfet_03v3 ad=0.725p pd=2.725u as=1.3p ps=5.3u w=2u l=0.28u
X31 a_160_63# m2_24_342# via_dev$5$3_9/VSUBS via_dev$5$3_9/VSUBS nfet_03v3 ad=0.315p pd=2.26u as=0.325p ps=2.3u w=0.5u l=0.28u
X32 a_9609_407# a_9050_63# w_n310_281# w_n310_281# pfet_03v3 ad=1.3p pd=5.3u as=0.725p ps=2.725u w=2u l=0.28u
X33 a_6128_n37# m2_5700_324# via_dev$5$3_9/VSUBS via_dev$5$3_9/VSUBS nfet_03v3 ad=0.3625p pd=1.725u as=0.54p ps=3.08u w=1u l=0.28u
X34 via_dev$5$3_9/VSUBS a_5768_63# a_6520_n37# via_dev$5$3_9/VSUBS nfet_03v3 ad=0.65p pd=3.3u as=0.3625p ps=1.725u w=1u l=0.28u
X35 a_7410_63# m2_5700_324# w_n310_281# w_n310_281# pfet_03v3 ad=0.64p pd=3.28u as=0.48p ps=2.96u w=1u l=0.28u
X36 m2_9431_79# a_8918_358# a_9609_407# w_n310_281# pfet_03v3 ad=0.725p pd=2.725u as=1.09p ps=5.09u w=2u l=0.28u
X37 a_11480_63# a_10906_466# via_dev$5$3_9/VSUBS via_dev$5$3_9/VSUBS nfet_03v3 ad=0.315p pd=2.26u as=0.2425p ps=1.97u w=0.5u l=0.28u
X38 a_1845_466# a_378_271# w_n310_281# w_n310_281# pfet_03v3 ad=0.42p pd=1.84u as=0.65p ps=3.3u w=1u l=0.28u
X39 a_8361_407# a_7410_63# w_n310_281# w_n310_281# pfet_03v3 ad=1.3p pd=5.3u as=0.725p ps=2.725u w=2u l=0.28u
X40 w_n310_281# m2_1295_79# a_10906_466# w_n310_281# pfet_03v3 ad=0.735p pd=2.47u as=0.42p ps=1.84u w=1u l=0.28u
X41 a_7083_63# m2_6151_79# via_dev$5$3_9/VSUBS via_dev$5$3_9/VSUBS nfet_03v3 ad=0.2625p pd=2.05u as=0.265p ps=2.06u w=0.5u l=0.28u
X42 a_510_63# a_378_271# w_n310_281# w_n310_281# pfet_03v3 ad=0.65p pd=3.3u as=0.56p ps=3.12u w=1u l=0.28u
X43 a_10363_63# m2_9431_79# w_n310_281# w_n310_281# pfet_03v3 ad=0.715p pd=3.43u as=0.53p ps=3.06u w=1u l=0.28u
X44 a_510_63# a_378_271# via_dev$5$3_9/VSUBS via_dev$5$3_9/VSUBS nfet_03v3 ad=0.315p pd=2.26u as=0.28p ps=2.12u w=0.5u l=0.28u
X45 a_1262_n37# a_160_63# m2_1295_79# via_dev$5$3_9/VSUBS nfet_03v3 ad=0.3625p pd=1.725u as=0.3375p ps=1.675u w=1u l=0.28u
X46 a_1845_n37# a_378_271# via_dev$5$3_9/VSUBS via_dev$5$3_9/VSUBS nfet_03v3 ad=0.42p pd=1.84u as=0.63p ps=3.26u w=1u l=0.28u
X47 m2_6151_79# m2_5700_324# a_6721_407# w_n310_281# pfet_03v3 ad=0.725p pd=2.725u as=1.09p ps=5.09u w=2u l=0.28u
X48 a_6721_407# a_5768_63# w_n310_281# w_n310_281# pfet_03v3 ad=1.3p pd=5.3u as=0.725p ps=2.725u w=2u l=0.28u
X49 a_10363_63# m2_9431_79# via_dev$5$3_9/VSUBS via_dev$5$3_9/VSUBS nfet_03v3 ad=0.3575p pd=2.43u as=0.265p ps=2.06u w=0.5u l=0.28u
X50 a_10906_466# m2_1295_79# a_10906_n37# via_dev$5$3_9/VSUBS nfet_03v3 ad=0.65p pd=3.3u as=0.42p ps=1.84u w=1u l=0.28u
X51 a_8723_63# m2_7791_79# w_n310_281# w_n310_281# pfet_03v3 ad=0.545p pd=3.09u as=0.53p ps=3.06u w=1u l=0.28u
X52 a_11480_63# a_10906_466# w_n310_281# w_n310_281# pfet_03v3 ad=0.65p pd=3.3u as=0.735p ps=2.47u w=1u l=0.28u
X53 a_12559_3# a_11922_3# via_dev$5$3_9/VSUBS via_dev$5$3_9/VSUBS nfet_03v3 ad=0.315p pd=2.26u as=0.325p ps=2.3u w=0.5u l=0.28u
X54 a_7083_63# m2_6151_79# w_n310_281# w_n310_281# pfet_03v3 ad=0.545p pd=3.09u as=0.53p ps=3.06u w=1u l=0.28u
X55 a_7768_n37# m2_5700_324# via_dev$5$3_9/VSUBS via_dev$5$3_9/VSUBS nfet_03v3 ad=0.3625p pd=1.725u as=0.54p ps=3.08u w=1u l=0.28u
X56 a_160_63# m2_24_342# w_n310_281# w_n310_281# pfet_03v3 ad=0.63p pd=3.26u as=0.65p ps=3.3u w=1u l=0.28u
X57 m2_1295_79# a_160_63# a_705_407# w_n310_281# pfet_03v3 ad=0.725p pd=2.725u as=0.675p ps=2.675u w=2u l=0.28u
X58 a_5042_n37# a_3940_63# a_5042_407# via_dev$5$3_9/VSUBS nfet_03v3 ad=0.3625p pd=1.725u as=0.3375p ps=1.675u w=1u l=0.28u
X59 m2_1295_79# m2_24_342# a_870_n37# via_dev$5$3_9/VSUBS nfet_03v3 ad=0.3375p pd=1.675u as=0.3625p ps=1.725u w=1u l=0.28u
X60 a_11922_3# a_2419_63# a_11922_391# w_n310_281# pfet_03v3 ad=1.3p pd=5.3u as=0.725p ps=2.725u w=2u l=0.28u
X61 a_9800_n37# a_7083_63# m2_9431_79# via_dev$5$3_9/VSUBS nfet_03v3 ad=0.3625p pd=1.725u as=0.3375p ps=1.675u w=1u l=0.28u
X62 m2_7791_79# m2_5700_324# a_8361_407# w_n310_281# pfet_03v3 ad=0.725p pd=2.725u as=1.09p ps=5.09u w=2u l=0.28u
X63 a_5042_407# a_3940_63# a_5243_407# w_n310_281# pfet_03v3 ad=0.725p pd=2.725u as=0.675p ps=2.675u w=2u l=0.28u
X64 a_3940_63# m2_1295_79# via_dev$5$3_9/VSUBS via_dev$5$3_9/VSUBS nfet_03v3 ad=0.315p pd=2.26u as=0.325p ps=2.3u w=0.5u l=0.28u
X65 a_8160_n37# a_3498_3# m2_7791_79# via_dev$5$3_9/VSUBS nfet_03v3 ad=0.3625p pd=1.725u as=0.3375p ps=1.675u w=1u l=0.28u
X66 a_705_407# m2_24_342# w_n310_281# w_n310_281# pfet_03v3 ad=0.675p pd=2.675u as=0.725p ps=2.725u w=2u l=0.28u
X67 a_5042_407# m2_1295_79# a_4650_n37# via_dev$5$3_9/VSUBS nfet_03v3 ad=0.3375p pd=1.675u as=0.3625p ps=1.725u w=1u l=0.28u
X68 a_6520_n37# a_5042_407# m2_6151_79# via_dev$5$3_9/VSUBS nfet_03v3 ad=0.3625p pd=1.725u as=0.3375p ps=1.675u w=1u l=0.28u
X69 w_n310_281# a_7083_63# a_9609_407# w_n310_281# pfet_03v3 ad=0.725p pd=2.725u as=0.675p ps=2.675u w=2u l=0.28u
X70 a_2419_63# a_1845_466# w_n310_281# w_n310_281# pfet_03v3 ad=0.65p pd=3.3u as=0.735p ps=2.47u w=1u l=0.28u
X71 m2_9431_79# a_8723_63# a_9408_n37# via_dev$5$3_9/VSUBS nfet_03v3 ad=0.3375p pd=1.675u as=0.3625p ps=1.725u w=1u l=0.28u
X72 w_n310_281# a_3498_3# a_8361_407# w_n310_281# pfet_03v3 ad=0.725p pd=2.725u as=0.675p ps=2.675u w=2u l=0.28u
X73 a_2861_391# m2_1295_79# w_n310_281# w_n310_281# pfet_03v3 ad=0.725p pd=2.725u as=1.3p ps=5.3u w=2u l=0.28u
X74 a_4290_63# a_4158_271# w_n310_281# w_n310_281# pfet_03v3 ad=0.65p pd=3.3u as=0.56p ps=3.12u w=1u l=0.28u
X75 a_5243_407# m2_1295_79# w_n310_281# w_n310_281# pfet_03v3 ad=0.675p pd=2.675u as=0.725p ps=2.725u w=2u l=0.28u
X76 w_n310_281# a_5042_407# a_6721_407# w_n310_281# pfet_03v3 ad=0.725p pd=2.725u as=0.675p ps=2.675u w=2u l=0.28u
X77 a_3498_3# a_2861_3# via_dev$5$3_9/VSUBS via_dev$5$3_9/VSUBS nfet_03v3 ad=0.315p pd=2.26u as=0.325p ps=2.3u w=0.5u l=0.28u
X78 a_9609_407# a_8723_63# m2_9431_79# w_n310_281# pfet_03v3 ad=0.675p pd=2.675u as=0.725p ps=2.725u w=2u l=0.28u
X79 via_dev$5$3_9/VSUBS a_4290_63# a_5042_n37# via_dev$5$3_9/VSUBS nfet_03v3 ad=0.65p pd=3.3u as=0.3625p ps=1.725u w=1u l=0.28u
X80 m2_6151_79# a_2419_63# a_6128_n37# via_dev$5$3_9/VSUBS nfet_03v3 ad=0.3375p pd=1.675u as=0.3625p ps=1.725u w=1u l=0.28u
X81 w_n310_281# m2_24_342# a_1845_466# w_n310_281# pfet_03v3 ad=0.735p pd=2.47u as=0.42p ps=1.84u w=1u l=0.28u
X82 a_870_n37# a_378_271# via_dev$5$3_9/VSUBS via_dev$5$3_9/VSUBS nfet_03v3 ad=0.3625p pd=1.725u as=0.54p ps=3.08u w=1u l=0.28u
X83 a_12559_3# a_11922_3# w_n310_281# w_n310_281# pfet_03v3 ad=0.65p pd=3.3u as=0.675p ps=3.35u w=1u l=0.28u
C0 a_2419_63# a_9609_407# 0
C1 a_1845_466# a_160_63# 0
C2 a_378_271# a_160_63# 0.09182f
C3 a_2419_63# a_4158_271# 0.14782f
C4 a_2861_3# a_705_407# 0
C5 a_2419_63# a_10363_63# 0.00126f
C6 a_2419_63# a_8361_407# 0
C7 a_2419_63# a_11922_3# 0.16984f
C8 a_2861_391# m2_1295_79# 0.00841f
C9 a_2419_63# a_7083_63# 0.01345f
C10 a_2861_3# a_3498_3# 0.09846f
C11 a_9050_63# m2_9431_79# 0.328f
C12 a_2419_63# m2_1295_79# 0.3246f
C13 a_2419_63# a_11922_391# 0.00754f
C14 a_2419_63# a_8723_63# 0.00649f
C15 a_1845_466# a_3940_63# 0
C16 m2_5700_324# m2_7791_79# 0.05245f
C17 a_6520_n37# a_4158_271# 0.00406f
C18 a_2419_63# a_10906_466# 0.00833f
C19 m2_5700_324# a_5243_407# 0.01927f
C20 a_2861_3# a_5042_407# 0
C21 a_6520_n37# a_7083_63# 0.00272f
C22 a_4290_63# a_5243_407# 0.14023f
C23 m2_5700_324# a_4158_271# 0.00861f
C24 a_2861_3# a_3940_63# 0
C25 a_8918_358# w_n310_281# 0.49498f
C26 m2_5700_324# a_8361_407# 0.05956f
C27 a_4290_63# a_4158_271# 0.11363f
C28 a_7768_n37# m2_9431_79# 0
C29 m2_5700_324# a_7083_63# 0.12051f
C30 m2_5700_324# m2_1295_79# 0.07849f
C31 a_510_63# a_705_407# 0.13828f
C32 a_1845_466# w_n310_281# 0.44517f
C33 a_7410_63# a_8918_358# 0
C34 a_378_271# w_n310_281# 0.63374f
C35 m2_5700_324# a_8723_63# 0
C36 a_4290_63# m2_1295_79# 0.13519f
C37 a_9050_63# w_n310_281# 0.28931f
C38 a_510_63# a_160_63# 0.28903f
C39 a_2861_3# w_n310_281# 0.4655f
C40 m2_24_342# a_1845_466# 0.06999f
C41 m2_24_342# a_378_271# 0.56715f
C42 a_9408_n37# m2_7791_79# 0
C43 a_8160_n37# m2_9431_79# 0
C44 a_8918_358# a_2419_63# 0.01449f
C45 a_4290_63# a_4650_n37# 0.01502f
C46 a_9408_n37# a_9609_407# 0
C47 a_1845_466# a_2419_63# 0.10509f
C48 a_9408_n37# a_7083_63# 0.00336f
C49 a_9050_63# a_2419_63# 0.00801f
C50 a_2861_3# a_2861_391# 0.01616f
C51 a_7410_63# a_7768_n37# 0.00935f
C52 a_2861_3# a_2419_63# 0.21478f
C53 a_705_407# a_160_63# 0.06737f
C54 a_4290_63# a_5042_n37# 0.00898f
C55 a_8918_358# m2_5700_324# 0
C56 a_9609_407# m2_7791_79# 0
C57 a_510_63# w_n310_281# 0.28255f
C58 a_3498_3# m2_6151_79# 0
C59 m2_7791_79# a_4158_271# 0
C60 a_9800_n37# a_4158_271# 0.00497f
C61 a_5243_407# a_4158_271# 0.02964f
C62 a_6721_407# m2_6151_79# 0.4935f
C63 a_8361_407# m2_7791_79# 0.49779f
C64 a_3498_3# a_6721_407# 0
C65 m2_7791_79# a_7083_63# 0.14708f
C66 a_9609_407# a_4158_271# 0
C67 a_9800_n37# a_7083_63# 0.00527f
C68 a_3498_3# m2_9431_79# 0
C69 a_5042_407# m2_6151_79# 0.20459f
C70 m2_1295_79# m2_7791_79# 0.05731f
C71 a_10363_63# a_9609_407# 0.01306f
C72 a_8361_407# a_9609_407# 0.00466f
C73 a_3498_3# a_5042_407# 0.02015f
C74 a_5243_407# m2_1295_79# 0.10989f
C75 a_10363_63# a_4158_271# 0.02222f
C76 a_7410_63# a_8160_n37# 0.01329f
C77 m2_24_342# a_510_63# 0.13025f
C78 m2_7791_79# a_8723_63# 0.08381f
C79 a_9609_407# a_7083_63# 0.0285f
C80 a_11922_3# a_4158_271# 0.0013f
C81 a_5768_63# m2_6151_79# 0.35511f
C82 a_7083_63# a_4158_271# 1.09133f
C83 a_5042_407# a_6721_407# 0.03265f
C84 m2_1295_79# a_9609_407# 0.0093f
C85 a_5768_63# a_3498_3# 0
C86 m2_1295_79# a_4158_271# 0.16058f
C87 a_3498_3# a_3940_63# 0.04602f
C88 a_10363_63# a_7083_63# 0.00582f
C89 a_11480_63# m2_9431_79# 0
C90 a_8361_407# a_7083_63# 0.01453f
C91 a_9609_407# a_8723_63# 0.0593f
C92 a_5768_63# a_6721_407# 0.14017f
C93 a_10363_63# m2_1295_79# 0.00179f
C94 a_8723_63# a_4158_271# 0
C95 m2_1295_79# a_8361_407# 0.02509f
C96 a_1845_n37# m2_1295_79# 0.00942f
C97 a_11922_3# m2_1295_79# 0
C98 a_2861_3# a_4290_63# 0
C99 m2_1295_79# a_7083_63# 0.01071f
C100 a_10363_63# a_8723_63# 0
C101 a_10906_466# a_9609_407# 0
C102 a_11922_391# a_11922_3# 0.01891f
C103 a_8361_407# a_8723_63# 0.01268f
C104 a_10906_466# a_4158_271# 0.03873f
C105 a_5768_63# a_5042_407# 0.22596f
C106 a_8723_63# a_7083_63# 0.15796f
C107 a_3940_63# a_5042_407# 0.0941f
C108 a_10363_63# a_10906_466# 0.02047f
C109 a_870_n37# m2_1295_79# 0.00639f
C110 m2_1295_79# a_8723_63# 0.00796f
C111 a_10906_466# a_11922_3# 0
C112 w_n310_281# a_705_407# 0.79414f
C113 a_5768_63# a_3940_63# 0
C114 a_10906_466# a_7083_63# 0
C115 a_4650_n37# a_4158_271# 0.00383f
C116 a_10906_466# m2_1295_79# 0.0692f
C117 w_n310_281# m2_6151_79# 0.44301f
C118 w_n310_281# a_3498_3# 1.03377f
C119 w_n310_281# a_160_63# 0.30515f
C120 w_n310_281# a_6721_407# 0.72579f
C121 w_n310_281# m2_9431_79# 0.46253f
C122 w_n310_281# a_10906_n37# 0
C123 a_7410_63# m2_6151_79# 0
C124 m2_24_342# a_705_407# 0.10607f
C125 a_9050_63# a_9408_n37# 0.00935f
C126 a_7410_63# a_3498_3# 0.11774f
C127 w_n310_281# a_5042_407# 0.29911f
C128 w_n310_281# a_11480_63# 0.37298f
C129 a_5042_n37# a_5243_407# 0
C130 m2_24_342# a_3498_3# 0
C131 a_8918_358# m2_7791_79# 0.02764f
C132 a_7410_63# m2_9431_79# 0.00105f
C133 a_5768_63# w_n310_281# 0.31314f
C134 m2_24_342# a_160_63# 0.42316f
C135 w_n310_281# a_3940_63# 0.30087f
C136 a_5042_n37# a_4158_271# 0
C137 a_2861_391# a_705_407# 0
C138 w_n310_281# a_12559_3# 0.08598f
C139 a_7410_63# a_5042_407# 0
C140 a_6128_n37# m2_6151_79# 0.01733f
C141 a_8918_358# a_9609_407# 0.02942f
C142 a_2419_63# a_705_407# 0
C143 a_8918_358# a_4158_271# 0.00101f
C144 a_2861_391# a_3498_3# 0.00454f
C145 a_2419_63# m2_6151_79# 0.05852f
C146 a_8918_358# a_10363_63# 0
C147 a_6128_n37# a_6721_407# 0
C148 a_8918_358# a_8361_407# 0
C149 a_2419_63# a_3498_3# 0.01177f
C150 a_9050_63# m2_7791_79# 0.00127f
C151 a_8918_358# a_7083_63# 0.01057f
C152 a_9050_63# a_9800_n37# 0.01329f
C153 a_1262_n37# m2_1295_79# 0.01607f
C154 a_2419_63# a_6721_407# 0.01825f
C155 a_8918_358# m2_1295_79# 0.01371f
C156 a_2419_63# m2_9431_79# 0.00832f
C157 a_6128_n37# a_5042_407# 0.00376f
C158 a_8918_358# a_8723_63# 0.12497f
C159 a_9050_63# a_9609_407# 0.1261f
C160 a_1845_466# a_1845_n37# 0.01333f
C161 a_2861_3# a_5243_407# 0
C162 a_9050_63# a_4158_271# 0.00717f
C163 a_2419_63# a_5042_407# 0.08051f
C164 a_2419_63# a_11480_63# 0.0769f
C165 a_5768_63# a_6128_n37# 0.00935f
C166 a_1845_466# m2_1295_79# 0.09644f
C167 a_378_271# m2_1295_79# 0.02669f
C168 a_9050_63# a_10363_63# 0.01385f
C169 a_6520_n37# m2_6151_79# 0.00766f
C170 a_9050_63# a_8361_407# 0
C171 a_5768_63# a_2419_63# 0.07749f
C172 a_9050_63# a_7083_63# 0.21474f
C173 a_2419_63# a_3940_63# 0.00879f
C174 a_1845_466# a_870_n37# 0
C175 a_7410_63# w_n310_281# 0.31086f
C176 a_9050_63# m2_1295_79# 0.00716f
C177 a_2419_63# a_12559_3# 0
C178 m2_5700_324# m2_6151_79# 0.14941f
C179 a_7768_n37# m2_7791_79# 0.01733f
C180 a_9050_63# a_8723_63# 0.52788f
C181 m2_24_342# w_n310_281# 0.66878f
C182 m2_5700_324# a_3498_3# 0.55174f
C183 a_2861_3# m2_1295_79# 0.15381f
C184 a_4290_63# m2_6151_79# 0
C185 a_6520_n37# a_5042_407# 0.00483f
C186 m2_5700_324# a_6721_407# 0.50857f
C187 a_4290_63# a_3498_3# 0.00876f
C188 a_5768_63# a_6520_n37# 0.01329f
C189 a_2861_391# w_n310_281# 0.03535f
C190 m2_5700_324# a_5042_407# 0.06917f
C191 a_7768_n37# a_8361_407# 0
C192 a_7768_n37# a_7083_63# 0.0028f
C193 a_2419_63# w_n310_281# 0.75125f
C194 a_5768_63# m2_5700_324# 0.16447f
C195 a_4290_63# a_5042_407# 0.38112f
C196 m2_5700_324# a_3940_63# 0.00132f
C197 a_8160_n37# m2_7791_79# 0.01048f
C198 a_5768_63# a_4290_63# 0.01093f
C199 a_4290_63# a_3940_63# 0.28903f
C200 a_7410_63# a_2419_63# 0.00801f
C201 m2_24_342# a_2419_63# 0.00234f
C202 a_510_63# a_1845_n37# 0.0011f
C203 a_1262_n37# a_1845_466# 0
C204 a_510_63# m2_1295_79# 0.39896f
C205 a_8160_n37# a_7083_63# 0.00507f
C206 a_510_63# a_870_n37# 0.01502f
C207 w_n310_281# m2_5700_324# 1.65678f
C208 a_2861_391# a_2419_63# 0.0163f
C209 a_8918_358# a_9050_63# 0.09973f
C210 a_9408_n37# m2_9431_79# 0.01733f
C211 a_4290_63# w_n310_281# 0.2819f
C212 a_378_271# a_1845_466# 0.01278f
C213 a_7410_63# m2_5700_324# 0.14432f
C214 m2_6151_79# m2_7791_79# 0.00114f
C215 a_2861_3# a_1845_466# 0
C216 a_3498_3# m2_7791_79# 0.0296f
C217 a_3498_3# a_5243_407# 0.16427f
C218 m2_6151_79# a_4158_271# 0.04334f
C219 m2_7791_79# m2_9431_79# 0.01571f
C220 a_9800_n37# m2_9431_79# 0.0074f
C221 a_3498_3# a_4158_271# 0.00829f
C222 a_2419_63# m2_5700_324# 0.074f
C223 a_5042_407# m2_7791_79# 0.00555f
C224 a_705_407# m2_1295_79# 0.30816f
C225 m2_6151_79# a_7083_63# 0.08089f
C226 a_9609_407# m2_9431_79# 0.49779f
C227 a_5243_407# a_5042_407# 0.29512f
C228 a_3498_3# a_8361_407# 0.12093f
C229 m2_9431_79# a_4158_271# 0.05572f
C230 a_10906_n37# a_4158_271# 0.00824f
C231 m2_1295_79# m2_6151_79# 0.00667f
C232 a_3498_3# a_7083_63# 0.01356f
C233 a_5768_63# m2_7791_79# 0
C234 a_2419_63# a_4290_63# 0.00652f
C235 a_3498_3# m2_1295_79# 0.3391f
C236 a_10363_63# m2_9431_79# 0.07766f
C237 a_11480_63# a_9609_407# 0
C238 a_5768_63# a_5243_407# 0.00722f
C239 a_10363_63# a_10906_n37# 0
C240 a_5042_407# a_4158_271# 0.63867f
C241 a_8361_407# m2_9431_79# 0
C242 a_6721_407# a_7083_63# 0.01268f
C243 a_160_63# m2_1295_79# 0.09339f
C244 a_5243_407# a_3940_63# 0.06737f
C245 a_11480_63# a_4158_271# 0.00295f
C246 a_510_63# a_1262_n37# 0.00898f
C247 m2_9431_79# a_7083_63# 0.19293f
C248 a_3498_3# a_8723_63# 0.00575f
C249 m2_1295_79# a_6721_407# 0.00452f
C250 a_10363_63# a_11480_63# 0
C251 a_870_n37# a_160_63# 0.00441f
C252 m2_1295_79# m2_9431_79# 0.0078f
C253 a_5768_63# a_4158_271# 0.00573f
C254 a_11480_63# a_11922_3# 0.04054f
C255 a_3940_63# a_4158_271# 0.16366f
C256 a_5042_407# a_7083_63# 0.02611f
C257 m2_9431_79# a_8723_63# 0.13485f
C258 m2_1295_79# a_5042_407# 0.03487f
C259 a_11480_63# m2_1295_79# 0.00126f
C260 a_5768_63# a_7083_63# 0.01494f
C261 a_510_63# a_1845_466# 0.01433f
C262 a_11480_63# a_11922_391# 0.00152f
C263 a_510_63# a_378_271# 0.14298f
C264 a_10906_466# m2_9431_79# 0.00167f
C265 a_5768_63# m2_1295_79# 0.00766f
C266 a_10906_466# a_10906_n37# 0.01333f
C267 a_11922_3# a_12559_3# 0.0899f
C268 m2_1295_79# a_3940_63# 0.46061f
C269 a_11480_63# a_10906_466# 0.1131f
C270 w_n310_281# m2_7791_79# 0.45142f
C271 a_4290_63# m2_5700_324# 0.01531f
C272 w_n310_281# a_5243_407# 0.78984f
C273 w_n310_281# a_9609_407# 0.7653f
C274 a_4650_n37# a_5042_407# 0.00712f
C275 a_10906_466# a_12559_3# 0
C276 w_n310_281# a_4158_271# 0.66883f
C277 a_7410_63# m2_7791_79# 0.36168f
C278 w_n310_281# a_10363_63# 0.15741f
C279 w_n310_281# a_8361_407# 0.75753f
C280 a_1845_n37# w_n310_281# 0
C281 w_n310_281# a_11922_3# 0.46598f
C282 a_4650_n37# a_3940_63# 0.00441f
C283 w_n310_281# a_7083_63# 0.31663f
C284 a_5042_n37# m2_6151_79# 0
C285 a_1262_n37# a_705_407# 0
C286 w_n310_281# m2_1295_79# 2.35222f
C287 a_7410_63# a_4158_271# 0
C288 w_n310_281# a_11922_391# 0.03535f
C289 w_n310_281# a_8723_63# 0.33519f
C290 a_7410_63# a_8361_407# 0.1423f
C291 a_7410_63# a_7083_63# 0.07718f
C292 w_n310_281# a_10906_466# 0.44509f
C293 a_7410_63# m2_1295_79# 0.07614f
C294 a_1845_466# a_705_407# 0.0126f
C295 a_378_271# a_705_407# 0.02817f
C296 a_2419_63# m2_7791_79# 0.00843f
C297 a_5042_n37# a_5042_407# 0.01726f
C298 a_2419_63# a_5243_407# 0
C299 a_7410_63# a_8723_63# 0.01398f
C300 a_8918_358# m2_9431_79# 0.03217f
C301 m2_24_342# m2_1295_79# 0.04399f
C302 a_1845_466# a_3498_3# 0.00105f
C303 a_4158_271# via_dev$5$3_9/VSUBS 2.63856f
C304 a_7083_63# via_dev$5$3_9/VSUBS 0.86585f
C305 a_8723_63# via_dev$5$3_9/VSUBS 0.40977f
C306 m2_9431_79# via_dev$5$3_9/VSUBS 0.75255f
C307 m2_7791_79# via_dev$5$3_9/VSUBS 0.74612f
C308 a_9609_407# via_dev$5$3_9/VSUBS 0.11967f
C309 a_8361_407# via_dev$5$3_9/VSUBS 0.05216f
C310 m2_6151_79# via_dev$5$3_9/VSUBS 0.72815f
C311 a_6721_407# via_dev$5$3_9/VSUBS 0.01698f
C312 a_5042_407# via_dev$5$3_9/VSUBS 0.88916f
C313 a_3940_63# via_dev$5$3_9/VSUBS 0.46864f
C314 m2_1295_79# via_dev$5$3_9/VSUBS 3.34703f
C315 a_160_63# via_dev$5$3_9/VSUBS 0.5921f
C316 a_5243_407# via_dev$5$3_9/VSUBS 0.01661f
C317 a_705_407# via_dev$5$3_9/VSUBS 0.13677f
C318 a_3498_3# via_dev$5$3_9/VSUBS 1.27724f
C319 a_10906_n37# via_dev$5$3_9/VSUBS 0.02232f
C320 a_9800_n37# via_dev$5$3_9/VSUBS 0.01742f
C321 a_9408_n37# via_dev$5$3_9/VSUBS 0.007f
C322 a_8160_n37# via_dev$5$3_9/VSUBS 0.01743f
C323 a_7768_n37# via_dev$5$3_9/VSUBS 0.007f
C324 a_6520_n37# via_dev$5$3_9/VSUBS 0.01743f
C325 a_6128_n37# via_dev$5$3_9/VSUBS 0.007f
C326 a_5042_n37# via_dev$5$3_9/VSUBS 0.00833f
C327 a_4650_n37# via_dev$5$3_9/VSUBS 0.01565f
C328 a_12559_3# via_dev$5$3_9/VSUBS 0.19481f
C329 a_11922_3# via_dev$5$3_9/VSUBS 0.64569f
C330 a_11922_391# via_dev$5$3_9/VSUBS 0.00119f
C331 a_10906_466# via_dev$5$3_9/VSUBS 0.59796f
C332 a_11480_63# via_dev$5$3_9/VSUBS 0.42359f
C333 a_10363_63# via_dev$5$3_9/VSUBS 0.13924f
C334 a_9050_63# via_dev$5$3_9/VSUBS 0.53264f
C335 a_8918_358# via_dev$5$3_9/VSUBS 0.5203f
C336 a_7410_63# via_dev$5$3_9/VSUBS 0.53731f
C337 a_5768_63# via_dev$5$3_9/VSUBS 0.54f
C338 a_1845_n37# via_dev$5$3_9/VSUBS 0.01974f
C339 a_1262_n37# via_dev$5$3_9/VSUBS 0.0069f
C340 a_870_n37# via_dev$5$3_9/VSUBS 0.01517f
C341 a_4290_63# via_dev$5$3_9/VSUBS 0.57048f
C342 a_2861_3# via_dev$5$3_9/VSUBS 0.62907f
C343 a_1845_466# via_dev$5$3_9/VSUBS 0.59853f
C344 a_2419_63# via_dev$5$3_9/VSUBS 6.64114f
C345 a_510_63# via_dev$5$3_9/VSUBS 0.55998f
C346 a_378_271# via_dev$5$3_9/VSUBS 1.37769f
C347 w_n310_281# via_dev$5$3_9/VSUBS 27.06676f
C348 m2_5700_324# via_dev$5$3_9/VSUBS 1.14834f
C349 m2_24_342# via_dev$5$3_9/VSUBS 1.98211f
.ends

.subckt x1bitblock a_2861_3# a_8361_407# a_6520_n37# a_1262_n37# a_2861_391# a_1845_466#
+ a_10906_n37# a_510_63# a_870_n37# a_9800_n37# a_11480_63# a_6128_n37# a_5768_63#
+ m2_6151_79# a_11922_391# a_5042_n37# a_9408_n37# a_8918_357# a_9609_407# a_5042_407#
+ a_8160_n37# a_4158_271# a_11922_3# a_2419_63# m2_9431_79# a_10906_466# a_4650_n37#
+ a_9050_63# a_7768_n37# a_3940_63# m2_7791_79# a_10363_63# a_160_63# a_4290_63# a_7083_63#
+ a_705_407# a_12559_3# a_7410_63# a_1845_n37# via_dev$5_9/VSUBS m2_1295_79# a_8723_63#
+ a_378_271# a_3498_3# m2_5700_324# w_n310_281# m2_24_342#
X0 a_2419_63# a_1845_466# via_dev$5_9/VSUBS via_dev$5_9/VSUBS nfet_03v3 ad=0.315p pd=2.26u as=0.2425p ps=1.97u w=0.5u l=0.28u
X1 a_1845_466# m2_24_342# a_1845_n37# via_dev$5_9/VSUBS nfet_03v3 ad=0.65p pd=3.3u as=0.42p ps=1.84u w=1u l=0.28u
X2 a_3940_63# m2_1295_79# w_n310_281# w_n310_281# pfet_03v3 ad=0.63p pd=3.26u as=0.65p ps=3.3u w=1u l=0.28u
X3 via_dev$5_9/VSUBS a_510_63# a_1262_n37# via_dev$5_9/VSUBS nfet_03v3 ad=0.65p pd=3.3u as=0.3625p ps=1.725u w=1u l=0.28u
X4 a_5243_407# a_4290_63# a_5042_407# w_n310_281# pfet_03v3 ad=1.3p pd=5.3u as=0.725p ps=2.725u w=2u l=0.28u
X5 a_6721_407# a_2419_63# m2_6151_79# w_n310_281# pfet_03v3 ad=0.675p pd=2.675u as=0.725p ps=2.725u w=2u l=0.28u
X6 a_10906_466# a_4158_271# w_n310_281# w_n310_281# pfet_03v3 ad=0.42p pd=1.84u as=0.65p ps=3.3u w=1u l=0.28u
X7 a_4290_63# a_4158_271# via_dev$5_9/VSUBS via_dev$5_9/VSUBS nfet_03v3 ad=0.315p pd=2.26u as=0.28p ps=2.12u w=0.5u l=0.28u
X8 w_n310_281# a_378_271# a_705_407# w_n310_281# pfet_03v3 ad=0.725p pd=2.725u as=1.09p ps=5.09u w=2u l=0.28u
X9 a_2861_3# m2_1295_79# via_dev$5_9/VSUBS via_dev$5_9/VSUBS nfet_03v3 ad=0.18125p pd=1.225u as=0.325p ps=2.3u w=0.5u l=0.28u
X10 via_dev$5_9/VSUBS a_2419_63# a_2861_3# via_dev$5_9/VSUBS nfet_03v3 ad=0.315p pd=2.26u as=0.18125p ps=1.225u w=0.5u l=0.28u
X11 m2_7791_79# m2_1295_79# a_7768_n37# via_dev$5_9/VSUBS nfet_03v3 ad=0.3375p pd=1.675u as=0.3625p ps=1.725u w=1u l=0.28u
X12 a_10906_n37# a_4158_271# via_dev$5_9/VSUBS via_dev$5_9/VSUBS nfet_03v3 ad=0.42p pd=1.84u as=0.63p ps=3.26u w=1u l=0.28u
X13 a_9050_63# a_8918_357# via_dev$5_9/VSUBS via_dev$5_9/VSUBS nfet_03v3 ad=0.31p pd=2.24u as=0.24p ps=1.96u w=0.5u l=0.28u
X14 a_11922_3# a_11480_63# via_dev$5_9/VSUBS via_dev$5_9/VSUBS nfet_03v3 ad=0.18125p pd=1.225u as=0.325p ps=2.3u w=0.5u l=0.28u
X15 via_dev$5_9/VSUBS a_2419_63# a_11922_3# via_dev$5_9/VSUBS nfet_03v3 ad=0.315p pd=2.26u as=0.18125p ps=1.225u w=0.5u l=0.28u
X16 a_705_407# a_510_63# m2_1295_79# w_n310_281# pfet_03v3 ad=1.3p pd=5.3u as=0.725p ps=2.725u w=2u l=0.28u
X17 a_4650_n37# a_4158_271# via_dev$5_9/VSUBS via_dev$5_9/VSUBS nfet_03v3 ad=0.3625p pd=1.725u as=0.54p ps=3.08u w=1u l=0.28u
X18 a_2861_3# a_2419_63# a_2861_391# w_n310_281# pfet_03v3 ad=1.3p pd=5.3u as=0.725p ps=2.725u w=2u l=0.28u
X19 a_5768_63# m2_5700_324# via_dev$5_9/VSUBS via_dev$5_9/VSUBS nfet_03v3 ad=0.315p pd=2.26u as=0.3175p ps=2.27u w=0.5u l=0.28u
X20 via_dev$5_9/VSUBS a_9050_63# a_9800_n37# via_dev$5_9/VSUBS nfet_03v3 ad=0.65p pd=3.3u as=0.3625p ps=1.725u w=1u l=0.28u
X21 a_8361_407# m2_1295_79# m2_7791_79# w_n310_281# pfet_03v3 ad=0.675p pd=2.675u as=0.725p ps=2.725u w=2u l=0.28u
X22 a_9408_n37# a_8918_357# via_dev$5_9/VSUBS via_dev$5_9/VSUBS nfet_03v3 ad=0.3625p pd=1.725u as=0.54p ps=3.08u w=1u l=0.28u
X23 a_3498_3# a_2861_3# w_n310_281# w_n310_281# pfet_03v3 ad=0.65p pd=3.3u as=0.675p ps=3.35u w=1u l=0.28u
X24 a_7410_63# m2_5700_324# via_dev$5_9/VSUBS via_dev$5_9/VSUBS nfet_03v3 ad=0.31p pd=2.24u as=0.24p ps=1.96u w=0.5u l=0.28u
X25 via_dev$5_9/VSUBS a_7410_63# a_8160_n37# via_dev$5_9/VSUBS nfet_03v3 ad=0.65p pd=3.3u as=0.3625p ps=1.725u w=1u l=0.28u
X26 a_8723_63# m2_7791_79# via_dev$5_9/VSUBS via_dev$5_9/VSUBS nfet_03v3 ad=0.2625p pd=2.05u as=0.265p ps=2.06u w=0.5u l=0.28u
X27 w_n310_281# a_4158_271# a_5243_407# w_n310_281# pfet_03v3 ad=0.725p pd=2.725u as=1.09p ps=5.09u w=2u l=0.28u
X28 a_5768_63# m2_5700_324# w_n310_281# w_n310_281# pfet_03v3 ad=0.65p pd=3.3u as=0.635p ps=3.27u w=1u l=0.28u
X29 a_9050_63# a_8918_357# w_n310_281# w_n310_281# pfet_03v3 ad=0.64p pd=3.28u as=0.48p ps=2.96u w=1u l=0.28u
X30 a_11922_391# a_11480_63# w_n310_281# w_n310_281# pfet_03v3 ad=0.725p pd=2.725u as=1.3p ps=5.3u w=2u l=0.28u
X31 a_160_63# m2_24_342# via_dev$5_9/VSUBS via_dev$5_9/VSUBS nfet_03v3 ad=0.315p pd=2.26u as=0.325p ps=2.3u w=0.5u l=0.28u
X32 a_9609_407# a_9050_63# w_n310_281# w_n310_281# pfet_03v3 ad=1.3p pd=5.3u as=0.725p ps=2.725u w=2u l=0.28u
X33 a_6128_n37# m2_5700_324# via_dev$5_9/VSUBS via_dev$5_9/VSUBS nfet_03v3 ad=0.3625p pd=1.725u as=0.54p ps=3.08u w=1u l=0.28u
X34 via_dev$5_9/VSUBS a_5768_63# a_6520_n37# via_dev$5_9/VSUBS nfet_03v3 ad=0.65p pd=3.3u as=0.3625p ps=1.725u w=1u l=0.28u
X35 a_7410_63# m2_5700_324# w_n310_281# w_n310_281# pfet_03v3 ad=0.64p pd=3.28u as=0.48p ps=2.96u w=1u l=0.28u
X36 m2_9431_79# a_8918_357# a_9609_407# w_n310_281# pfet_03v3 ad=0.725p pd=2.725u as=1.09p ps=5.09u w=2u l=0.28u
X37 a_11480_63# a_10906_466# via_dev$5_9/VSUBS via_dev$5_9/VSUBS nfet_03v3 ad=0.315p pd=2.26u as=0.2425p ps=1.97u w=0.5u l=0.28u
X38 a_1845_466# a_378_271# w_n310_281# w_n310_281# pfet_03v3 ad=0.42p pd=1.84u as=0.65p ps=3.3u w=1u l=0.28u
X39 a_8361_407# a_7410_63# w_n310_281# w_n310_281# pfet_03v3 ad=1.3p pd=5.3u as=0.725p ps=2.725u w=2u l=0.28u
X40 w_n310_281# m2_1295_79# a_10906_466# w_n310_281# pfet_03v3 ad=0.735p pd=2.47u as=0.42p ps=1.84u w=1u l=0.28u
X41 a_7083_63# m2_6151_79# via_dev$5_9/VSUBS via_dev$5_9/VSUBS nfet_03v3 ad=0.2625p pd=2.05u as=0.265p ps=2.06u w=0.5u l=0.28u
X42 a_510_63# a_378_271# w_n310_281# w_n310_281# pfet_03v3 ad=0.65p pd=3.3u as=0.56p ps=3.12u w=1u l=0.28u
X43 a_10363_63# m2_9431_79# w_n310_281# w_n310_281# pfet_03v3 ad=0.715p pd=3.43u as=0.53p ps=3.06u w=1u l=0.28u
X44 a_510_63# a_378_271# via_dev$5_9/VSUBS via_dev$5_9/VSUBS nfet_03v3 ad=0.315p pd=2.26u as=0.28p ps=2.12u w=0.5u l=0.28u
X45 a_1262_n37# a_160_63# m2_1295_79# via_dev$5_9/VSUBS nfet_03v3 ad=0.3625p pd=1.725u as=0.3375p ps=1.675u w=1u l=0.28u
X46 a_1845_n37# a_378_271# via_dev$5_9/VSUBS via_dev$5_9/VSUBS nfet_03v3 ad=0.42p pd=1.84u as=0.63p ps=3.26u w=1u l=0.28u
X47 m2_6151_79# m2_5700_324# a_6721_407# w_n310_281# pfet_03v3 ad=0.725p pd=2.725u as=1.09p ps=5.09u w=2u l=0.28u
X48 a_6721_407# a_5768_63# w_n310_281# w_n310_281# pfet_03v3 ad=1.3p pd=5.3u as=0.725p ps=2.725u w=2u l=0.28u
X49 a_10363_63# m2_9431_79# via_dev$5_9/VSUBS via_dev$5_9/VSUBS nfet_03v3 ad=0.3575p pd=2.43u as=0.265p ps=2.06u w=0.5u l=0.28u
X50 a_10906_466# m2_1295_79# a_10906_n37# via_dev$5_9/VSUBS nfet_03v3 ad=0.65p pd=3.3u as=0.42p ps=1.84u w=1u l=0.28u
X51 a_8723_63# m2_7791_79# w_n310_281# w_n310_281# pfet_03v3 ad=0.545p pd=3.09u as=0.53p ps=3.06u w=1u l=0.28u
X52 a_11480_63# a_10906_466# w_n310_281# w_n310_281# pfet_03v3 ad=0.65p pd=3.3u as=0.735p ps=2.47u w=1u l=0.28u
X53 a_12559_3# a_11922_3# via_dev$5_9/VSUBS via_dev$5_9/VSUBS nfet_03v3 ad=0.315p pd=2.26u as=0.325p ps=2.3u w=0.5u l=0.28u
X54 a_7083_63# m2_6151_79# w_n310_281# w_n310_281# pfet_03v3 ad=0.545p pd=3.09u as=0.53p ps=3.06u w=1u l=0.28u
X55 a_7768_n37# m2_5700_324# via_dev$5_9/VSUBS via_dev$5_9/VSUBS nfet_03v3 ad=0.3625p pd=1.725u as=0.54p ps=3.08u w=1u l=0.28u
X56 a_160_63# m2_24_342# w_n310_281# w_n310_281# pfet_03v3 ad=0.63p pd=3.26u as=0.65p ps=3.3u w=1u l=0.28u
X57 m2_1295_79# a_160_63# a_705_407# w_n310_281# pfet_03v3 ad=0.725p pd=2.725u as=0.675p ps=2.675u w=2u l=0.28u
X58 a_5042_n37# a_3940_63# a_5042_407# via_dev$5_9/VSUBS nfet_03v3 ad=0.3625p pd=1.725u as=0.3375p ps=1.675u w=1u l=0.28u
X59 m2_1295_79# m2_24_342# a_870_n37# via_dev$5_9/VSUBS nfet_03v3 ad=0.3375p pd=1.675u as=0.3625p ps=1.725u w=1u l=0.28u
X60 a_11922_3# a_2419_63# a_11922_391# w_n310_281# pfet_03v3 ad=1.3p pd=5.3u as=0.725p ps=2.725u w=2u l=0.28u
X61 a_9800_n37# a_7083_63# m2_9431_79# via_dev$5_9/VSUBS nfet_03v3 ad=0.3625p pd=1.725u as=0.3375p ps=1.675u w=1u l=0.28u
X62 m2_7791_79# m2_5700_324# a_8361_407# w_n310_281# pfet_03v3 ad=0.725p pd=2.725u as=1.09p ps=5.09u w=2u l=0.28u
X63 a_5042_407# a_3940_63# a_5243_407# w_n310_281# pfet_03v3 ad=0.725p pd=2.725u as=0.675p ps=2.675u w=2u l=0.28u
X64 a_3940_63# m2_1295_79# via_dev$5_9/VSUBS via_dev$5_9/VSUBS nfet_03v3 ad=0.315p pd=2.26u as=0.325p ps=2.3u w=0.5u l=0.28u
X65 a_8160_n37# a_3498_3# m2_7791_79# via_dev$5_9/VSUBS nfet_03v3 ad=0.3625p pd=1.725u as=0.3375p ps=1.675u w=1u l=0.28u
X66 a_705_407# m2_24_342# w_n310_281# w_n310_281# pfet_03v3 ad=0.675p pd=2.675u as=0.725p ps=2.725u w=2u l=0.28u
X67 a_5042_407# m2_1295_79# a_4650_n37# via_dev$5_9/VSUBS nfet_03v3 ad=0.3375p pd=1.675u as=0.3625p ps=1.725u w=1u l=0.28u
X68 a_6520_n37# a_5042_407# m2_6151_79# via_dev$5_9/VSUBS nfet_03v3 ad=0.3625p pd=1.725u as=0.3375p ps=1.675u w=1u l=0.28u
X69 w_n310_281# a_7083_63# a_9609_407# w_n310_281# pfet_03v3 ad=0.725p pd=2.725u as=0.675p ps=2.675u w=2u l=0.28u
X70 a_2419_63# a_1845_466# w_n310_281# w_n310_281# pfet_03v3 ad=0.65p pd=3.3u as=0.735p ps=2.47u w=1u l=0.28u
X71 m2_9431_79# a_8723_63# a_9408_n37# via_dev$5_9/VSUBS nfet_03v3 ad=0.3375p pd=1.675u as=0.3625p ps=1.725u w=1u l=0.28u
X72 w_n310_281# a_3498_3# a_8361_407# w_n310_281# pfet_03v3 ad=0.725p pd=2.725u as=0.675p ps=2.675u w=2u l=0.28u
X73 a_2861_391# m2_1295_79# w_n310_281# w_n310_281# pfet_03v3 ad=0.725p pd=2.725u as=1.3p ps=5.3u w=2u l=0.28u
X74 a_4290_63# a_4158_271# w_n310_281# w_n310_281# pfet_03v3 ad=0.65p pd=3.3u as=0.56p ps=3.12u w=1u l=0.28u
X75 a_5243_407# m2_1295_79# w_n310_281# w_n310_281# pfet_03v3 ad=0.675p pd=2.675u as=0.725p ps=2.725u w=2u l=0.28u
X76 w_n310_281# a_5042_407# a_6721_407# w_n310_281# pfet_03v3 ad=0.725p pd=2.725u as=0.675p ps=2.675u w=2u l=0.28u
X77 a_3498_3# a_2861_3# via_dev$5_9/VSUBS via_dev$5_9/VSUBS nfet_03v3 ad=0.315p pd=2.26u as=0.325p ps=2.3u w=0.5u l=0.28u
X78 a_9609_407# a_8723_63# m2_9431_79# w_n310_281# pfet_03v3 ad=0.675p pd=2.675u as=0.725p ps=2.725u w=2u l=0.28u
X79 via_dev$5_9/VSUBS a_4290_63# a_5042_n37# via_dev$5_9/VSUBS nfet_03v3 ad=0.65p pd=3.3u as=0.3625p ps=1.725u w=1u l=0.28u
X80 m2_6151_79# a_2419_63# a_6128_n37# via_dev$5_9/VSUBS nfet_03v3 ad=0.3375p pd=1.675u as=0.3625p ps=1.725u w=1u l=0.28u
X81 w_n310_281# m2_24_342# a_1845_466# w_n310_281# pfet_03v3 ad=0.735p pd=2.47u as=0.42p ps=1.84u w=1u l=0.28u
X82 a_870_n37# a_378_271# via_dev$5_9/VSUBS via_dev$5_9/VSUBS nfet_03v3 ad=0.3625p pd=1.725u as=0.54p ps=3.08u w=1u l=0.28u
X83 a_12559_3# a_11922_3# w_n310_281# w_n310_281# pfet_03v3 ad=0.65p pd=3.3u as=0.675p ps=3.35u w=1u l=0.28u
C0 a_9050_63# a_7083_63# 0.21474f
C1 a_5768_63# a_2419_63# 0.07749f
C2 a_9050_63# m2_1295_79# 0.00716f
C3 a_5768_63# a_6520_n37# 0.01329f
C4 a_9050_63# a_8723_63# 0.5277f
C5 a_2861_3# m2_1295_79# 0.15381f
C6 a_5042_n37# m2_6151_79# 0
C7 a_11922_3# a_12559_3# 0.0899f
C8 a_510_63# a_378_271# 0.14298f
C9 a_510_63# a_870_n37# 0.01502f
C10 m2_5700_324# a_7410_63# 0.14432f
C11 a_5042_n37# a_5042_407# 0.01726f
C12 a_8918_357# a_7410_63# 0
C13 w_n310_281# a_7410_63# 0.31086f
C14 w_n310_281# a_1845_466# 0.44517f
C15 a_4290_63# a_4650_n37# 0.01502f
C16 a_1845_466# a_705_407# 0.0126f
C17 a_8918_357# a_9609_407# 0.02942f
C18 a_9609_407# w_n310_281# 0.7653f
C19 a_7410_63# m2_6151_79# 0
C20 a_4290_63# a_5243_407# 0.14023f
C21 m2_24_342# a_378_271# 0.56715f
C22 w_n310_281# a_10906_466# 0.44509f
C23 a_7410_63# a_3498_3# 0.11774f
C24 a_2419_63# a_10363_63# 0.00126f
C25 a_1845_466# a_3498_3# 0.00105f
C26 a_1845_n37# w_n310_281# 0
C27 a_1845_466# a_160_63# 0
C28 a_4290_63# a_4158_271# 0.11363f
C29 a_2419_63# m2_7791_79# 0.00843f
C30 a_7410_63# m2_9431_79# 0.00105f
C31 a_2419_63# a_5243_407# 0
C32 a_378_271# m2_1295_79# 0.02669f
C33 a_7410_63# a_5042_407# 0
C34 a_870_n37# m2_1295_79# 0.00639f
C35 m2_24_342# a_2419_63# 0.00234f
C36 a_9609_407# m2_9431_79# 0.49779f
C37 a_2419_63# a_4158_271# 0.14782f
C38 a_4290_63# m2_1295_79# 0.13519f
C39 a_10906_466# m2_9431_79# 0.00167f
C40 a_10906_466# a_10906_n37# 0.01333f
C41 a_6520_n37# a_4158_271# 0.00406f
C42 a_2419_63# a_8361_407# 0
C43 a_1845_466# a_3940_63# 0
C44 a_2419_63# a_7083_63# 0.01345f
C45 a_10363_63# a_11480_63# 0
C46 a_2419_63# m2_1295_79# 0.3246f
C47 a_6520_n37# a_7083_63# 0.00272f
C48 a_10906_466# a_12559_3# 0
C49 a_11922_391# a_11922_3# 0.01891f
C50 a_2419_63# a_8723_63# 0.00649f
C51 a_7768_n37# m2_9431_79# 0
C52 a_11480_63# a_4158_271# 0.00295f
C53 a_9050_63# a_9609_407# 0.1261f
C54 a_5768_63# m2_7791_79# 0
C55 a_2861_3# a_1845_466# 0
C56 a_5768_63# a_5243_407# 0.00722f
C57 a_11480_63# m2_1295_79# 0.00126f
C58 a_5768_63# a_4158_271# 0.00573f
C59 a_2419_63# a_11922_3# 0.16984f
C60 a_5768_63# a_7083_63# 0.01494f
C61 a_9408_n37# m2_7791_79# 0
C62 a_8160_n37# m2_9431_79# 0
C63 a_4290_63# a_5042_n37# 0.00898f
C64 a_5768_63# m2_1295_79# 0.00766f
C65 a_8918_357# m2_5700_324# 0
C66 m2_5700_324# w_n310_281# 1.65678f
C67 a_8918_357# w_n310_281# 0.49453f
C68 a_9408_n37# a_7083_63# 0.00336f
C69 w_n310_281# a_705_407# 0.79414f
C70 a_11480_63# a_11922_3# 0.04054f
C71 m2_5700_324# m2_6151_79# 0.14941f
C72 a_510_63# a_1262_n37# 0.00898f
C73 w_n310_281# m2_6151_79# 0.44301f
C74 m2_5700_324# a_3498_3# 0.55174f
C75 a_378_271# a_1845_466# 0.01278f
C76 a_510_63# m2_24_342# 0.13025f
C77 w_n310_281# a_3498_3# 1.03377f
C78 a_870_n37# a_1845_466# 0
C79 w_n310_281# a_160_63# 0.30515f
C80 m2_5700_324# a_6721_407# 0.50857f
C81 w_n310_281# a_6721_407# 0.72579f
C82 a_705_407# a_160_63# 0.06737f
C83 a_10363_63# a_4158_271# 0.02222f
C84 w_n310_281# m2_9431_79# 0.46253f
C85 a_8918_357# m2_9431_79# 0.03217f
C86 a_4650_n37# a_4158_271# 0.00383f
C87 a_3498_3# m2_6151_79# 0
C88 w_n310_281# a_10906_n37# 0
C89 m2_7791_79# a_4158_271# 0
C90 a_510_63# m2_1295_79# 0.39896f
C91 a_9800_n37# a_4158_271# 0.00497f
C92 m2_5700_324# a_5042_407# 0.06917f
C93 a_2419_63# a_7410_63# 0.00801f
C94 a_5243_407# a_4158_271# 0.02964f
C95 w_n310_281# a_5042_407# 0.29911f
C96 a_6721_407# m2_6151_79# 0.4935f
C97 a_10363_63# a_7083_63# 0.00582f
C98 a_2419_63# a_1845_466# 0.10509f
C99 a_8361_407# m2_7791_79# 0.49779f
C100 a_3498_3# a_6721_407# 0
C101 a_10363_63# m2_1295_79# 0.00179f
C102 a_9609_407# a_2419_63# 0
C103 m2_7791_79# a_7083_63# 0.14708f
C104 a_9800_n37# a_7083_63# 0.00527f
C105 m2_5700_324# a_3940_63# 0.00132f
C106 a_3498_3# m2_9431_79# 0
C107 w_n310_281# a_12559_3# 0.08598f
C108 a_2861_391# w_n310_281# 0.03535f
C109 a_2419_63# a_10906_466# 0.00833f
C110 a_5042_407# m2_6151_79# 0.20459f
C111 w_n310_281# a_3940_63# 0.30087f
C112 m2_1295_79# m2_7791_79# 0.05731f
C113 a_10363_63# a_8723_63# 0
C114 a_2861_391# a_705_407# 0
C115 a_3498_3# a_5042_407# 0.02015f
C116 a_5243_407# m2_1295_79# 0.10989f
C117 m2_7791_79# a_8723_63# 0.08381f
C118 a_7083_63# a_4158_271# 1.09132f
C119 a_1262_n37# m2_1295_79# 0.01607f
C120 a_5042_407# a_6721_407# 0.03265f
C121 a_2861_391# a_3498_3# 0.00454f
C122 m2_24_342# m2_1295_79# 0.04399f
C123 m2_1295_79# a_4158_271# 0.16058f
C124 a_3498_3# a_3940_63# 0.04602f
C125 a_8361_407# a_7083_63# 0.01453f
C126 a_8918_357# a_9050_63# 0.09973f
C127 a_9050_63# w_n310_281# 0.28931f
C128 a_8723_63# a_4158_271# 0
C129 m2_1295_79# a_8361_407# 0.02509f
C130 m2_1295_79# a_7083_63# 0.01071f
C131 a_2861_3# w_n310_281# 0.4655f
C132 a_8361_407# a_8723_63# 0.01268f
C133 a_9609_407# a_11480_63# 0
C134 a_8723_63# a_7083_63# 0.15796f
C135 a_2861_3# a_705_407# 0
C136 a_3940_63# a_5042_407# 0.0941f
C137 a_11480_63# a_10906_466# 0.1131f
C138 m2_1295_79# a_8723_63# 0.00796f
C139 a_2861_3# a_3498_3# 0.09846f
C140 a_9050_63# m2_9431_79# 0.328f
C141 a_11922_3# a_4158_271# 0.0013f
C142 a_2861_3# a_5042_407# 0
C143 a_2861_3# a_2861_391# 0.01616f
C144 w_n310_281# a_11922_391# 0.03535f
C145 a_11922_3# m2_1295_79# 0
C146 a_5042_n37# a_5243_407# 0
C147 a_2861_3# a_3940_63# 0
C148 a_9609_407# a_9408_n37# 0
C149 a_5042_n37# a_4158_271# 0
C150 w_n310_281# a_378_271# 0.63374f
C151 a_6128_n37# m2_6151_79# 0.01733f
C152 a_510_63# a_1845_466# 0.01433f
C153 a_378_271# a_705_407# 0.02817f
C154 m2_5700_324# a_4290_63# 0.01531f
C155 w_n310_281# a_4290_63# 0.2819f
C156 a_6128_n37# a_6721_407# 0
C157 a_7410_63# m2_7791_79# 0.36168f
C158 a_9609_407# a_10363_63# 0.01306f
C159 a_378_271# a_160_63# 0.09182f
C160 a_4290_63# m2_6151_79# 0
C161 m2_5700_324# a_2419_63# 0.074f
C162 a_510_63# a_1845_n37# 0.0011f
C163 a_8918_357# a_2419_63# 0.01449f
C164 w_n310_281# a_2419_63# 0.75124f
C165 a_10363_63# a_10906_466# 0.02047f
C166 a_870_n37# a_160_63# 0.00441f
C167 a_4290_63# a_3498_3# 0.00876f
C168 a_9609_407# m2_7791_79# 0
C169 a_6128_n37# a_5042_407# 0.00376f
C170 a_2419_63# a_705_407# 0
C171 a_1262_n37# a_1845_466# 0
C172 a_7410_63# a_4158_271# 0
C173 m2_24_342# a_1845_466# 0.06999f
C174 a_2419_63# m2_6151_79# 0.05852f
C175 a_7410_63# a_8361_407# 0.1423f
C176 a_2419_63# a_3498_3# 0.01177f
C177 a_9609_407# a_4158_271# 0
C178 a_6520_n37# m2_6151_79# 0.00766f
C179 a_7410_63# a_7083_63# 0.07718f
C180 a_4290_63# a_5042_407# 0.38112f
C181 a_10906_466# a_4158_271# 0.03873f
C182 a_2419_63# a_6721_407# 0.01825f
C183 a_7410_63# m2_1295_79# 0.07614f
C184 a_9609_407# a_8361_407# 0.00466f
C185 a_1845_466# m2_1295_79# 0.09644f
C186 a_2419_63# m2_9431_79# 0.00832f
C187 a_9609_407# a_7083_63# 0.0285f
C188 a_7410_63# a_8723_63# 0.01398f
C189 a_4290_63# a_3940_63# 0.28903f
C190 a_7768_n37# m2_7791_79# 0.01733f
C191 a_9609_407# m2_1295_79# 0.0093f
C192 a_10906_466# a_7083_63# 0
C193 a_2419_63# a_5042_407# 0.08051f
C194 w_n310_281# a_11480_63# 0.37298f
C195 a_10906_466# m2_1295_79# 0.0692f
C196 a_9609_407# a_8723_63# 0.0593f
C197 a_6520_n37# a_5042_407# 0.00483f
C198 a_2861_391# a_2419_63# 0.0163f
C199 a_2419_63# a_12559_3# 0
C200 a_1845_n37# m2_1295_79# 0.00942f
C201 a_2419_63# a_3940_63# 0.00879f
C202 m2_5700_324# a_5768_63# 0.16447f
C203 a_5768_63# w_n310_281# 0.31314f
C204 a_7768_n37# a_8361_407# 0
C205 a_7768_n37# a_7083_63# 0.0028f
C206 a_2861_3# a_4290_63# 0
C207 a_11480_63# m2_9431_79# 0
C208 a_9050_63# a_2419_63# 0.00801f
C209 a_5768_63# m2_6151_79# 0.35511f
C210 a_5768_63# a_3498_3# 0
C211 a_8160_n37# m2_7791_79# 0.01048f
C212 a_2861_3# a_2419_63# 0.21478f
C213 a_5768_63# a_6721_407# 0.14017f
C214 a_10906_466# a_11922_3# 0
C215 a_5768_63# a_5042_407# 0.22596f
C216 a_8160_n37# a_7083_63# 0.00507f
C217 a_5768_63# a_3940_63# 0
C218 a_510_63# w_n310_281# 0.28255f
C219 a_9408_n37# m2_9431_79# 0.01733f
C220 a_510_63# a_705_407# 0.13828f
C221 w_n310_281# a_10363_63# 0.15741f
C222 a_8918_357# a_10363_63# 0
C223 m2_5700_324# m2_7791_79# 0.05245f
C224 a_8918_357# m2_7791_79# 0.02763f
C225 w_n310_281# m2_7791_79# 0.45143f
C226 a_2419_63# a_11922_391# 0.00754f
C227 m2_5700_324# a_5243_407# 0.01927f
C228 a_510_63# a_160_63# 0.28903f
C229 w_n310_281# a_5243_407# 0.78984f
C230 m2_6151_79# m2_7791_79# 0.00114f
C231 m2_5700_324# a_4158_271# 0.00861f
C232 m2_24_342# w_n310_281# 0.66878f
C233 a_8918_357# a_4158_271# 0.00101f
C234 w_n310_281# a_4158_271# 0.66883f
C235 a_1262_n37# a_705_407# 0
C236 a_3498_3# m2_7791_79# 0.0296f
C237 m2_24_342# a_705_407# 0.10607f
C238 m2_5700_324# a_8361_407# 0.05956f
C239 a_10363_63# m2_9431_79# 0.07766f
C240 a_3498_3# a_5243_407# 0.16427f
C241 a_10363_63# a_10906_n37# 0
C242 a_8918_357# a_8361_407# 0
C243 m2_5700_324# a_7083_63# 0.12051f
C244 w_n310_281# a_8361_407# 0.75753f
C245 a_4290_63# a_2419_63# 0.00652f
C246 a_8918_357# a_7083_63# 0.01057f
C247 w_n310_281# a_7083_63# 0.31663f
C248 m2_6151_79# a_4158_271# 0.04334f
C249 m2_7791_79# m2_9431_79# 0.01571f
C250 a_9800_n37# m2_9431_79# 0.0074f
C251 m2_5700_324# m2_1295_79# 0.07849f
C252 a_9050_63# a_9408_n37# 0.00935f
C253 m2_24_342# a_3498_3# 0
C254 a_8918_357# m2_1295_79# 0.01371f
C255 a_3498_3# a_4158_271# 0.00829f
C256 w_n310_281# m2_1295_79# 2.35223f
C257 a_4650_n37# a_5042_407# 0.00712f
C258 m2_24_342# a_160_63# 0.42316f
C259 a_9609_407# a_10906_466# 0
C260 a_1845_n37# a_1845_466# 0.01333f
C261 m2_5700_324# a_8723_63# 0
C262 a_5042_407# m2_7791_79# 0.00555f
C263 a_705_407# m2_1295_79# 0.30816f
C264 a_11480_63# a_11922_391# 0.00152f
C265 m2_6151_79# a_7083_63# 0.08089f
C266 a_8918_357# a_8723_63# 0.1249f
C267 w_n310_281# a_8723_63# 0.33516f
C268 a_5243_407# a_5042_407# 0.29512f
C269 a_3498_3# a_8361_407# 0.12093f
C270 m2_9431_79# a_4158_271# 0.05572f
C271 a_10906_n37# a_4158_271# 0.00824f
C272 m2_1295_79# m2_6151_79# 0.00667f
C273 a_3498_3# a_7083_63# 0.01356f
C274 a_4650_n37# a_3940_63# 0.00441f
C275 a_3498_3# m2_1295_79# 0.3391f
C276 a_5042_407# a_4158_271# 0.63867f
C277 a_7410_63# a_7768_n37# 0.00935f
C278 a_8361_407# m2_9431_79# 0
C279 a_6721_407# a_7083_63# 0.01268f
C280 a_160_63# m2_1295_79# 0.09339f
C281 a_5243_407# a_3940_63# 0.06737f
C282 m2_9431_79# a_7083_63# 0.19293f
C283 a_3498_3# a_8723_63# 0.00575f
C284 m2_1295_79# a_6721_407# 0.00452f
C285 m2_1295_79# m2_9431_79# 0.0078f
C286 a_9050_63# a_10363_63# 0.01385f
C287 a_3940_63# a_4158_271# 0.16366f
C288 a_5042_407# a_7083_63# 0.02611f
C289 a_5768_63# a_6128_n37# 0.00935f
C290 m2_9431_79# a_8723_63# 0.13485f
C291 a_9050_63# m2_7791_79# 0.00127f
C292 m2_1295_79# a_5042_407# 0.03487f
C293 a_9050_63# a_9800_n37# 0.01329f
C294 w_n310_281# a_11922_3# 0.46598f
C295 a_2861_391# m2_1295_79# 0.00841f
C296 a_2419_63# a_11480_63# 0.0769f
C297 m2_1295_79# a_3940_63# 0.46061f
C298 a_5768_63# a_4290_63# 0.01093f
C299 a_2861_3# a_5243_407# 0
C300 a_9050_63# a_4158_271# 0.00717f
C301 a_7410_63# a_8160_n37# 0.01329f
C302 a_9050_63# a_8361_407# 0
C303 a_4158_271# via_dev$5_9/VSUBS 2.6385f
C304 a_7083_63# via_dev$5_9/VSUBS 0.86585f
C305 a_8723_63# via_dev$5_9/VSUBS 0.40969f
C306 m2_9431_79# via_dev$5_9/VSUBS 0.75255f
C307 m2_7791_79# via_dev$5_9/VSUBS 0.74612f
C308 a_8361_407# via_dev$5_9/VSUBS 0.05216f
C309 m2_6151_79# via_dev$5_9/VSUBS 0.72815f
C310 a_6721_407# via_dev$5_9/VSUBS 0.01698f
C311 a_5042_407# via_dev$5_9/VSUBS 0.88916f
C312 a_3940_63# via_dev$5_9/VSUBS 0.46864f
C313 m2_1295_79# via_dev$5_9/VSUBS 3.34416f
C314 a_160_63# via_dev$5_9/VSUBS 0.5921f
C315 a_5243_407# via_dev$5_9/VSUBS 0.01661f
C316 a_705_407# via_dev$5_9/VSUBS 0.13677f
C317 a_3498_3# via_dev$5_9/VSUBS 1.27724f
C318 a_10906_n37# via_dev$5_9/VSUBS 0.02232f
C319 a_9800_n37# via_dev$5_9/VSUBS 0.01742f
C320 a_9408_n37# via_dev$5_9/VSUBS 0.007f
C321 a_8160_n37# via_dev$5_9/VSUBS 0.01743f
C322 a_7768_n37# via_dev$5_9/VSUBS 0.007f
C323 a_6520_n37# via_dev$5_9/VSUBS 0.01743f
C324 a_6128_n37# via_dev$5_9/VSUBS 0.007f
C325 a_5042_n37# via_dev$5_9/VSUBS 0.00833f
C326 a_4650_n37# via_dev$5_9/VSUBS 0.01565f
C327 a_12559_3# via_dev$5_9/VSUBS 0.19481f
C328 a_11922_3# via_dev$5_9/VSUBS 0.64569f
C329 a_11922_391# via_dev$5_9/VSUBS 0.00119f
C330 a_10906_466# via_dev$5_9/VSUBS 0.59796f
C331 a_11480_63# via_dev$5_9/VSUBS 0.42359f
C332 a_10363_63# via_dev$5_9/VSUBS 0.13924f
C333 a_9050_63# via_dev$5_9/VSUBS 0.53264f
C334 a_8918_357# via_dev$5_9/VSUBS 0.52045f
C335 a_7410_63# via_dev$5_9/VSUBS 0.53731f
C336 a_5768_63# via_dev$5_9/VSUBS 0.54f
C337 a_1845_n37# via_dev$5_9/VSUBS 0.01974f
C338 a_1262_n37# via_dev$5_9/VSUBS 0.0069f
C339 a_870_n37# via_dev$5_9/VSUBS 0.01517f
C340 a_4290_63# via_dev$5_9/VSUBS 0.57048f
C341 a_2861_3# via_dev$5_9/VSUBS 0.62907f
C342 a_1845_466# via_dev$5_9/VSUBS 0.59853f
C343 a_2419_63# via_dev$5_9/VSUBS 6.64114f
C344 a_510_63# via_dev$5_9/VSUBS 0.55998f
C345 a_378_271# via_dev$5_9/VSUBS 1.37769f
C346 w_n310_281# via_dev$5_9/VSUBS 27.06926f
C347 a_9609_407# via_dev$5_9/VSUBS 0.11967f
C348 m2_24_342# via_dev$5_9/VSUBS 1.98211f
C349 m2_5700_324# via_dev$5_9/VSUBS 1.14834f
.ends

.subckt x1bitblock$1 a_2861_3# a_8361_407# a_6520_n37# a_1262_n37# a_2861_391# a_1845_466#
+ a_10906_n37# a_510_63# a_870_n37# a_6721_407# a_9800_n37# m2_24_342# a_11480_63#
+ a_6128_n37# a_5768_63# m2_6151_79# a_3498_3# a_11922_391# a_5042_n37# a_9408_n37#
+ a_9609_407# a_5042_407# a_8160_n37# a_4158_271# a_11922_3# a_2419_63# m2_9431_79#
+ a_10906_466# a_4650_n37# a_9050_63# a_5243_407# a_7768_n37# a_160_63# a_3940_63#
+ a_8919_370# m2_7791_79# a_10363_63# a_4290_63# a_7083_63# a_705_407# a_12559_3#
+ a_7410_63# m2_5700_324# a_1845_n37# via_dev$5$1_9/VSUBS m2_1295_79# a_8723_63# a_378_271#
+ w_n310_281#
X0 a_2419_63# a_1845_466# via_dev$5$1_9/VSUBS via_dev$5$1_9/VSUBS nfet_03v3 ad=0.315p pd=2.26u as=0.2425p ps=1.97u w=0.5u l=0.28u
X1 a_1845_466# m2_24_342# a_1845_n37# via_dev$5$1_9/VSUBS nfet_03v3 ad=0.65p pd=3.3u as=0.42p ps=1.84u w=1u l=0.28u
X2 a_3940_63# m2_1295_79# w_n310_281# w_n310_281# pfet_03v3 ad=0.63p pd=3.26u as=0.65p ps=3.3u w=1u l=0.28u
X3 via_dev$5$1_9/VSUBS a_510_63# a_1262_n37# via_dev$5$1_9/VSUBS nfet_03v3 ad=0.65p pd=3.3u as=0.3625p ps=1.725u w=1u l=0.28u
X4 a_5243_407# a_4290_63# a_5042_407# w_n310_281# pfet_03v3 ad=1.3p pd=5.3u as=0.725p ps=2.725u w=2u l=0.28u
X5 a_6721_407# a_2419_63# m2_6151_79# w_n310_281# pfet_03v3 ad=0.675p pd=2.675u as=0.725p ps=2.725u w=2u l=0.28u
X6 a_10906_466# a_4158_271# w_n310_281# w_n310_281# pfet_03v3 ad=0.42p pd=1.84u as=0.65p ps=3.3u w=1u l=0.28u
X7 a_4290_63# a_4158_271# via_dev$5$1_9/VSUBS via_dev$5$1_9/VSUBS nfet_03v3 ad=0.315p pd=2.26u as=0.28p ps=2.12u w=0.5u l=0.28u
X8 w_n310_281# a_378_271# a_705_407# w_n310_281# pfet_03v3 ad=0.725p pd=2.725u as=1.09p ps=5.09u w=2u l=0.28u
X9 a_2861_3# m2_1295_79# via_dev$5$1_9/VSUBS via_dev$5$1_9/VSUBS nfet_03v3 ad=0.18125p pd=1.225u as=0.325p ps=2.3u w=0.5u l=0.28u
X10 via_dev$5$1_9/VSUBS a_2419_63# a_2861_3# via_dev$5$1_9/VSUBS nfet_03v3 ad=0.315p pd=2.26u as=0.18125p ps=1.225u w=0.5u l=0.28u
X11 m2_7791_79# m2_1295_79# a_7768_n37# via_dev$5$1_9/VSUBS nfet_03v3 ad=0.3375p pd=1.675u as=0.3625p ps=1.725u w=1u l=0.28u
X12 a_10906_n37# a_4158_271# via_dev$5$1_9/VSUBS via_dev$5$1_9/VSUBS nfet_03v3 ad=0.42p pd=1.84u as=0.63p ps=3.26u w=1u l=0.28u
X13 a_9050_63# a_8919_370# via_dev$5$1_9/VSUBS via_dev$5$1_9/VSUBS nfet_03v3 ad=0.31p pd=2.24u as=0.24p ps=1.96u w=0.5u l=0.28u
X14 a_11922_3# a_11480_63# via_dev$5$1_9/VSUBS via_dev$5$1_9/VSUBS nfet_03v3 ad=0.18125p pd=1.225u as=0.325p ps=2.3u w=0.5u l=0.28u
X15 via_dev$5$1_9/VSUBS a_2419_63# a_11922_3# via_dev$5$1_9/VSUBS nfet_03v3 ad=0.315p pd=2.26u as=0.18125p ps=1.225u w=0.5u l=0.28u
X16 a_705_407# a_510_63# m2_1295_79# w_n310_281# pfet_03v3 ad=1.3p pd=5.3u as=0.725p ps=2.725u w=2u l=0.28u
X17 a_4650_n37# a_4158_271# via_dev$5$1_9/VSUBS via_dev$5$1_9/VSUBS nfet_03v3 ad=0.3625p pd=1.725u as=0.54p ps=3.08u w=1u l=0.28u
X18 a_2861_3# a_2419_63# a_2861_391# w_n310_281# pfet_03v3 ad=1.3p pd=5.3u as=0.725p ps=2.725u w=2u l=0.28u
X19 a_5768_63# m2_5700_324# via_dev$5$1_9/VSUBS via_dev$5$1_9/VSUBS nfet_03v3 ad=0.315p pd=2.26u as=0.3175p ps=2.27u w=0.5u l=0.28u
X20 via_dev$5$1_9/VSUBS a_9050_63# a_9800_n37# via_dev$5$1_9/VSUBS nfet_03v3 ad=0.65p pd=3.3u as=0.3625p ps=1.725u w=1u l=0.28u
X21 a_8361_407# m2_1295_79# m2_7791_79# w_n310_281# pfet_03v3 ad=0.675p pd=2.675u as=0.725p ps=2.725u w=2u l=0.28u
X22 a_9408_n37# a_8919_370# via_dev$5$1_9/VSUBS via_dev$5$1_9/VSUBS nfet_03v3 ad=0.3625p pd=1.725u as=0.54p ps=3.08u w=1u l=0.28u
X23 a_3498_3# a_2861_3# w_n310_281# w_n310_281# pfet_03v3 ad=0.65p pd=3.3u as=0.675p ps=3.35u w=1u l=0.28u
X24 a_7410_63# m2_5700_324# via_dev$5$1_9/VSUBS via_dev$5$1_9/VSUBS nfet_03v3 ad=0.31p pd=2.24u as=0.24p ps=1.96u w=0.5u l=0.28u
X25 via_dev$5$1_9/VSUBS a_7410_63# a_8160_n37# via_dev$5$1_9/VSUBS nfet_03v3 ad=0.65p pd=3.3u as=0.3625p ps=1.725u w=1u l=0.28u
X26 a_8723_63# m2_7791_79# via_dev$5$1_9/VSUBS via_dev$5$1_9/VSUBS nfet_03v3 ad=0.2625p pd=2.05u as=0.265p ps=2.06u w=0.5u l=0.28u
X27 w_n310_281# a_4158_271# a_5243_407# w_n310_281# pfet_03v3 ad=0.725p pd=2.725u as=1.09p ps=5.09u w=2u l=0.28u
X28 a_5768_63# m2_5700_324# w_n310_281# w_n310_281# pfet_03v3 ad=0.65p pd=3.3u as=0.635p ps=3.27u w=1u l=0.28u
X29 a_9050_63# a_8919_370# w_n310_281# w_n310_281# pfet_03v3 ad=0.64p pd=3.28u as=0.48p ps=2.96u w=1u l=0.28u
X30 a_11922_391# a_11480_63# w_n310_281# w_n310_281# pfet_03v3 ad=0.725p pd=2.725u as=1.3p ps=5.3u w=2u l=0.28u
X31 a_160_63# m2_24_342# via_dev$5$1_9/VSUBS via_dev$5$1_9/VSUBS nfet_03v3 ad=0.315p pd=2.26u as=0.325p ps=2.3u w=0.5u l=0.28u
X32 a_9609_407# a_9050_63# w_n310_281# w_n310_281# pfet_03v3 ad=1.3p pd=5.3u as=0.725p ps=2.725u w=2u l=0.28u
X33 a_6128_n37# m2_5700_324# via_dev$5$1_9/VSUBS via_dev$5$1_9/VSUBS nfet_03v3 ad=0.3625p pd=1.725u as=0.54p ps=3.08u w=1u l=0.28u
X34 via_dev$5$1_9/VSUBS a_5768_63# a_6520_n37# via_dev$5$1_9/VSUBS nfet_03v3 ad=0.65p pd=3.3u as=0.3625p ps=1.725u w=1u l=0.28u
X35 a_7410_63# m2_5700_324# w_n310_281# w_n310_281# pfet_03v3 ad=0.64p pd=3.28u as=0.48p ps=2.96u w=1u l=0.28u
X36 m2_9431_79# a_8919_370# a_9609_407# w_n310_281# pfet_03v3 ad=0.725p pd=2.725u as=1.09p ps=5.09u w=2u l=0.28u
X37 a_11480_63# a_10906_466# via_dev$5$1_9/VSUBS via_dev$5$1_9/VSUBS nfet_03v3 ad=0.315p pd=2.26u as=0.2425p ps=1.97u w=0.5u l=0.28u
X38 a_1845_466# a_378_271# w_n310_281# w_n310_281# pfet_03v3 ad=0.42p pd=1.84u as=0.65p ps=3.3u w=1u l=0.28u
X39 a_8361_407# a_7410_63# w_n310_281# w_n310_281# pfet_03v3 ad=1.3p pd=5.3u as=0.725p ps=2.725u w=2u l=0.28u
X40 w_n310_281# m2_1295_79# a_10906_466# w_n310_281# pfet_03v3 ad=0.735p pd=2.47u as=0.42p ps=1.84u w=1u l=0.28u
X41 a_7083_63# m2_6151_79# via_dev$5$1_9/VSUBS via_dev$5$1_9/VSUBS nfet_03v3 ad=0.2625p pd=2.05u as=0.265p ps=2.06u w=0.5u l=0.28u
X42 a_510_63# a_378_271# w_n310_281# w_n310_281# pfet_03v3 ad=0.65p pd=3.3u as=0.56p ps=3.12u w=1u l=0.28u
X43 a_10363_63# m2_9431_79# w_n310_281# w_n310_281# pfet_03v3 ad=0.715p pd=3.43u as=0.53p ps=3.06u w=1u l=0.28u
X44 a_510_63# a_378_271# via_dev$5$1_9/VSUBS via_dev$5$1_9/VSUBS nfet_03v3 ad=0.315p pd=2.26u as=0.28p ps=2.12u w=0.5u l=0.28u
X45 a_1262_n37# a_160_63# m2_1295_79# via_dev$5$1_9/VSUBS nfet_03v3 ad=0.3625p pd=1.725u as=0.3375p ps=1.675u w=1u l=0.28u
X46 a_1845_n37# a_378_271# via_dev$5$1_9/VSUBS via_dev$5$1_9/VSUBS nfet_03v3 ad=0.42p pd=1.84u as=0.63p ps=3.26u w=1u l=0.28u
X47 m2_6151_79# m2_5700_324# a_6721_407# w_n310_281# pfet_03v3 ad=0.725p pd=2.725u as=1.09p ps=5.09u w=2u l=0.28u
X48 a_6721_407# a_5768_63# w_n310_281# w_n310_281# pfet_03v3 ad=1.3p pd=5.3u as=0.725p ps=2.725u w=2u l=0.28u
X49 a_10363_63# m2_9431_79# via_dev$5$1_9/VSUBS via_dev$5$1_9/VSUBS nfet_03v3 ad=0.3575p pd=2.43u as=0.265p ps=2.06u w=0.5u l=0.28u
X50 a_10906_466# m2_1295_79# a_10906_n37# via_dev$5$1_9/VSUBS nfet_03v3 ad=0.65p pd=3.3u as=0.42p ps=1.84u w=1u l=0.28u
X51 a_8723_63# m2_7791_79# w_n310_281# w_n310_281# pfet_03v3 ad=0.545p pd=3.09u as=0.53p ps=3.06u w=1u l=0.28u
X52 a_11480_63# a_10906_466# w_n310_281# w_n310_281# pfet_03v3 ad=0.65p pd=3.3u as=0.735p ps=2.47u w=1u l=0.28u
X53 a_12559_3# a_11922_3# via_dev$5$1_9/VSUBS via_dev$5$1_9/VSUBS nfet_03v3 ad=0.315p pd=2.26u as=0.325p ps=2.3u w=0.5u l=0.28u
X54 a_7083_63# m2_6151_79# w_n310_281# w_n310_281# pfet_03v3 ad=0.545p pd=3.09u as=0.53p ps=3.06u w=1u l=0.28u
X55 a_7768_n37# m2_5700_324# via_dev$5$1_9/VSUBS via_dev$5$1_9/VSUBS nfet_03v3 ad=0.3625p pd=1.725u as=0.54p ps=3.08u w=1u l=0.28u
X56 a_160_63# m2_24_342# w_n310_281# w_n310_281# pfet_03v3 ad=0.63p pd=3.26u as=0.65p ps=3.3u w=1u l=0.28u
X57 m2_1295_79# a_160_63# a_705_407# w_n310_281# pfet_03v3 ad=0.725p pd=2.725u as=0.675p ps=2.675u w=2u l=0.28u
X58 a_5042_n37# a_3940_63# a_5042_407# via_dev$5$1_9/VSUBS nfet_03v3 ad=0.3625p pd=1.725u as=0.3375p ps=1.675u w=1u l=0.28u
X59 m2_1295_79# m2_24_342# a_870_n37# via_dev$5$1_9/VSUBS nfet_03v3 ad=0.3375p pd=1.675u as=0.3625p ps=1.725u w=1u l=0.28u
X60 a_11922_3# a_2419_63# a_11922_391# w_n310_281# pfet_03v3 ad=1.3p pd=5.3u as=0.725p ps=2.725u w=2u l=0.28u
X61 a_9800_n37# a_7083_63# m2_9431_79# via_dev$5$1_9/VSUBS nfet_03v3 ad=0.3625p pd=1.725u as=0.3375p ps=1.675u w=1u l=0.28u
X62 m2_7791_79# m2_5700_324# a_8361_407# w_n310_281# pfet_03v3 ad=0.725p pd=2.725u as=1.09p ps=5.09u w=2u l=0.28u
X63 a_5042_407# a_3940_63# a_5243_407# w_n310_281# pfet_03v3 ad=0.725p pd=2.725u as=0.675p ps=2.675u w=2u l=0.28u
X64 a_3940_63# m2_1295_79# via_dev$5$1_9/VSUBS via_dev$5$1_9/VSUBS nfet_03v3 ad=0.315p pd=2.26u as=0.325p ps=2.3u w=0.5u l=0.28u
X65 a_8160_n37# a_3498_3# m2_7791_79# via_dev$5$1_9/VSUBS nfet_03v3 ad=0.3625p pd=1.725u as=0.3375p ps=1.675u w=1u l=0.28u
X66 a_705_407# m2_24_342# w_n310_281# w_n310_281# pfet_03v3 ad=0.675p pd=2.675u as=0.725p ps=2.725u w=2u l=0.28u
X67 a_5042_407# m2_1295_79# a_4650_n37# via_dev$5$1_9/VSUBS nfet_03v3 ad=0.3375p pd=1.675u as=0.3625p ps=1.725u w=1u l=0.28u
X68 a_6520_n37# a_5042_407# m2_6151_79# via_dev$5$1_9/VSUBS nfet_03v3 ad=0.3625p pd=1.725u as=0.3375p ps=1.675u w=1u l=0.28u
X69 w_n310_281# a_7083_63# a_9609_407# w_n310_281# pfet_03v3 ad=0.725p pd=2.725u as=0.675p ps=2.675u w=2u l=0.28u
X70 a_2419_63# a_1845_466# w_n310_281# w_n310_281# pfet_03v3 ad=0.65p pd=3.3u as=0.735p ps=2.47u w=1u l=0.28u
X71 m2_9431_79# a_8723_63# a_9408_n37# via_dev$5$1_9/VSUBS nfet_03v3 ad=0.3375p pd=1.675u as=0.3625p ps=1.725u w=1u l=0.28u
X72 w_n310_281# a_3498_3# a_8361_407# w_n310_281# pfet_03v3 ad=0.725p pd=2.725u as=0.675p ps=2.675u w=2u l=0.28u
X73 a_2861_391# m2_1295_79# w_n310_281# w_n310_281# pfet_03v3 ad=0.725p pd=2.725u as=1.3p ps=5.3u w=2u l=0.28u
X74 a_4290_63# a_4158_271# w_n310_281# w_n310_281# pfet_03v3 ad=0.65p pd=3.3u as=0.56p ps=3.12u w=1u l=0.28u
X75 a_5243_407# m2_1295_79# w_n310_281# w_n310_281# pfet_03v3 ad=0.675p pd=2.675u as=0.725p ps=2.725u w=2u l=0.28u
X76 w_n310_281# a_5042_407# a_6721_407# w_n310_281# pfet_03v3 ad=0.725p pd=2.725u as=0.675p ps=2.675u w=2u l=0.28u
X77 a_3498_3# a_2861_3# via_dev$5$1_9/VSUBS via_dev$5$1_9/VSUBS nfet_03v3 ad=0.315p pd=2.26u as=0.325p ps=2.3u w=0.5u l=0.28u
X78 a_9609_407# a_8723_63# m2_9431_79# w_n310_281# pfet_03v3 ad=0.675p pd=2.675u as=0.725p ps=2.725u w=2u l=0.28u
X79 via_dev$5$1_9/VSUBS a_4290_63# a_5042_n37# via_dev$5$1_9/VSUBS nfet_03v3 ad=0.65p pd=3.3u as=0.3625p ps=1.725u w=1u l=0.28u
X80 m2_6151_79# a_2419_63# a_6128_n37# via_dev$5$1_9/VSUBS nfet_03v3 ad=0.3375p pd=1.675u as=0.3625p ps=1.725u w=1u l=0.28u
X81 w_n310_281# m2_24_342# a_1845_466# w_n310_281# pfet_03v3 ad=0.735p pd=2.47u as=0.42p ps=1.84u w=1u l=0.28u
X82 a_870_n37# a_378_271# via_dev$5$1_9/VSUBS via_dev$5$1_9/VSUBS nfet_03v3 ad=0.3625p pd=1.725u as=0.54p ps=3.08u w=1u l=0.28u
X83 a_12559_3# a_11922_3# w_n310_281# w_n310_281# pfet_03v3 ad=0.65p pd=3.3u as=0.675p ps=3.35u w=1u l=0.28u
C0 w_n310_281# a_5042_407# 0.29911f
C1 m2_9431_79# a_8723_63# 0.13485f
C2 m2_1295_79# a_5042_407# 0.03487f
C3 w_n310_281# a_11480_63# 0.37298f
C4 a_11480_63# m2_1295_79# 0.00126f
C5 a_8919_370# a_2419_63# 0.01445f
C6 a_5768_63# a_2419_63# 0.07749f
C7 m2_24_342# a_3498_3# 0
C8 a_11480_63# a_11922_391# 0.00152f
C9 a_10906_466# m2_9431_79# 0.00167f
C10 a_10906_466# a_10906_n37# 0.01333f
C11 m2_24_342# a_160_63# 0.42316f
C12 a_11922_3# a_12559_3# 0.0899f
C13 w_n310_281# a_3940_63# 0.30087f
C14 m2_1295_79# a_3940_63# 0.46061f
C15 w_n310_281# a_12559_3# 0.08598f
C16 a_7410_63# a_7768_n37# 0.00935f
C17 a_11480_63# a_10906_466# 0.1131f
C18 a_5768_63# a_6520_n37# 0.01329f
C19 a_378_271# w_n310_281# 0.6337f
C20 a_378_271# m2_1295_79# 0.02669f
C21 a_9050_63# a_2419_63# 0.00801f
C22 a_1262_n37# a_1845_466# 0
C23 a_4650_n37# a_5042_407# 0.00712f
C24 a_10906_466# a_12559_3# 0
C25 a_510_63# a_1845_n37# 0.0011f
C26 m2_5700_324# a_2419_63# 0.074f
C27 a_4650_n37# a_3940_63# 0.00441f
C28 a_5042_n37# m2_6151_79# 0
C29 a_378_271# m2_24_342# 0.56715f
C30 a_7410_63# a_8160_n37# 0.01329f
C31 a_5042_n37# a_5042_407# 0.01726f
C32 a_8919_370# a_9050_63# 0.10006f
C33 a_510_63# w_n310_281# 0.28255f
C34 a_510_63# m2_1295_79# 0.39896f
C35 a_1845_466# a_705_407# 0.0126f
C36 m2_5700_324# a_8919_370# 0
C37 a_2419_63# m2_7791_79# 0.00843f
C38 m2_5700_324# a_5768_63# 0.16447f
C39 a_2419_63# a_5243_407# 0
C40 a_1845_466# a_3498_3# 0.00105f
C41 a_2419_63# a_9609_407# 0
C42 a_1845_466# a_160_63# 0
C43 a_4290_63# m2_6151_79# 0
C44 a_2419_63# a_4158_271# 0.14782f
C45 a_2861_3# a_5243_407# 0
C46 a_510_63# m2_24_342# 0.13025f
C47 a_4290_63# a_3498_3# 0.00876f
C48 a_2419_63# a_10363_63# 0.00126f
C49 w_n310_281# a_2861_391# 0.03535f
C50 a_2419_63# a_8361_407# 0
C51 a_2861_391# m2_1295_79# 0.00841f
C52 a_2419_63# a_11922_3# 0.16984f
C53 a_2419_63# a_7083_63# 0.01345f
C54 a_7410_63# m2_6151_79# 0
C55 a_6520_n37# a_4158_271# 0.00406f
C56 w_n310_281# a_2419_63# 0.75141f
C57 a_2419_63# m2_1295_79# 0.32461f
C58 a_9050_63# a_9408_n37# 0.00935f
C59 a_7410_63# a_3498_3# 0.11774f
C60 a_870_n37# m2_1295_79# 0.00639f
C61 a_2419_63# a_11922_391# 0.00754f
C62 a_2419_63# a_8723_63# 0.00661f
C63 a_4290_63# a_5042_407# 0.38112f
C64 a_1845_466# a_3940_63# 0
C65 a_6520_n37# a_7083_63# 0.00272f
C66 w_n310_281# a_2861_3# 0.4655f
C67 a_2861_3# m2_1295_79# 0.15381f
C68 a_7410_63# m2_9431_79# 0.00105f
C69 a_8919_370# m2_7791_79# 0.02774f
C70 a_5768_63# m2_7791_79# 0
C71 a_2419_63# a_10906_466# 0.00833f
C72 a_4290_63# a_3940_63# 0.28903f
C73 a_378_271# a_1845_466# 0.01278f
C74 a_5768_63# a_5243_407# 0.00722f
C75 a_7410_63# a_5042_407# 0
C76 a_7768_n37# m2_9431_79# 0
C77 a_8919_370# a_9609_407# 0.02942f
C78 m2_24_342# a_2419_63# 0.00234f
C79 a_8919_370# a_4158_271# 0.001f
C80 a_5768_63# a_4158_271# 0.00573f
C81 a_8919_370# a_10363_63# 0
C82 a_8919_370# a_8361_407# 0
C83 a_1262_n37# a_705_407# 0
C84 a_9050_63# m2_7791_79# 0.00127f
C85 a_8919_370# a_7083_63# 0.01057f
C86 a_9050_63# a_9800_n37# 0.01329f
C87 a_5768_63# a_7083_63# 0.01494f
C88 w_n310_281# a_8919_370# 0.50001f
C89 a_8919_370# m2_1295_79# 0.01372f
C90 w_n310_281# a_5768_63# 0.31314f
C91 a_5768_63# m2_1295_79# 0.00766f
C92 a_8919_370# a_8723_63# 0.12581f
C93 a_9050_63# a_9609_407# 0.1261f
C94 m2_5700_324# m2_7791_79# 0.05245f
C95 a_9050_63# a_4158_271# 0.00717f
C96 m2_5700_324# a_5243_407# 0.01927f
C97 a_9408_n37# m2_7791_79# 0
C98 a_8160_n37# m2_9431_79# 0
C99 a_9050_63# a_10363_63# 0.01385f
C100 a_9050_63# a_8361_407# 0
C101 a_9050_63# a_7083_63# 0.21474f
C102 m2_5700_324# a_4158_271# 0.00861f
C103 w_n310_281# a_9050_63# 0.28931f
C104 a_9050_63# m2_1295_79# 0.00716f
C105 a_9408_n37# a_9609_407# 0
C106 a_510_63# a_1845_466# 0.01433f
C107 m2_5700_324# a_8361_407# 0.05956f
C108 a_9050_63# a_8723_63# 0.53121f
C109 m2_5700_324# a_7083_63# 0.12051f
C110 m2_5700_324# w_n310_281# 1.65678f
C111 m2_5700_324# m2_1295_79# 0.07849f
C112 a_9408_n37# a_7083_63# 0.00336f
C113 m2_5700_324# a_8723_63# 0
C114 a_705_407# a_160_63# 0.06737f
C115 a_9609_407# m2_7791_79# 0
C116 a_3498_3# m2_6151_79# 0
C117 m2_7791_79# a_4158_271# 0
C118 a_9800_n37# a_4158_271# 0.00497f
C119 a_1845_466# a_2419_63# 0.10509f
C120 w_n310_281# a_1845_n37# 0
C121 a_1845_n37# m2_1295_79# 0.00942f
C122 a_5243_407# a_4158_271# 0.02964f
C123 a_6721_407# m2_6151_79# 0.4935f
C124 a_870_n37# a_1845_466# 0
C125 a_8361_407# m2_7791_79# 0.49779f
C126 a_3498_3# a_6721_407# 0
C127 m2_7791_79# a_7083_63# 0.14708f
C128 a_9609_407# a_4158_271# 0
C129 a_2419_63# a_4290_63# 0.00652f
C130 a_9800_n37# a_7083_63# 0.00527f
C131 a_3498_3# m2_9431_79# 0
C132 a_1845_466# a_2861_3# 0
C133 w_n310_281# m2_7791_79# 0.45139f
C134 a_5042_407# m2_6151_79# 0.20459f
C135 m2_1295_79# m2_7791_79# 0.05731f
C136 a_10363_63# a_9609_407# 0.01306f
C137 w_n310_281# a_5243_407# 0.78984f
C138 a_8361_407# a_9609_407# 0.00466f
C139 a_5243_407# m2_1295_79# 0.10989f
C140 a_3498_3# a_5042_407# 0.02015f
C141 a_10363_63# a_4158_271# 0.02222f
C142 m2_7791_79# a_8723_63# 0.08396f
C143 a_9609_407# a_7083_63# 0.0285f
C144 a_2861_3# a_4290_63# 0
C145 a_11922_3# a_4158_271# 0.0013f
C146 a_7410_63# a_2419_63# 0.00801f
C147 w_n310_281# a_9609_407# 0.7653f
C148 a_7083_63# a_4158_271# 1.09132f
C149 a_5042_407# a_6721_407# 0.03265f
C150 m2_1295_79# a_9609_407# 0.0093f
C151 w_n310_281# a_4158_271# 0.66883f
C152 m2_1295_79# a_4158_271# 0.16058f
C153 a_378_271# a_705_407# 0.02817f
C154 a_3498_3# a_3940_63# 0.04602f
C155 a_10363_63# a_7083_63# 0.00582f
C156 a_11480_63# m2_9431_79# 0
C157 a_510_63# a_1262_n37# 0.00898f
C158 a_8361_407# a_7083_63# 0.01453f
C159 a_9609_407# a_8723_63# 0.0593f
C160 w_n310_281# a_10363_63# 0.15741f
C161 a_10363_63# m2_1295_79# 0.00179f
C162 a_8723_63# a_4158_271# 0
C163 w_n310_281# a_8361_407# 0.75753f
C164 w_n310_281# a_11922_3# 0.46598f
C165 m2_1295_79# a_8361_407# 0.02509f
C166 a_11922_3# m2_1295_79# 0
C167 w_n310_281# a_7083_63# 0.31663f
C168 m2_1295_79# a_7083_63# 0.01071f
C169 a_10363_63# a_8723_63# 0
C170 a_10906_466# a_9609_407# 0
C171 a_11922_391# a_11922_3# 0.01891f
C172 a_8361_407# a_8723_63# 0.01268f
C173 w_n310_281# m2_1295_79# 2.35219f
C174 a_378_271# a_160_63# 0.09182f
C175 a_10906_466# a_4158_271# 0.03873f
C176 a_8723_63# a_7083_63# 0.15796f
C177 w_n310_281# a_11922_391# 0.03535f
C178 a_3940_63# a_5042_407# 0.0941f
C179 w_n310_281# a_8723_63# 0.33581f
C180 a_10363_63# a_10906_466# 0.02047f
C181 m2_1295_79# a_8723_63# 0.00803f
C182 a_10906_466# a_11922_3# 0
C183 a_5768_63# a_4290_63# 0.01093f
C184 a_10906_466# a_7083_63# 0
C185 a_4650_n37# a_4158_271# 0.00383f
C186 w_n310_281# a_10906_466# 0.44509f
C187 a_10906_466# m2_1295_79# 0.0692f
C188 a_7410_63# a_8919_370# 0
C189 w_n310_281# m2_24_342# 0.66878f
C190 m2_24_342# m2_1295_79# 0.04399f
C191 a_510_63# a_705_407# 0.13828f
C192 a_5042_n37# a_5243_407# 0
C193 m2_5700_324# a_4290_63# 0.01531f
C194 a_5042_n37# a_4158_271# 0
C195 a_510_63# a_160_63# 0.28903f
C196 m2_5700_324# a_7410_63# 0.14432f
C197 a_6128_n37# m2_6151_79# 0.01733f
C198 a_1845_n37# a_1845_466# 0.01333f
C199 a_2861_391# a_705_407# 0
C200 a_6128_n37# a_6721_407# 0
C201 a_2419_63# a_705_407# 0
C202 a_2861_391# a_3498_3# 0.00454f
C203 a_6128_n37# a_5042_407# 0.00376f
C204 a_2419_63# m2_6151_79# 0.05852f
C205 a_2861_3# a_705_407# 0
C206 a_2419_63# a_3498_3# 0.01177f
C207 a_510_63# a_378_271# 0.14298f
C208 a_4290_63# a_5243_407# 0.14023f
C209 a_2419_63# a_6721_407# 0.01825f
C210 a_870_n37# a_160_63# 0.00441f
C211 a_6520_n37# m2_6151_79# 0.00766f
C212 a_2419_63# m2_9431_79# 0.00832f
C213 a_2861_3# a_3498_3# 0.09846f
C214 a_7410_63# m2_7791_79# 0.36168f
C215 a_4290_63# a_4158_271# 0.11363f
C216 a_2419_63# a_5042_407# 0.08051f
C217 a_2419_63# a_11480_63# 0.0769f
C218 w_n310_281# a_1845_466# 0.44517f
C219 a_1845_466# m2_1295_79# 0.09644f
C220 a_7768_n37# m2_7791_79# 0.01733f
C221 a_2419_63# a_3940_63# 0.00879f
C222 a_2861_3# a_5042_407# 0
C223 a_7410_63# a_4158_271# 0
C224 a_6520_n37# a_5042_407# 0.00483f
C225 w_n310_281# a_4290_63# 0.2819f
C226 a_4290_63# m2_1295_79# 0.13519f
C227 a_2419_63# a_12559_3# 0
C228 a_7410_63# a_8361_407# 0.1423f
C229 a_2861_3# a_3940_63# 0
C230 a_5768_63# m2_6151_79# 0.35511f
C231 a_7410_63# a_7083_63# 0.07718f
C232 a_5768_63# a_3498_3# 0
C233 w_n310_281# a_7410_63# 0.31086f
C234 a_7410_63# m2_1295_79# 0.07614f
C235 a_7768_n37# a_8361_407# 0
C236 m2_24_342# a_1845_466# 0.06999f
C237 a_7768_n37# a_7083_63# 0.0028f
C238 a_5768_63# a_6721_407# 0.14017f
C239 a_7410_63# a_8723_63# 0.01398f
C240 a_8919_370# m2_9431_79# 0.03216f
C241 a_8160_n37# m2_7791_79# 0.01048f
C242 a_5768_63# a_5042_407# 0.22596f
C243 a_4290_63# a_4650_n37# 0.01502f
C244 a_5768_63# a_3940_63# 0
C245 m2_5700_324# m2_6151_79# 0.14941f
C246 a_9050_63# m2_9431_79# 0.328f
C247 m2_5700_324# a_3498_3# 0.55174f
C248 m2_5700_324# a_6721_407# 0.50857f
C249 a_8160_n37# a_7083_63# 0.00507f
C250 a_1262_n37# m2_1295_79# 0.01607f
C251 a_510_63# a_870_n37# 0.01502f
C252 m2_5700_324# a_5042_407# 0.06917f
C253 a_9408_n37# m2_9431_79# 0.01733f
C254 a_4290_63# a_5042_n37# 0.00898f
C255 m2_5700_324# a_3940_63# 0.00132f
C256 m2_6151_79# m2_7791_79# 0.00114f
C257 a_3498_3# m2_7791_79# 0.0296f
C258 a_2861_391# a_2419_63# 0.0163f
C259 a_3498_3# a_5243_407# 0.16427f
C260 m2_6151_79# a_4158_271# 0.04334f
C261 m2_7791_79# m2_9431_79# 0.01571f
C262 a_9800_n37# m2_9431_79# 0.0074f
C263 a_2861_391# a_2861_3# 0.01616f
C264 a_3498_3# a_4158_271# 0.00829f
C265 w_n310_281# a_705_407# 0.79414f
C266 a_5042_407# m2_7791_79# 0.00555f
C267 a_2861_3# a_2419_63# 0.21478f
C268 a_705_407# m2_1295_79# 0.30816f
C269 m2_6151_79# a_7083_63# 0.08089f
C270 a_9609_407# m2_9431_79# 0.49779f
C271 a_5243_407# a_5042_407# 0.29512f
C272 a_3498_3# a_8361_407# 0.12093f
C273 w_n310_281# m2_6151_79# 0.44301f
C274 m2_9431_79# a_4158_271# 0.05572f
C275 a_10906_n37# a_4158_271# 0.00824f
C276 m2_1295_79# m2_6151_79# 0.00667f
C277 a_3498_3# a_7083_63# 0.01356f
C278 a_5768_63# a_6128_n37# 0.00935f
C279 w_n310_281# a_3498_3# 1.03377f
C280 a_3498_3# m2_1295_79# 0.3391f
C281 a_10363_63# m2_9431_79# 0.07766f
C282 a_11480_63# a_9609_407# 0
C283 a_10363_63# a_10906_n37# 0
C284 a_5042_407# a_4158_271# 0.63867f
C285 a_8361_407# m2_9431_79# 0
C286 w_n310_281# a_160_63# 0.30515f
C287 a_6721_407# a_7083_63# 0.01268f
C288 a_160_63# m2_1295_79# 0.09339f
C289 a_5243_407# a_3940_63# 0.06737f
C290 a_11480_63# a_4158_271# 0.00295f
C291 m2_9431_79# a_7083_63# 0.19293f
C292 w_n310_281# a_6721_407# 0.72579f
C293 a_3498_3# a_8723_63# 0.00575f
C294 m2_1295_79# a_6721_407# 0.00452f
C295 w_n310_281# m2_9431_79# 0.46254f
C296 a_10363_63# a_11480_63# 0
C297 w_n310_281# a_10906_n37# 0
C298 m2_1295_79# m2_9431_79# 0.0078f
C299 a_11480_63# a_11922_3# 0.04054f
C300 m2_24_342# a_705_407# 0.10607f
C301 a_3940_63# a_4158_271# 0.16366f
C302 a_5042_407# a_7083_63# 0.02611f
C303 a_4158_271# via_dev$5$1_9/VSUBS 2.63898f
C304 a_7083_63# via_dev$5$1_9/VSUBS 0.86585f
C305 a_8723_63# via_dev$5$1_9/VSUBS 0.41121f
C306 m2_9431_79# via_dev$5$1_9/VSUBS 0.75255f
C307 m2_7791_79# via_dev$5$1_9/VSUBS 0.74612f
C308 a_9609_407# via_dev$5$1_9/VSUBS 0.11967f
C309 a_8361_407# via_dev$5$1_9/VSUBS 0.05216f
C310 m2_6151_79# via_dev$5$1_9/VSUBS 0.72815f
C311 a_6721_407# via_dev$5$1_9/VSUBS 0.01698f
C312 a_5042_407# via_dev$5$1_9/VSUBS 0.88916f
C313 a_3940_63# via_dev$5$1_9/VSUBS 0.46864f
C314 m2_1295_79# via_dev$5$1_9/VSUBS 3.37184f
C315 a_160_63# via_dev$5$1_9/VSUBS 0.5921f
C316 a_5243_407# via_dev$5$1_9/VSUBS 0.01661f
C317 a_705_407# via_dev$5$1_9/VSUBS 0.13677f
C318 a_3498_3# via_dev$5$1_9/VSUBS 1.27724f
C319 a_10906_n37# via_dev$5$1_9/VSUBS 0.02232f
C320 a_9800_n37# via_dev$5$1_9/VSUBS 0.01742f
C321 a_9408_n37# via_dev$5$1_9/VSUBS 0.007f
C322 a_8160_n37# via_dev$5$1_9/VSUBS 0.01743f
C323 a_7768_n37# via_dev$5$1_9/VSUBS 0.007f
C324 a_6520_n37# via_dev$5$1_9/VSUBS 0.01743f
C325 a_6128_n37# via_dev$5$1_9/VSUBS 0.007f
C326 a_5042_n37# via_dev$5$1_9/VSUBS 0.00833f
C327 a_4650_n37# via_dev$5$1_9/VSUBS 0.01565f
C328 a_12559_3# via_dev$5$1_9/VSUBS 0.19481f
C329 a_11922_3# via_dev$5$1_9/VSUBS 0.64569f
C330 a_11922_391# via_dev$5$1_9/VSUBS 0.00119f
C331 a_10906_466# via_dev$5$1_9/VSUBS 0.59796f
C332 a_11480_63# via_dev$5$1_9/VSUBS 0.42359f
C333 a_10363_63# via_dev$5$1_9/VSUBS 0.13924f
C334 a_9050_63# via_dev$5$1_9/VSUBS 0.53264f
C335 a_8919_370# via_dev$5$1_9/VSUBS 0.51824f
C336 a_7410_63# via_dev$5$1_9/VSUBS 0.53731f
C337 a_5768_63# via_dev$5$1_9/VSUBS 0.54f
C338 a_1845_n37# via_dev$5$1_9/VSUBS 0.01974f
C339 a_1262_n37# via_dev$5$1_9/VSUBS 0.0069f
C340 a_870_n37# via_dev$5$1_9/VSUBS 0.01517f
C341 a_4290_63# via_dev$5$1_9/VSUBS 0.57048f
C342 a_2861_3# via_dev$5$1_9/VSUBS 0.62907f
C343 a_1845_466# via_dev$5$1_9/VSUBS 0.59853f
C344 a_2419_63# via_dev$5$1_9/VSUBS 6.64124f
C345 a_510_63# via_dev$5$1_9/VSUBS 0.55998f
C346 a_378_271# via_dev$5$1_9/VSUBS 1.37769f
C347 w_n310_281# via_dev$5$1_9/VSUBS 27.06296f
C348 m2_24_342# via_dev$5$1_9/VSUBS 1.98211f
C349 m2_5700_324# via_dev$5$1_9/VSUBS 1.14834f
.ends

.subckt x4bitblock 1bitblock$2_0/a_9609_407# 1bitblock$3_0/a_8361_407# 1bitblock$2_0/a_8160_n37#
+ 1bitblock$2_0/a_5042_407# 1bitblock_0/m2_6151_79# 1bitblock$2_0/m2_9431_79# 1bitblock$2_0/a_4290_63#
+ 1bitblock$2_0/a_4650_n37# 1bitblock$3_0/a_8723_63# 1bitblock$3_0/a_510_63# 1bitblock_0/a_2419_63#
+ 1bitblock$3_0/a_378_271# 1bitblock_0/a_5042_n37# 1bitblock$2_0/a_7410_63# 1bitblock$3_0/a_1845_466#
+ MUX21_0/a_157_63# 1bitblock$2_0/a_5243_407# 1bitblock$1_0/a_3940_63# 1bitblock_0/a_5042_407#
+ 1bitblock_0/a_8160_n37# 1bitblock$2_0/a_7768_n37# 1bitblock$2_0/a_10906_466# 1bitblock$3_0/a_6721_407#
+ 1bitblock_0/m2_9431_79# 1bitblock$3_0/a_11480_63# 1bitblock_0/a_4650_n37# 1bitblock$2_0/m2_7791_79#
+ m2_10721_n3315# 1bitblock$3_0/a_3498_3# 1bitblock_0/a_3940_63# 1bitblock$1_0/a_7083_63#
+ 1bitblock$1_0/a_4290_63# 1bitblock$3_0/m2_6151_79# 1bitblock$2_0/a_10363_63# 1bitblock$1_0/a_8361_407#
+ 1bitblock$2_0/a_8723_63# 1bitblock_0/a_7768_n37# 1bitblock$2_0/a_378_271# MUX21_0/a_718_407#
+ m2_14516_n651# 1bitblock$1_0/a_7410_63# 1bitblock$2_0/a_3498_3# 1bitblock$2_0/a_7083_63#
+ MUX21_0/m2_540_79# 1bitblock$3_0/a_5042_n37# 1bitblock_0/m2_7791_79# 1bitblock_0/a_4290_63#
+ 1bitblock$2_0/m2_24_342# 1bitblock_0/a_7083_63# 1bitblock$3_0/a_9609_407# 1bitblock$3_0/a_5768_63#
+ 1bitblock$3_0/a_8160_n37# 1bitblock$3_0/a_5042_407# 1bitblock_0/a_10363_63# m1_8729_n3942#
+ 1bitblock$3_0/m2_9431_79# 1bitblock_0/a_7410_63# 1bitblock$3_0/a_10906_466# 1bitblock$3_0/a_4650_n37#
+ 1bitblock$3_0/a_160_63# 1bitblock$1_0/a_8723_63# 1bitblock$1_0/a_378_271# 1bitblock$1_0/a_3498_3#
+ 1bitblock$3_0/a_5243_407# m2_1701_n784# 1bitblock$1_0/m2_6151_79# 1bitblock$3_0/a_7768_n37#
+ 1bitblock$3_0/a_11922_3# 1bitblock$3_0/a_2419_63# 1bitblock$2_0/a_5768_63# 1bitblock_0/a_8723_63#
+ 1bitblock$3_0/m2_7791_79# 1bitblock_0/a_378_271# 1bitblock$1_0/a_5042_n37# 1bitblock_0/m2_24_342#
+ 1bitblock$3_0/a_10363_63# 1bitblock$1_0/a_9609_407# 1bitblock$2_0/a_8361_407# 1bitblock$1_0/a_8160_n37#
+ 1bitblock$1_0/a_5042_407# 1bitblock$3_0/a_9050_63# 1bitblock$1_0/m2_9431_79# AND4_0/a_518_229#
+ 1bitblock$1_0/a_4650_n37# m1_14167_n1145# AND4_0/a_704_n441# m1_12486_242# 1bitblock$3_0/a_3940_63#
+ 1bitblock$2_0/a_11922_3# 1bitblock$1_0/a_5243_407# 1bitblock_0/a_8361_407# 1bitblock$2_0/a_2419_63#
+ 1bitblock$1_0/a_5768_63# 1bitblock$1_0/a_7768_n37# m1_12484_n953# m2_5443_n3913#
+ 1bitblock$3_0/a_4290_63# 1bitblock$1_0/m2_7791_79# 1bitblock$3_0/a_7083_63# 1bitblock$1_0/m2_24_342#
+ 1bitblock$3_0/m2_24_342# 1bitblock$3_0/a_705_407# m2_2396_n2595# 1bitblock_0/a_5768_63#
+ 1bitblock$1_0/a_10363_63# 1bitblock$2_0/m2_6151_79# 1bitblock$1_0/a_10906_466# m1_12480_n3815#
+ 1bitblock$3_0/a_2861_3# 1bitblock_0/a_3498_3# MUX21_0/a_1472_63# 1bitblock$3_0/a_7410_63#
+ 1bitblock$2_0/a_3940_63# m1_n563_n5091# m1_15541_n412# 1bitblock$1_0/a_11922_3#
+ AND4_0/a_912_n441# m1_13543_n1146# 1bitblock$1_0/a_2419_63# 1bitblock$2_0/a_5042_n37#
+ VSUBS
XMUX21_0 MUX21_0/a_1472_63# MUX21_0/a_157_63# m2_14516_n651# MUX21_0/a_909_n37# m1_15541_n412#
+ MUX21_0/a_517_n37# MUX21_0/a_718_407# MUX21_0/m2_540_79# VSUBS m1_12480_n3815# m1_n563_n5091#
+ MUX21
X1bitblock$2_0 1bitblock$2_0/a_2861_3# 1bitblock$2_0/a_8361_407# 1bitblock$2_0/a_6520_n37#
+ 1bitblock$2_0/a_1262_n37# 1bitblock$2_0/a_2861_391# 1bitblock$2_0/a_1845_466# 1bitblock$2_0/a_10906_n37#
+ 1bitblock$2_0/a_510_63# 1bitblock$2_0/a_870_n37# 1bitblock$2_0/a_6721_407# 1bitblock$2_0/a_9800_n37#
+ 1bitblock$2_0/a_11480_63# 1bitblock$2_0/a_6128_n37# 1bitblock$2_0/a_5768_63# m1_8729_n3942#
+ 1bitblock$2_0/m2_6151_79# 1bitblock$2_0/a_11922_391# 1bitblock$2_0/a_5042_n37# 1bitblock$2_0/a_9408_n37#
+ 1bitblock$2_0/a_9609_407# 1bitblock$2_0/a_5042_407# 1bitblock$2_0/a_8160_n37# m1_12484_n953#
+ 1bitblock$2_0/a_11922_3# 1bitblock$2_0/a_2419_63# 1bitblock$2_0/m2_9431_79# 1bitblock$2_0/a_10906_466#
+ 1bitblock$2_0/a_4650_n37# 1bitblock$2_0/a_9050_63# 1bitblock$2_0/a_5243_407# 1bitblock$2_0/a_7768_n37#
+ 1bitblock$2_0/a_3940_63# 1bitblock$2_0/m2_7791_79# 1bitblock$2_0/a_10363_63# 1bitblock$2_0/a_160_63#
+ 1bitblock$2_0/a_4290_63# 1bitblock$2_0/a_7083_63# 1bitblock$2_0/a_705_407# m2_10721_n3315#
+ 1bitblock$2_0/a_7410_63# m2_5443_n3913# 1bitblock$2_0/a_1845_n37# VSUBS m2_2396_n2595#
+ 1bitblock$2_0/a_8723_63# 1bitblock$2_0/a_378_271# 1bitblock$2_0/a_3498_3# m1_n563_n5091#
+ 1bitblock$2_0/m2_24_342# x1bitblock$2
XAND4_0 m1_n563_n5091# m2_2396_n2595# VSUBS m1_13543_n1146# m2_14516_n651# m2_1701_n784#
+ AND4_0/a_704_n441# m1_14167_n1145# AND4_0/a_912_n441# AND4_0/a_518_229# AND4_0/a_1120_n441#
+ AND4
X1bitblock$3_0 1bitblock$3_0/a_2861_3# 1bitblock$3_0/a_8361_407# 1bitblock$3_0/a_6520_n37#
+ 1bitblock$3_0/a_1262_n37# 1bitblock$3_0/a_2861_391# 1bitblock$3_0/a_1845_466# 1bitblock$3_0/a_10906_n37#
+ 1bitblock$3_0/a_510_63# 1bitblock$3_0/a_870_n37# 1bitblock$3_0/a_6721_407# 1bitblock$3_0/a_9800_n37#
+ 1bitblock$3_0/a_11480_63# 1bitblock$3_0/a_6128_n37# 1bitblock$3_0/a_5768_63# 1bitblock$3_0/m2_6151_79#
+ 1bitblock$3_0/a_11922_391# 1bitblock$3_0/a_5042_n37# 1bitblock$3_0/a_9408_n37# 1bitblock$3_0/a_9609_407#
+ 1bitblock$3_0/a_5042_407# 1bitblock$3_0/a_8160_n37# m2_10721_n3315# 1bitblock$3_0/a_11922_3#
+ m1_8729_n3942# 1bitblock$3_0/a_2419_63# 1bitblock$3_0/m2_9431_79# 1bitblock$3_0/a_10906_466#
+ 1bitblock$3_0/a_4650_n37# 1bitblock$3_0/a_9050_63# 1bitblock$3_0/a_5243_407# 1bitblock$3_0/a_7768_n37#
+ 1bitblock$3_0/a_3940_63# 1bitblock$3_0/m2_7791_79# 1bitblock$3_0/a_10363_63# 1bitblock$3_0/a_160_63#
+ 1bitblock$3_0/a_4290_63# 1bitblock$3_0/a_7083_63# 1bitblock$3_0/a_705_407# m1_12480_n3815#
+ 1bitblock$3_0/a_7410_63# 1bitblock$3_0/a_1845_n37# m2_5443_n3913# VSUBS 1bitblock$3_0/a_3498_3#
+ m1_13543_n1146# 1bitblock$3_0/a_8723_63# 1bitblock$3_0/a_378_271# m1_n563_n5091#
+ 1bitblock$3_0/m2_24_342# x1bitblock$3
X1bitblock_0 1bitblock_0/a_2861_3# 1bitblock_0/a_8361_407# 1bitblock_0/a_6520_n37#
+ 1bitblock_0/a_1262_n37# 1bitblock_0/a_2861_391# 1bitblock_0/a_1845_466# 1bitblock_0/a_10906_n37#
+ 1bitblock_0/a_510_63# 1bitblock_0/a_870_n37# 1bitblock_0/a_9800_n37# 1bitblock_0/a_11480_63#
+ 1bitblock_0/a_6128_n37# 1bitblock_0/a_5768_63# 1bitblock_0/m2_6151_79# 1bitblock_0/a_11922_391#
+ 1bitblock_0/a_5042_n37# 1bitblock_0/a_9408_n37# m1_8729_n3942# 1bitblock_0/a_9609_407#
+ 1bitblock_0/a_5042_407# 1bitblock_0/a_8160_n37# m1_15541_n412# 1bitblock_0/a_11922_3#
+ 1bitblock_0/a_2419_63# 1bitblock_0/m2_9431_79# 1bitblock_0/a_10906_466# 1bitblock_0/a_4650_n37#
+ 1bitblock_0/a_9050_63# 1bitblock_0/a_7768_n37# 1bitblock_0/a_3940_63# 1bitblock_0/m2_7791_79#
+ 1bitblock_0/a_10363_63# 1bitblock_0/a_160_63# 1bitblock_0/a_4290_63# 1bitblock_0/a_7083_63#
+ 1bitblock_0/a_705_407# m1_12486_242# 1bitblock_0/a_7410_63# 1bitblock_0/a_1845_n37#
+ VSUBS m1_14167_n1145# 1bitblock_0/a_8723_63# 1bitblock_0/a_378_271# 1bitblock_0/a_3498_3#
+ m2_5443_n3913# m1_n563_n5091# 1bitblock_0/m2_24_342# x1bitblock
X1bitblock$1_0 1bitblock$1_0/a_2861_3# 1bitblock$1_0/a_8361_407# 1bitblock$1_0/a_6520_n37#
+ 1bitblock$1_0/a_1262_n37# 1bitblock$1_0/a_2861_391# 1bitblock$1_0/a_1845_466# 1bitblock$1_0/a_10906_n37#
+ 1bitblock$1_0/a_510_63# 1bitblock$1_0/a_870_n37# 1bitblock$1_0/a_6721_407# 1bitblock$1_0/a_9800_n37#
+ 1bitblock$1_0/m2_24_342# 1bitblock$1_0/a_11480_63# 1bitblock$1_0/a_6128_n37# 1bitblock$1_0/a_5768_63#
+ 1bitblock$1_0/m2_6151_79# 1bitblock$1_0/a_3498_3# 1bitblock$1_0/a_11922_391# 1bitblock$1_0/a_5042_n37#
+ 1bitblock$1_0/a_9408_n37# 1bitblock$1_0/a_9609_407# 1bitblock$1_0/a_5042_407# 1bitblock$1_0/a_8160_n37#
+ m1_12486_242# 1bitblock$1_0/a_11922_3# 1bitblock$1_0/a_2419_63# 1bitblock$1_0/m2_9431_79#
+ 1bitblock$1_0/a_10906_466# 1bitblock$1_0/a_4650_n37# 1bitblock$1_0/a_9050_63# 1bitblock$1_0/a_5243_407#
+ 1bitblock$1_0/a_7768_n37# 1bitblock$1_0/a_160_63# 1bitblock$1_0/a_3940_63# m1_8729_n3942#
+ 1bitblock$1_0/m2_7791_79# 1bitblock$1_0/a_10363_63# 1bitblock$1_0/a_4290_63# 1bitblock$1_0/a_7083_63#
+ 1bitblock$1_0/a_705_407# m1_12484_n953# 1bitblock$1_0/a_7410_63# m2_5443_n3913#
+ 1bitblock$1_0/a_1845_n37# VSUBS m2_1701_n784# 1bitblock$1_0/a_8723_63# 1bitblock$1_0/a_378_271#
+ m1_n563_n5091# x1bitblock$1
C0 1bitblock$1_0/a_1845_466# m2_1701_n784# 0.01233f
C1 1bitblock$2_0/m2_24_342# 1bitblock$1_0/m2_24_342# 0.0286f
C2 1bitblock$2_0/a_2419_63# m2_5443_n3913# 0.00972f
C3 1bitblock$1_0/a_10906_466# m1_12486_242# 0.0161f
C4 m2_5443_n3913# 1bitblock$3_0/a_5042_n37# 0
C5 MUX21_0/a_718_407# m1_14167_n1145# 0
C6 1bitblock$3_0/a_2861_3# 1bitblock$3_0/a_705_407# -0
C7 1bitblock$3_0/a_11922_3# m1_12480_n3815# 0.00447f
C8 m2_1701_n784# 1bitblock$1_0/a_8723_63# -0
C9 m1_13543_n1146# 1bitblock$3_0/a_3940_63# 0
C10 1bitblock$2_0/a_5042_407# m2_5443_n3913# 0.06277f
C11 m1_14167_n1145# 1bitblock$1_0/a_378_271# 0.00256f
C12 1bitblock_0/a_378_271# m2_1701_n784# 0.00257f
C13 1bitblock$2_0/a_705_407# 1bitblock$1_0/a_510_63# 0
C14 m1_8729_n3942# 1bitblock$3_0/a_9408_n37# 0
C15 1bitblock_0/a_9050_63# m2_1701_n784# 0
C16 m1_12480_n3815# m1_13543_n1146# 0.07257f
C17 1bitblock_0/m2_24_342# m1_n563_n5091# 0.01777f
C18 1bitblock$3_0/a_2861_3# 1bitblock$3_0/a_3498_3# -0
C19 1bitblock$2_0/a_378_271# 1bitblock$1_0/a_510_63# 0
C20 1bitblock_0/a_870_n37# 1bitblock$1_0/a_160_63# 0.00138f
C21 1bitblock_0/a_160_63# 1bitblock$1_0/a_870_n37# 0.00138f
C22 1bitblock$1_0/a_10906_466# m2_1701_n784# 0
C23 1bitblock$2_0/a_378_271# 1bitblock$3_0/a_705_407# 0
C24 1bitblock$3_0/a_2861_391# m1_13543_n1146# 0.01584f
C25 1bitblock$2_0/a_510_63# m1_n563_n5091# 0
C26 1bitblock$2_0/a_3940_63# m2_5443_n3913# 0.00421f
C27 1bitblock$2_0/a_5768_63# m2_5443_n3913# 0.01877f
C28 MUX21_0/a_517_n37# m1_15541_n412# 0
C29 1bitblock$2_0/a_1262_n37# 1bitblock$3_0/a_705_407# 0
C30 AND4_0/a_518_229# 1bitblock$1_0/a_11922_3# 0.0046f
C31 m1_13543_n1146# m1_15541_n412# 0
C32 1bitblock$2_0/a_705_407# 1bitblock$3_0/a_160_63# 0
C33 1bitblock$2_0/a_160_63# 1bitblock$3_0/a_705_407# 0
C34 MUX21_0/a_157_63# m1_15541_n412# 0
C35 MUX21_0/a_718_407# m1_n563_n5091# 0.0018f
C36 m1_8729_n3942# 1bitblock_0/a_8160_n37# 0.00164f
C37 AND4_0/a_518_229# m2_1701_n784# 0.02153f
C38 1bitblock$2_0/a_378_271# 1bitblock$3_0/a_160_63# 0.00362f
C39 m1_n563_n5091# 1bitblock$1_0/a_378_271# 0.00489f
C40 1bitblock$2_0/a_7768_n37# m1_8729_n3942# 0
C41 1bitblock$2_0/a_510_63# m2_2396_n2595# 0.00105f
C42 m1_n563_n5091# 1bitblock$3_0/m2_7791_79# -0
C43 m1_n563_n5091# 1bitblock$1_0/a_9050_63# 0
C44 m2_5443_n3913# 1bitblock$1_0/a_5768_63# 0.01876f
C45 1bitblock$1_0/a_2861_3# m2_1701_n784# 0
C46 1bitblock_0/a_1262_n37# 1bitblock$1_0/a_705_407# 0
C47 1bitblock_0/a_705_407# 1bitblock$1_0/a_1262_n37# 0
C48 1bitblock_0/m2_7791_79# 1bitblock_0/m2_9431_79# -0.00444f
C49 MUX21_0/a_517_n37# m1_14167_n1145# 0
C50 1bitblock$2_0/a_2861_3# m1_13543_n1146# 0.00145f
C51 m2_5443_n3913# 1bitblock$1_0/a_5243_407# 0.01246f
C52 1bitblock$2_0/a_160_63# 1bitblock$3_0/a_160_63# 0.0454f
C53 MUX21_0/a_718_407# m2_2396_n2595# 0.00276f
C54 MUX21_0/a_157_63# m1_14167_n1145# 0.0056f
C55 1bitblock_0/a_2419_63# m1_15541_n412# 0.07066f
C56 m2_2396_n2595# 1bitblock$1_0/a_378_271# 0
C57 m1_8729_n3942# 1bitblock$3_0/m2_7791_79# 0.01998f
C58 1bitblock$3_0/a_7410_63# 1bitblock$3_0/m2_9431_79# -0
C59 m1_12484_n953# m2_10721_n3315# 2.41735f
C60 m1_8729_n3942# 1bitblock$1_0/a_9050_63# 0.02224f
C61 1bitblock_0/a_705_407# m1_14167_n1145# 0.00558f
C62 m1_8729_n3942# 1bitblock$3_0/a_9800_n37# 0.0014f
C63 1bitblock$2_0/a_2419_63# 1bitblock$3_0/a_2419_63# 1.31417f
C64 m2_2396_n2595# 1bitblock$1_0/a_9050_63# 0.00507f
C65 1bitblock_0/m2_24_342# 1bitblock$1_0/a_705_407# 0
C66 m1_n563_n5091# m2_10721_n3315# 0.0925f
C67 m2_5443_n3913# m1_12486_242# 0.0535f
C68 1bitblock$2_0/m2_24_342# 1bitblock$1_0/a_378_271# 0
C69 1bitblock$1_0/a_4290_63# m2_1701_n784# 0
C70 1bitblock$2_0/a_510_63# 1bitblock$1_0/a_705_407# 0
C71 1bitblock_0/a_10906_n37# m1_15541_n412# 0.00266f
C72 m1_12484_n953# 1bitblock$3_0/a_11922_3# 0
C73 1bitblock$2_0/a_11922_3# m2_10721_n3315# 0.00359f
C74 m1_8729_n3942# 1bitblock$3_0/a_9609_407# 0.00145f
C75 m1_n563_n5091# 1bitblock$3_0/a_11922_3# 0
C76 1bitblock$1_0/a_7410_63# m2_1701_n784# 0
C77 1bitblock_0/a_1845_466# 1bitblock_0/a_3498_3# -0
C78 1bitblock_0/a_3498_3# m1_14167_n1145# 1.79259f
C79 m2_5443_n3913# 1bitblock_0/a_6128_n37# 0
C80 m1_8729_n3942# m2_10721_n3315# 0.05078f
C81 m2_5443_n3913# 1bitblock$1_0/a_7083_63# 0.00187f
C82 1bitblock_0/a_160_63# m1_14167_n1145# 0
C83 1bitblock_0/a_2419_63# m1_14167_n1145# 0.07947f
C84 1bitblock_0/a_11480_63# m1_15541_n412# 0
C85 m1_12484_n953# m1_13543_n1146# 0.08498f
C86 m2_2396_n2595# m2_10721_n3315# 0.01652f
C87 m1_n563_n5091# 1bitblock$3_0/a_1845_466# 0
C88 1bitblock_0/m2_24_342# 1bitblock$1_0/a_160_63# 0.00441f
C89 m1_n563_n5091# m1_13543_n1146# 0.69902f
C90 1bitblock$2_0/a_11922_3# 1bitblock$3_0/a_11922_3# 0.0017f
C91 MUX21_0/a_157_63# m1_n563_n5091# 0.00149f
C92 m2_5443_n3913# m2_1701_n784# 0.03676f
C93 1bitblock$2_0/a_3940_63# 1bitblock$3_0/a_2419_63# 0
C94 m1_8729_n3942# 1bitblock$3_0/a_10363_63# 0.00105f
C95 m1_14167_n1145# 1bitblock_0/m2_9431_79# 0.02029f
C96 m1_8729_n3942# 1bitblock$3_0/a_8361_407# 0
C97 1bitblock_0/a_10906_n37# m1_14167_n1145# 0.00154f
C98 1bitblock$2_0/a_8160_n37# m1_8729_n3942# 0.00164f
C99 m1_n563_n5091# 1bitblock_0/a_705_407# -0
C100 MUX21_0/m2_540_79# m1_15541_n412# 0.00831f
C101 m1_n563_n5091# 1bitblock$3_0/a_8723_63# -0.00531f
C102 1bitblock$2_0/a_11922_3# m1_13543_n1146# 0
C103 1bitblock$3_0/a_9050_63# 1bitblock$3_0/m2_7791_79# -0
C104 m1_8729_n3942# 1bitblock$3_0/a_7083_63# 0.0537f
C105 1bitblock$2_0/a_2419_63# 1bitblock$3_0/a_3940_63# 0
C106 1bitblock$2_0/a_4290_63# m2_5443_n3913# 0.00738f
C107 m2_14516_n651# m2_10721_n3315# 0.00204f
C108 1bitblock_0/m2_9431_79# 1bitblock_0/a_8723_63# -0
C109 m1_8729_n3942# m1_13543_n1146# 0.01251f
C110 1bitblock_0/a_11480_63# m1_14167_n1145# 0.00995f
C111 m2_2396_n2595# 1bitblock$3_0/a_1845_466# 0.00179f
C112 m2_2396_n2595# m1_13543_n1146# 0.33711f
C113 1bitblock$2_0/a_10906_466# m2_10721_n3315# 0
C114 MUX21_0/a_157_63# m2_2396_n2595# 0
C115 1bitblock$2_0/m2_24_342# 1bitblock$3_0/a_1845_466# 0
C116 m1_n563_n5091# 1bitblock_0/a_3498_3# -0.00886f
C117 1bitblock$2_0/m2_24_342# m1_13543_n1146# 0.00392f
C118 1bitblock_0/a_2861_3# 1bitblock_0/a_705_407# -0
C119 1bitblock$2_0/a_2861_3# 1bitblock$2_0/a_705_407# -0
C120 m1_8729_n3942# 1bitblock$3_0/a_8723_63# 0.08003f
C121 m1_n563_n5091# 1bitblock_0/a_160_63# 0.02528f
C122 m1_n563_n5091# 1bitblock_0/a_2419_63# 0
C123 MUX21_0/m2_540_79# m1_14167_n1145# 0.01323f
C124 AND4_0/a_912_n441# m2_2396_n2595# 0.0044f
C125 m1_14167_n1145# 1bitblock_0/a_3940_63# 0
C126 m1_14167_n1145# 1bitblock$1_0/a_1845_n37# 0
C127 1bitblock_0/a_1845_n37# m2_1701_n784# 0.00311f
C128 MUX21_0/a_517_n37# m2_14516_n651# 0
C129 1bitblock$1_0/a_9050_63# 1bitblock$1_0/m2_9431_79# -0
C130 m2_14516_n651# m1_13543_n1146# 0.00988f
C131 MUX21_0/a_157_63# m2_14516_n651# 0.01122f
C132 m1_n563_n5091# 1bitblock_0/m2_9431_79# -0.00109f
C133 1bitblock$2_0/a_3940_63# 1bitblock$3_0/a_3940_63# 0.01104f
C134 1bitblock_0/a_2861_3# 1bitblock_0/a_3498_3# -0
C135 m1_8729_n3942# 1bitblock_0/a_3498_3# 0.00142f
C136 1bitblock$2_0/a_2861_3# 1bitblock$2_0/a_3498_3# -0
C137 1bitblock$1_0/a_510_63# m2_1701_n784# 0.00173f
C138 m2_5443_n3913# 1bitblock$1_0/a_4650_n37# 0.00119f
C139 m2_5443_n3913# 1bitblock_0/a_6520_n37# 0.0015f
C140 1bitblock$2_0/a_6128_n37# m2_5443_n3913# 0
C141 m1_8729_n3942# 1bitblock_0/a_2419_63# 0.00658f
C142 1bitblock$2_0/a_2861_391# m2_2396_n2595# 0.01578f
C143 1bitblock_0/a_2861_391# m1_14167_n1145# 0.01608f
C144 AND4_0/a_912_n441# m2_14516_n651# 0.00402f
C145 m2_2396_n2595# 1bitblock_0/a_2419_63# 0
C146 1bitblock$3_0/a_378_271# m1_13543_n1146# 0.00199f
C147 1bitblock$3_0/m2_24_342# 1bitblock$3_0/a_3498_3# -0
C148 1bitblock$3_0/a_9050_63# m1_13543_n1146# 0.00508f
C149 m1_8729_n3942# 1bitblock_0/m2_9431_79# 0.02012f
C150 1bitblock$2_0/a_705_407# m1_n563_n5091# 0.00817f
C151 MUX21_0/m2_540_79# m1_n563_n5091# -0.00173f
C152 m1_13543_n1146# 1bitblock$1_0/a_2419_63# 0
C153 1bitblock$2_0/m2_7791_79# 1bitblock$2_0/m2_9431_79# -0.00474f
C154 1bitblock$2_0/a_378_271# m1_n563_n5091# 0.00489f
C155 AND4_0/a_1120_n441# m2_2396_n2595# 0
C156 m2_2396_n2595# 1bitblock$3_0/a_2861_3# 0.00145f
C157 m2_5443_n3913# 1bitblock$1_0/a_4290_63# 0.00738f
C158 1bitblock$2_0/a_3498_3# m1_n563_n5091# 0.02184f
C159 1bitblock_0/a_705_407# 1bitblock$1_0/a_160_63# 0
C160 1bitblock_0/a_160_63# 1bitblock$1_0/a_705_407# 0
C161 1bitblock$2_0/a_1845_466# 1bitblock$3_0/a_1845_466# 0.00184f
C162 1bitblock$2_0/a_1845_466# m1_13543_n1146# 0.00178f
C163 1bitblock$2_0/a_705_407# m2_2396_n2595# 0.00549f
C164 1bitblock$2_0/a_160_63# m1_n563_n5091# 0.02629f
C165 1bitblock$1_0/a_870_n37# m2_1701_n784# 0
C166 1bitblock_0/a_7410_63# 1bitblock_0/m2_9431_79# -0
C167 AND4_0/a_1120_n441# m2_14516_n651# 0.00515f
C168 1bitblock$2_0/a_378_271# m2_2396_n2595# 0.00194f
C169 1bitblock$2_0/a_2419_63# m1_12484_n953# 0.03322f
C170 1bitblock$2_0/a_10906_n37# m1_12484_n953# 0.00483f
C171 1bitblock$2_0/m2_9431_79# m1_n563_n5091# -0
C172 1bitblock$2_0/a_2419_63# m1_n563_n5091# 0.00232f
C173 1bitblock$1_0/m2_24_342# 1bitblock_0/m2_24_342# 0.16333f
C174 1bitblock$2_0/a_3498_3# m1_8729_n3942# 0.00389f
C175 1bitblock$2_0/a_3498_3# m2_2396_n2595# 1.47227f
C176 m2_5443_n3913# 1bitblock$1_0/a_5042_n37# 0
C177 1bitblock_0/a_2419_63# 1bitblock$1_0/a_2419_63# 1.63229f
C178 1bitblock$3_0/a_7410_63# m1_8729_n3942# 0.00461f
C179 1bitblock$2_0/a_6520_n37# m2_5443_n3913# 0.00151f
C180 1bitblock_0/a_160_63# 1bitblock$1_0/a_160_63# 0.04611f
C181 MUX21_0/m2_540_79# m2_14516_n651# 0.00787f
C182 1bitblock$1_0/m2_24_342# 1bitblock$2_0/a_510_63# 0
C183 1bitblock$2_0/a_160_63# m2_2396_n2595# 0
C184 1bitblock$2_0/m2_24_342# 1bitblock$2_0/a_3498_3# -0
C185 1bitblock$2_0/a_5042_407# m1_n563_n5091# 0
C186 1bitblock$2_0/a_11480_63# m1_12484_n953# 0.0167f
C187 1bitblock$2_0/a_11480_63# m1_n563_n5091# 0
C188 1bitblock_0/a_5768_63# m2_1701_n784# 0
C189 m1_15541_n412# m1_12486_242# 1.92011f
C190 1bitblock_0/m2_7791_79# m2_1701_n784# 0
C191 m1_8729_n3942# 1bitblock$1_0/a_9408_n37# 0
C192 1bitblock$2_0/a_2419_63# m1_8729_n3942# 0.00665f
C193 1bitblock$2_0/m2_9431_79# m1_8729_n3942# 0.02467f
C194 1bitblock$2_0/a_705_407# 1bitblock$1_0/a_705_407# 0.04927f
C195 m2_2396_n2595# 1bitblock$2_0/m2_9431_79# 0.01952f
C196 1bitblock$2_0/a_2419_63# m2_2396_n2595# 0.07185f
C197 1bitblock$2_0/a_10906_n37# m2_2396_n2595# 0.00148f
C198 1bitblock$2_0/a_705_407# 1bitblock$3_0/a_378_271# 0
C199 1bitblock$2_0/a_378_271# 1bitblock$1_0/a_705_407# 0
C200 1bitblock$2_0/a_3940_63# m1_n563_n5091# 0
C201 1bitblock_0/a_11922_3# m1_12486_242# 0.01844f
C202 m1_15541_n412# 1bitblock$1_0/a_11922_3# 0
C203 1bitblock$2_0/m2_9431_79# 1bitblock$2_0/a_8723_63# -0
C204 1bitblock$2_0/a_870_n37# 1bitblock$3_0/a_160_63# 0.00135f
C205 1bitblock_0/a_9050_63# 1bitblock_0/m2_7791_79# -0
C206 1bitblock$2_0/a_5768_63# m1_n563_n5091# 0
C207 1bitblock$2_0/a_11480_63# m2_2396_n2595# 0.00938f
C208 m1_15541_n412# m2_1701_n784# 2.16295f
C209 m1_14167_n1145# m1_12486_242# 0.0897f
C210 1bitblock$2_0/a_705_407# 1bitblock$1_0/a_160_63# 0
C211 1bitblock$2_0/a_160_63# 1bitblock$1_0/a_705_407# 0
C212 1bitblock_0/a_11922_3# 1bitblock$1_0/a_11922_3# 0.00177f
C213 1bitblock$2_0/a_160_63# 1bitblock$3_0/a_378_271# 0.00364f
C214 1bitblock_0/a_2419_63# 1bitblock$1_0/a_3940_63# 0
C215 1bitblock_0/a_3940_63# 1bitblock$1_0/a_2419_63# 0
C216 1bitblock_0/a_11922_391# m1_12486_242# 0.00287f
C217 1bitblock$1_0/a_1262_n37# m2_1701_n784# 0
C218 m2_2396_n2595# 1bitblock$2_0/a_3940_63# 0
C219 m1_n563_n5091# 1bitblock$1_0/a_5768_63# 0
C220 1bitblock$2_0/a_3498_3# 1bitblock$1_0/a_3498_3# 0.01312f
C221 m1_n563_n5091# 1bitblock$1_0/m2_7791_79# -0
C222 1bitblock_0/a_11922_3# m2_1701_n784# 0
C223 1bitblock_0/a_7083_63# m2_1701_n784# 0.02635f
C224 1bitblock$2_0/a_3498_3# 1bitblock$1_0/a_2419_63# 0
C225 1bitblock_0/a_1845_466# 1bitblock$1_0/a_1845_466# 0.00192f
C226 m2_5443_n3913# 1bitblock$3_0/m2_6151_79# 0.01067f
C227 1bitblock_0/a_1845_466# m2_1701_n784# 0.00247f
C228 m1_14167_n1145# 1bitblock$1_0/a_1845_466# 0.00183f
C229 m1_14167_n1145# m2_1701_n784# 0.36644f
C230 1bitblock$2_0/a_160_63# 1bitblock$1_0/a_160_63# 0.00196f
C231 1bitblock_0/a_10906_466# m1_12486_242# 0.00953f
C232 m2_2396_n2595# 1bitblock$3_0/a_510_63# 0
C233 m2_5443_n3913# 1bitblock$3_0/a_3498_3# 0
C234 1bitblock$2_0/a_2419_63# 1bitblock$1_0/a_3498_3# 0
C235 1bitblock$2_0/a_1845_466# 1bitblock$2_0/a_3498_3# -0
C236 m1_8729_n3942# 1bitblock$1_0/m2_7791_79# 0.02398f
C237 m2_5443_n3913# 1bitblock$3_0/a_2419_63# 0.00867f
C238 m1_8729_n3942# 1bitblock$1_0/a_9800_n37# 0.0014f
C239 1bitblock_0/a_8723_63# m2_1701_n784# 0
C240 m1_12484_n953# m1_12486_242# 0.0157f
C241 m2_2396_n2595# 1bitblock$1_0/m2_7791_79# 0.0169f
C242 1bitblock$2_0/a_2419_63# 1bitblock$1_0/a_2419_63# 0.00365f
C243 m1_n563_n5091# m1_12486_242# 0.12729f
C244 1bitblock_0/a_378_271# m1_14167_n1145# 0.00199f
C245 1bitblock_0/a_9050_63# m1_14167_n1145# 0.0052f
C246 1bitblock$3_0/m2_24_342# m1_n563_n5091# 0.01803f
C247 1bitblock_0/a_3940_63# 1bitblock$1_0/a_3940_63# 0.01129f
C248 1bitblock$2_0/a_510_63# 1bitblock$1_0/a_378_271# 0
C249 m1_12484_n953# 1bitblock$1_0/a_11922_3# 0.01185f
C250 AND4_0/a_518_229# m1_15541_n412# 0
C251 1bitblock$2_0/a_1845_n37# m1_13543_n1146# 0.00179f
C252 1bitblock$1_0/m2_24_342# 1bitblock_0/a_705_407# 0
C253 m1_n563_n5091# 1bitblock$1_0/a_11922_3# 0.00267f
C254 m1_8729_n3942# 1bitblock$1_0/a_9609_407# 0.01871f
C255 m2_2396_n2595# 1bitblock$1_0/a_9609_407# 0.1012f
C256 m1_n563_n5091# 1bitblock$1_0/a_7083_63# 0
C257 m1_8729_n3942# m1_12486_242# 0.05039f
C258 m2_5443_n3913# 1bitblock$3_0/a_5042_407# 0.05824f
C259 m1_12484_n953# m2_1701_n784# 0.00165f
C260 m2_2396_n2595# m1_12486_242# 0.0866f
C261 m1_n563_n5091# 1bitblock$1_0/a_1845_466# 0.00107f
C262 m1_n563_n5091# m2_1701_n784# 0.08054f
C263 1bitblock$2_0/a_11922_3# 1bitblock$1_0/a_11922_3# 0
C264 m1_8729_n3942# 1bitblock$1_0/a_10363_63# 0.00192f
C265 m1_12484_n953# 1bitblock$1_0/a_11922_391# 0.00359f
C266 m2_2396_n2595# 1bitblock$1_0/a_10363_63# 0.00482f
C267 m1_8729_n3942# 1bitblock$1_0/a_8361_407# 0.00891f
C268 1bitblock$3_0/m2_24_342# m2_2396_n2595# 0.00389f
C269 m2_2396_n2595# 1bitblock$1_0/a_8361_407# 0.03598f
C270 m1_n563_n5091# 1bitblock$1_0/a_8723_63# -0.00527f
C271 m2_2396_n2595# 1bitblock$1_0/a_11922_3# 0.01205f
C272 1bitblock$2_0/a_4290_63# m1_n563_n5091# 0
C273 1bitblock$1_0/m2_24_342# 1bitblock_0/a_160_63# 0.00432f
C274 AND4_0/a_518_229# m1_14167_n1145# 0.01521f
C275 m1_8729_n3942# 1bitblock$1_0/a_7083_63# 0.05469f
C276 1bitblock$2_0/a_11480_63# 1bitblock$1_0/a_11480_63# 0.00182f
C277 1bitblock$2_0/m2_24_342# 1bitblock$3_0/m2_24_342# 0.14833f
C278 m2_5443_n3913# 1bitblock$3_0/a_3940_63# 0.00284f
C279 m2_2396_n2595# 1bitblock$1_0/a_7083_63# 0.00482f
C280 m2_5443_n3913# 1bitblock_0/a_5768_63# 0.01316f
C281 m2_14516_n651# m1_12486_242# 0.00988f
C282 1bitblock$2_0/a_2861_3# 1bitblock$1_0/a_2861_3# 0
C283 m1_8729_n3942# m2_1701_n784# 0.03255f
C284 1bitblock_0/a_2861_3# m2_1701_n784# 0.00149f
C285 m1_14167_n1145# 1bitblock$1_0/a_2861_3# 0.00149f
C286 m2_2396_n2595# 1bitblock$1_0/a_1845_466# 0.0015f
C287 1bitblock_0/a_1262_n37# 1bitblock_0/a_705_407# 0
C288 m2_2396_n2595# m2_1701_n784# 1.22078f
C289 m1_12484_n953# 1bitblock$1_0/a_10906_466# 0
C290 m1_n563_n5091# 1bitblock$1_0/a_10906_466# 0.00111f
C291 1bitblock$3_0/a_2419_63# 1bitblock$3_0/a_705_407# -0
C292 1bitblock$3_0/a_705_407# 1bitblock$3_0/a_160_63# 0
C293 1bitblock$2_0/m2_24_342# m2_1701_n784# 0
C294 m2_2396_n2595# 1bitblock$1_0/a_11922_391# 0.00705f
C295 1bitblock$3_0/a_9609_407# 1bitblock$3_0/m2_7791_79# -0
C296 m1_8729_n3942# 1bitblock$1_0/a_8723_63# 0.09524f
C297 m2_14516_n651# 1bitblock$1_0/a_11922_3# 0.00533f
C298 m2_2396_n2595# 1bitblock$1_0/a_8723_63# 0.02997f
C299 m1_8729_n3942# 1bitblock$3_0/a_7768_n37# 0
C300 1bitblock$2_0/a_510_63# m1_13543_n1146# 0
C301 m1_8729_n3942# 1bitblock_0/a_9050_63# 0.01686f
C302 1bitblock$1_0/m2_7791_79# 1bitblock$1_0/m2_9431_79# -0.00474f
C303 m2_5443_n3913# m1_15541_n412# 0.05217f
C304 m2_14516_n651# m2_1701_n784# 0.85907f
C305 1bitblock_0/a_4290_63# m2_1701_n784# 0
C306 1bitblock$3_0/a_2419_63# 1bitblock$3_0/a_3498_3# -0
C307 m2_2396_n2595# 1bitblock$1_0/a_10906_466# 0.0111f
C308 AND4_0/a_518_229# m1_12484_n953# 0.00876f
C309 1bitblock$1_0/m2_24_342# 1bitblock$2_0/a_705_407# 0
C310 AND4_0/a_518_229# m1_n563_n5091# 0.0239f
C311 1bitblock$2_0/a_9050_63# 1bitblock$2_0/m2_7791_79# -0
C312 1bitblock$1_0/a_2419_63# m1_12486_242# -0.00165f
C313 1bitblock_0/a_7410_63# m2_1701_n784# 0
C314 1bitblock$3_0/a_3498_3# 1bitblock$3_0/m2_9431_79# -0
C315 1bitblock$2_0/a_378_271# 1bitblock$1_0/m2_24_342# 0
C316 1bitblock_0/m2_24_342# 1bitblock_0/a_3498_3# -0
C317 m1_n563_n5091# 1bitblock$1_0/a_2861_3# 0.00101f
C318 m2_5443_n3913# 1bitblock_0/a_7083_63# 0.00107f
C319 m1_13543_n1146# 1bitblock$3_0/m2_7791_79# 0.01676f
C320 1bitblock_0/m2_24_342# 1bitblock_0/a_160_63# -0
C321 m2_1701_n784# 1bitblock$1_0/m2_6151_79# 0
C322 1bitblock$1_0/a_10906_n37# m1_12486_242# 0.00484f
C323 m2_5443_n3913# m1_14167_n1145# 0.00325f
C324 m2_14516_n651# 1bitblock$1_0/a_10906_466# 0
C325 1bitblock_0/a_378_271# 1bitblock$1_0/a_705_407# 0
C326 1bitblock_0/a_705_407# 1bitblock$1_0/a_378_271# 0
C327 m2_2396_n2595# 1bitblock$3_0/a_1262_n37# 0
C328 1bitblock$3_0/m2_7791_79# 1bitblock$3_0/a_8723_63# 0
C329 1bitblock$1_0/m2_24_342# 1bitblock$2_0/a_160_63# 0
C330 AND4_0/a_518_229# m2_2396_n2595# 0.05061f
C331 1bitblock$2_0/a_10906_466# 1bitblock$1_0/a_10906_466# 0.00145f
C332 1bitblock$1_0/a_3498_3# m2_1701_n784# -0.0052f
C333 1bitblock$3_0/a_11922_3# m2_10721_n3315# 0.01722f
C334 1bitblock$2_0/a_9050_63# m1_n563_n5091# 0
C335 1bitblock_0/a_9609_407# 1bitblock_0/m2_7791_79# -0
C336 1bitblock$1_0/a_2419_63# m2_1701_n784# 0.4677f
C337 m1_13543_n1146# 1bitblock$3_0/a_9609_407# 0.10003f
C338 1bitblock$1_0/a_160_63# m2_1701_n784# 0
C339 1bitblock$1_0/a_11480_63# m1_12486_242# 0.01269f
C340 m2_2396_n2595# 1bitblock$1_0/a_2861_3# 0.01004f
C341 m1_n563_n5091# 1bitblock$1_0/a_4290_63# 0
C342 m1_13543_n1146# m2_10721_n3315# 0.17094f
C343 1bitblock$3_0/a_2861_391# 1bitblock$3_0/a_705_407# -0
C344 1bitblock$2_0/a_5243_407# m2_5443_n3913# 0.01246f
C345 m2_1701_n784# 1bitblock$1_0/m2_9431_79# 0
C346 1bitblock$2_0/a_1845_466# 1bitblock$1_0/a_1845_466# 0.00145f
C347 1bitblock$3_0/a_2419_63# 1bitblock$3_0/a_3940_63# -0
C348 1bitblock$2_0/a_1845_466# m2_1701_n784# 0.0015f
C349 1bitblock$3_0/a_11922_391# m2_10721_n3315# 0.00397f
C350 m1_n563_n5091# 1bitblock$1_0/a_7410_63# 0
C351 AND4_0/a_518_229# m2_14516_n651# 0.01804f
C352 1bitblock_0/a_378_271# 1bitblock$1_0/a_160_63# 0.00372f
C353 1bitblock_0/a_160_63# 1bitblock$1_0/a_378_271# 0.00373f
C354 1bitblock$3_0/a_10363_63# m1_13543_n1146# 0.00478f
C355 m1_8729_n3942# 1bitblock$3_0/a_8160_n37# 0.00163f
C356 m1_13543_n1146# 1bitblock$3_0/a_8361_407# 0.03557f
C357 1bitblock$2_0/a_9050_63# m1_8729_n3942# 0.02224f
C358 1bitblock$2_0/a_9050_63# m2_2396_n2595# 0.00483f
C359 1bitblock$3_0/a_11922_3# m1_13543_n1146# 0.01495f
C360 1bitblock$1_0/m2_9431_79# 1bitblock$1_0/a_8723_63# -0
C361 m1_12484_n953# m2_5443_n3913# 0.05387f
C362 m2_1701_n784# 1bitblock$1_0/a_5042_407# 0.02321f
C363 m1_13543_n1146# 1bitblock$3_0/a_7083_63# 0.0048f
C364 1bitblock$3_0/a_2861_391# 1bitblock$3_0/a_3498_3# -0
C365 1bitblock_0/a_1845_n37# m1_14167_n1145# 0
C366 m2_5443_n3913# m1_n563_n5091# 0.18639f
C367 1bitblock$3_0/a_1845_466# m1_13543_n1146# 0.01449f
C368 1bitblock$3_0/a_10906_466# m2_10721_n3315# 0.0161f
C369 MUX21_0/a_157_63# m1_13543_n1146# 0
C370 m1_8729_n3942# 1bitblock$1_0/a_7410_63# 0.00637f
C371 m2_2396_n2595# 1bitblock$1_0/a_7410_63# 0.00161f
C372 m1_14167_n1145# 1bitblock$1_0/a_510_63# 0
C373 1bitblock_0/a_510_63# m2_1701_n784# 0
C374 m2_5443_n3913# 1bitblock_0/a_4650_n37# 0.00119f
C375 1bitblock$3_0/a_11922_391# m1_13543_n1146# 0.00701f
C376 AND4_0/a_704_n441# m2_1701_n784# 0.01591f
C377 1bitblock$2_0/a_7083_63# m2_5443_n3913# 0.00187f
C378 m2_1701_n784# 1bitblock$1_0/a_3940_63# 0.00175f
C379 m1_13543_n1146# 1bitblock$3_0/a_8723_63# 0.02911f
C380 m2_5443_n3913# m1_8729_n3942# 0.00777f
C381 1bitblock_0/a_9609_407# m1_14167_n1145# 0.10113f
C382 m2_2396_n2595# m2_5443_n3913# 0.06231f
C383 AND4_0/a_518_229# 1bitblock$1_0/a_2419_63# 0.00114f
C384 1bitblock$2_0/a_705_407# 1bitblock$1_0/a_378_271# 0
C385 1bitblock$3_0/a_10906_466# m1_13543_n1146# 0.01097f
C386 1bitblock$2_0/a_378_271# 1bitblock$1_0/a_378_271# 0.00593f
C387 m2_5443_n3913# 1bitblock$3_0/a_6128_n37# 0
C388 1bitblock$2_0/a_2861_3# 1bitblock$3_0/a_2419_63# 0
C389 m2_5443_n3913# 1bitblock_0/a_4290_63# 0.00478f
C390 1bitblock_0/a_2419_63# 1bitblock_0/a_705_407# -0
C391 m1_n563_n5091# 1bitblock$1_0/a_510_63# 0
C392 m1_n563_n5091# 1bitblock$3_0/a_705_407# -0
C393 AND4_0/a_1120_n441# m1_13543_n1146# 0.0044f
C394 1bitblock$3_0/a_2861_3# m1_13543_n1146# 0.01984f
C395 m1_n563_n5091# 1bitblock$3_0/m2_6151_79# 0
C396 1bitblock_0/a_2419_63# 1bitblock_0/a_3498_3# -0
C397 m2_5443_n3913# 1bitblock$1_0/m2_6151_79# 0.01607f
C398 m1_n563_n5091# 1bitblock$3_0/a_3498_3# -0.0086f
C399 m2_5443_n3913# 1bitblock_0/a_5042_n37# 0
C400 1bitblock$2_0/a_4650_n37# m2_5443_n3913# 0.00119f
C401 m1_12484_n953# 1bitblock$3_0/a_2419_63# 0.04408f
C402 m2_5443_n3913# 1bitblock$1_0/a_3498_3# 0.05026f
C403 m2_2396_n2595# 1bitblock$3_0/a_705_407# 0
C404 m1_n563_n5091# 1bitblock$3_0/a_2419_63# 0
C405 1bitblock$2_0/a_705_407# m1_13543_n1146# 0
C406 m1_n563_n5091# 1bitblock$3_0/a_160_63# 0.0255f
C407 1bitblock$2_0/m2_24_342# 1bitblock$1_0/a_510_63# 0
C408 1bitblock_0/a_3498_3# 1bitblock_0/m2_9431_79# -0
C409 m2_5443_n3913# 1bitblock$1_0/a_2419_63# 0.00541f
C410 1bitblock$1_0/a_4290_63# 1bitblock$1_0/a_5042_407# 0
C411 MUX21_0/m2_540_79# MUX21_0/a_157_63# 0
C412 1bitblock_0/a_9609_407# m1_8729_n3942# 0.00143f
C413 1bitblock$2_0/m2_24_342# 1bitblock$3_0/a_705_407# 0
C414 1bitblock$1_0/m2_24_342# m2_1701_n784# 0.02455f
C415 m1_8729_n3942# 1bitblock_0/a_9408_n37# 0
C416 m1_14167_n1145# 1bitblock_0/m2_7791_79# 0.01686f
C417 1bitblock$2_0/a_378_271# m1_13543_n1146# 0.0025f
C418 m2_5443_n3913# 1bitblock$1_0/a_6721_407# 0.01358f
C419 1bitblock$2_0/a_2419_63# m2_10721_n3315# 0.04476f
C420 m1_n563_n5091# 1bitblock$3_0/m2_9431_79# -0.00106f
C421 m1_12480_n3815# m1_14167_n1145# 0
C422 m1_8729_n3942# 1bitblock$3_0/a_3498_3# 0.0014f
C423 1bitblock$2_0/a_3498_3# m1_13543_n1146# 0
C424 m2_2396_n2595# 1bitblock$3_0/a_3498_3# 0
C425 m2_5443_n3913# 1bitblock$3_0/a_6520_n37# 0.00151f
C426 1bitblock$3_0/a_2419_63# m1_8729_n3942# 0.00663f
C427 1bitblock$2_0/a_1262_n37# m1_13543_n1146# 0
C428 1bitblock$3_0/a_7410_63# m1_13543_n1146# 0.0016f
C429 1bitblock_0/a_11922_3# m1_15541_n412# 0
C430 m2_2396_n2595# 1bitblock$3_0/a_160_63# 0.00103f
C431 1bitblock$2_0/a_160_63# m1_13543_n1146# 0.00107f
C432 m2_2396_n2595# 1bitblock$3_0/a_2419_63# 0.00529f
C433 m1_n563_n5091# 1bitblock$3_0/a_5042_407# 0
C434 1bitblock$2_0/a_2419_63# 1bitblock$3_0/a_11922_3# 0
C435 m2_5443_n3913# 1bitblock$1_0/a_5042_407# 0.06275f
C436 1bitblock$2_0/m2_24_342# 1bitblock$3_0/a_160_63# 0.00437f
C437 m1_14167_n1145# m1_15541_n412# 0.08467f
C438 1bitblock_0/a_2861_391# 1bitblock_0/a_705_407# -0
C439 1bitblock$2_0/a_2861_391# 1bitblock$2_0/a_705_407# -0
C440 m1_8729_n3942# 1bitblock$3_0/m2_9431_79# 0.02041f
C441 1bitblock$2_0/a_2419_63# m1_13543_n1146# 0.00534f
C442 1bitblock$2_0/a_3940_63# m2_10721_n3315# 0
C443 1bitblock_0/a_10363_63# m1_14167_n1145# 0.00489f
C444 1bitblock_0/a_1262_n37# m2_1701_n784# 0
C445 m1_14167_n1145# 1bitblock$1_0/a_1262_n37# 0
C446 m1_n563_n5091# 1bitblock$3_0/a_3940_63# 0
C447 1bitblock$1_0/a_9050_63# 1bitblock$1_0/m2_7791_79# -0
C448 m1_14167_n1145# 1bitblock_0/a_8361_407# 0.03596f
C449 m2_5443_n3913# 1bitblock$1_0/a_3940_63# 0.00421f
C450 m1_n563_n5091# 1bitblock_0/m2_7791_79# -0
C451 1bitblock_0/a_11922_3# m1_14167_n1145# 0.01214f
C452 m1_12484_n953# m1_12480_n3815# 0
C453 m1_14167_n1145# 1bitblock_0/a_7083_63# 0.00482f
C454 m1_n563_n5091# m1_12480_n3815# 0.04173f
C455 1bitblock_0/a_2861_391# 1bitblock_0/a_3498_3# -0
C456 1bitblock$2_0/a_5042_n37# m2_5443_n3913# 0
C457 1bitblock_0/a_1845_466# m1_14167_n1145# 0.01466f
C458 1bitblock_0/a_10906_466# m1_15541_n412# 0.00242f
C459 1bitblock_0/m2_24_342# 1bitblock$1_0/a_1845_466# 0
C460 1bitblock_0/m2_24_342# m2_1701_n784# 0.01532f
C461 1bitblock_0/a_11922_391# m1_14167_n1145# 0.00712f
C462 1bitblock$2_0/a_3940_63# m1_13543_n1146# 0
C463 m2_2396_n2595# 1bitblock$3_0/a_3940_63# 0
C464 m1_8729_n3942# 1bitblock_0/m2_7791_79# 0.01993f
C465 m1_8729_n3942# 1bitblock$1_0/a_7768_n37# 0
C466 m1_8729_n3942# 1bitblock_0/a_9800_n37# 0.00139f
C467 m1_14167_n1145# 1bitblock_0/a_8723_63# 0.0292f
C468 1bitblock$2_0/a_9408_n37# m1_8729_n3942# 0
C469 m1_n563_n5091# m1_15541_n412# 0.00249f
C470 1bitblock$3_0/a_9050_63# 1bitblock$3_0/m2_9431_79# -0
C471 1bitblock$2_0/a_378_271# 1bitblock$2_0/a_705_407# -0
C472 MUX21_0/a_718_407# m2_1701_n784# 0
C473 1bitblock_0/a_10906_466# m1_14167_n1145# 0.01125f
C474 1bitblock$3_0/a_510_63# m1_13543_n1146# 0.00107f
C475 m1_n563_n5091# 1bitblock_0/a_11922_3# 0
C476 1bitblock$1_0/a_378_271# m2_1701_n784# 0.00848f
C477 m1_8729_n3942# m1_15541_n412# 0.0504f
C478 1bitblock$1_0/a_9050_63# m2_1701_n784# 0
C479 m2_14516_n651# m1_12480_n3815# 0
C480 m2_2396_n2595# m1_15541_n412# 0
C481 1bitblock$2_0/a_2861_3# m1_n563_n5091# 0.00101f
C482 1bitblock$2_0/a_2419_63# 1bitblock$3_0/a_2861_3# 0
C483 m1_n563_n5091# 1bitblock_0/a_1845_466# 0
C484 m1_n563_n5091# m1_14167_n1145# 0.68409f
C485 1bitblock$2_0/a_9609_407# 1bitblock$2_0/m2_7791_79# -0
C486 m1_8729_n3942# 1bitblock_0/a_10363_63# 0.00105f
C487 1bitblock_0/a_7410_63# 1bitblock_0/m2_7791_79# 0
C488 m1_8729_n3942# 1bitblock_0/a_8361_407# 0
C489 1bitblock$2_0/a_2419_63# 1bitblock$2_0/a_705_407# -0
C490 m1_n563_n5091# 1bitblock_0/a_8723_63# -0.0053f
C491 1bitblock$2_0/m2_7791_79# m1_n563_n5091# -0
C492 m1_8729_n3942# 1bitblock_0/a_7083_63# 0.05365f
C493 m2_14516_n651# m1_15541_n412# 0.13525f
C494 m1_8729_n3942# m1_14167_n1145# 0.01252f
C495 1bitblock$2_0/a_2861_3# m2_2396_n2595# 0.01973f
C496 1bitblock_0/a_2861_3# m1_14167_n1145# 0.0205f
C497 m2_2396_n2595# m1_14167_n1145# 0.00193f
C498 1bitblock$2_0/a_2419_63# 1bitblock$2_0/a_3498_3# -0
C499 1bitblock$3_0/m2_24_342# m1_13543_n1146# 0.0031f
C500 m1_8729_n3942# 1bitblock$1_0/a_8160_n37# 0.00164f
C501 m1_8729_n3942# 1bitblock_0/a_8723_63# 0.07922f
C502 1bitblock$2_0/m2_7791_79# m1_8729_n3942# 0.02388f
C503 1bitblock$2_0/a_9800_n37# m1_8729_n3942# 0.0014f
C504 m2_2396_n2595# 1bitblock$2_0/m2_7791_79# 0.01632f
C505 m1_12484_n953# m1_n563_n5091# 0.32612f
C506 m1_13543_n1146# 1bitblock$1_0/a_11922_3# 0
C507 MUX21_0/a_718_407# AND4_0/a_518_229# 0
C508 m2_14516_n651# m1_14167_n1145# 0.09216f
C509 m1_13543_n1146# m2_1701_n784# 0.0051f
C510 1bitblock$2_0/a_11922_3# m1_12484_n953# 0.03274f
C511 MUX21_0/a_157_63# m2_1701_n784# 0
C512 1bitblock$2_0/a_11922_3# m1_n563_n5091# 0.00103f
C513 1bitblock$2_0/a_9609_407# m1_8729_n3942# 0.01866f
C514 m2_2396_n2595# 1bitblock$2_0/a_9609_407# 0.09632f
C515 1bitblock$2_0/a_7083_63# m1_n563_n5091# 0
C516 m1_15541_n412# 1bitblock$1_0/a_2419_63# 0.01284f
C517 1bitblock_0/a_2419_63# m1_12486_242# 0.05407f
C518 1bitblock_0/a_7410_63# m1_14167_n1145# 0.00163f
C519 m1_12484_n953# m1_8729_n3942# 0.05077f
C520 m1_14167_n1145# 1bitblock$1_0/a_705_407# 0
C521 1bitblock_0/a_705_407# m2_1701_n784# 0
C522 m2_2396_n2595# m1_12484_n953# 0.16107f
C523 m1_n563_n5091# m1_8729_n3942# 0.27477f
C524 AND4_0/a_912_n441# m2_1701_n784# 0.01194f
C525 1bitblock$2_0/a_705_407# 1bitblock$3_0/a_510_63# 0
C526 m2_2396_n2595# m1_n563_n5091# 1.58588f
C527 1bitblock$2_0/a_10363_63# m1_8729_n3942# 0.00192f
C528 1bitblock$2_0/a_11922_391# m1_12484_n953# 0.00755f
C529 1bitblock$2_0/a_10363_63# m2_2396_n2595# 0.00459f
C530 1bitblock$2_0/m2_24_342# m1_n563_n5091# 0.03105f
C531 1bitblock_0/m2_6151_79# m2_1701_n784# 0
C532 1bitblock_0/a_10906_n37# m1_12486_242# 0.00168f
C533 1bitblock$2_0/a_8361_407# m1_8729_n3942# 0.00891f
C534 1bitblock_0/a_2419_63# 1bitblock$1_0/a_11922_3# 0
C535 m2_2396_n2595# 1bitblock$2_0/a_8361_407# 0.03425f
C536 1bitblock$2_0/a_8723_63# m1_n563_n5091# -0.0053f
C537 1bitblock$2_0/a_11922_3# m2_2396_n2595# 0.01144f
C538 1bitblock$2_0/a_7083_63# m1_8729_n3942# 0.0547f
C539 m1_14167_n1145# 1bitblock$1_0/a_3498_3# 0
C540 1bitblock_0/a_3498_3# m2_1701_n784# 0
C541 m2_2396_n2595# 1bitblock$2_0/a_7083_63# 0.00471f
C542 m2_5443_n3913# 1bitblock$1_0/a_6128_n37# 0
C543 m2_14516_n651# m1_12484_n953# 0.10897f
C544 1bitblock_0/a_2419_63# m2_1701_n784# 0.36366f
C545 m1_14167_n1145# 1bitblock$1_0/a_2419_63# 0.004f
C546 m1_14167_n1145# 1bitblock$1_0/a_160_63# 0.00107f
C547 1bitblock_0/a_160_63# m2_1701_n784# 0.00109f
C548 m2_2396_n2595# m1_8729_n3942# 0.09192f
C549 1bitblock_0/a_11480_63# m1_12486_242# 0.00896f
C550 m2_14516_n651# m1_n563_n5091# 0.16195f
C551 1bitblock$2_0/a_160_63# 1bitblock$3_0/a_510_63# 0
C552 1bitblock$2_0/a_10906_466# m1_12484_n953# 0.0176f
C553 1bitblock$2_0/a_10906_466# m1_n563_n5091# 0.00105f
C554 1bitblock$2_0/m2_24_342# m2_2396_n2595# 0.00302f
C555 1bitblock$2_0/a_11922_391# m2_2396_n2595# 0.00681f
C556 1bitblock_0/m2_9431_79# m2_1701_n784# 0
C557 1bitblock$2_0/a_8723_63# m1_8729_n3942# 0.09622f
C558 m1_n563_n5091# 1bitblock$1_0/a_705_407# 0.00876f
C559 m2_2396_n2595# 1bitblock$2_0/a_8723_63# 0.02885f
C560 1bitblock$3_0/a_1262_n37# m1_13543_n1146# -0
C561 AND4_0/a_518_229# m1_13543_n1146# 0.05606f
C562 1bitblock_0/a_3940_63# m1_12486_242# 0
C563 m1_n563_n5091# 1bitblock$3_0/a_378_271# 0
C564 m2_5443_n3913# 1bitblock$3_0/a_5768_63# 0.01326f
C565 1bitblock$3_0/m2_24_342# 1bitblock$2_0/a_705_407# 0
C566 1bitblock_0/a_5042_407# m2_1701_n784# 0.01787f
C567 m2_14516_n651# m2_2396_n2595# 0.00583f
C568 AND4_0/a_1120_n441# m2_1701_n784# 0.00916f
C569 m1_n563_n5091# 1bitblock$1_0/m2_6151_79# 0
C570 1bitblock$2_0/a_10906_466# m2_2396_n2595# 0.01059f
C571 m1_n563_n5091# 1bitblock$1_0/a_3498_3# 0.03072f
C572 m1_8729_n3942# 1bitblock_0/a_7410_63# 0.00465f
C573 m1_12484_n953# 1bitblock$1_0/a_2419_63# 0.00245f
C574 m2_2396_n2595# 1bitblock$1_0/a_705_407# 0.00123f
C575 1bitblock$2_0/a_705_407# m2_1701_n784# 0.00123f
C576 m1_n563_n5091# 1bitblock$1_0/a_160_63# 0.0263f
C577 m1_n563_n5091# 1bitblock$1_0/a_2419_63# 0.00292f
C578 1bitblock_0/a_510_63# m1_14167_n1145# 0.00107f
C579 m2_2396_n2595# 1bitblock$3_0/a_378_271# 0.00248f
C580 m1_8729_n3942# 1bitblock$3_0/a_9050_63# 0.01697f
C581 AND4_0/a_704_n441# m1_14167_n1145# 0.01112f
C582 1bitblock_0/a_3940_63# m2_1701_n784# 0.00164f
C583 m1_14167_n1145# 1bitblock$1_0/a_3940_63# 0
C584 1bitblock$2_0/m2_24_342# 1bitblock$1_0/a_705_407# 0
C585 1bitblock$1_0/a_1845_n37# m2_1701_n784# 0.00561f
C586 1bitblock$2_0/a_378_271# m2_1701_n784# 0
C587 1bitblock$3_0/m2_24_342# 1bitblock$2_0/a_160_63# 0.00419f
C588 m2_5443_n3913# m2_10721_n3315# 0.05254f
C589 1bitblock$2_0/a_510_63# 1bitblock$1_0/a_510_63# 0.00154f
C590 m1_n563_n5091# 1bitblock$1_0/m2_9431_79# -0
C591 1bitblock$2_0/a_160_63# 1bitblock$3_0/a_870_n37# 0.00135f
C592 1bitblock$2_0/a_1845_466# m1_n563_n5091# 0.00109f
C593 1bitblock$2_0/a_510_63# 1bitblock$3_0/a_705_407# 0
C594 m1_8729_n3942# 1bitblock$1_0/a_3498_3# 0.00389f
C595 m2_2396_n2595# 1bitblock$1_0/a_3498_3# 1.69486f
C596 1bitblock$2_0/a_3498_3# m2_1701_n784# 0.0012f
C597 m2_5443_n3913# 1bitblock$1_0/a_6520_n37# 0.00151f
C598 1bitblock_0/a_2861_3# 1bitblock$1_0/a_2419_63# 0
C599 1bitblock_0/a_2419_63# 1bitblock$1_0/a_2861_3# 0
C600 m1_8729_n3942# 1bitblock$1_0/a_2419_63# 0.00237f
C601 m2_2396_n2595# 1bitblock$1_0/a_2419_63# 0.01135f
C602 m1_n563_n5091# 1bitblock$1_0/a_5042_407# 0
C603 m1_12484_n953# 1bitblock$1_0/a_11480_63# 0.00279f
C604 m1_n563_n5091# 1bitblock$1_0/a_11480_63# 0
C605 m2_5443_n3913# 1bitblock$3_0/a_7083_63# 0.00109f
C606 1bitblock$2_0/m2_24_342# 1bitblock$1_0/a_160_63# 0
C607 m1_8729_n3942# 1bitblock$1_0/m2_9431_79# 0.02467f
C608 m2_5443_n3913# m1_13543_n1146# 0.00329f
C609 1bitblock$2_0/a_2419_63# m2_1701_n784# 0
C610 m2_2396_n2595# 1bitblock$1_0/m2_9431_79# 0.0203f
C611 1bitblock$2_0/a_1845_466# m2_2396_n2595# 0.01396f
C612 m2_2396_n2595# 1bitblock$1_0/a_10906_n37# 0.00153f
C613 1bitblock$2_0/a_7410_63# m1_n563_n5091# 0
C614 1bitblock$2_0/a_510_63# 1bitblock$3_0/a_160_63# 0
C615 m1_n563_n5091# 1bitblock$1_0/a_3940_63# 0
C616 m2_14516_n651# 1bitblock$1_0/a_2419_63# 0.00162f
C617 MUX21_0/a_909_n37# m2_14516_n651# 0
C618 1bitblock$2_0/a_705_407# 1bitblock$3_0/a_1262_n37# 0
C619 m2_2396_n2595# 1bitblock$1_0/a_11480_63# 0.00982f
C620 m2_5443_n3913# 1bitblock_0/m2_6151_79# 0.01043f
C621 1bitblock$2_0/a_7410_63# m1_8729_n3942# 0.00637f
C622 1bitblock$2_0/a_7410_63# m2_2396_n2595# 0.00156f
C623 1bitblock$1_0/a_9609_407# 1bitblock$1_0/m2_7791_79# -0
C624 m2_5443_n3913# 1bitblock_0/a_3498_3# 0
C625 m2_5443_n3913# 1bitblock_0/a_2419_63# 0.00862f
C626 m2_14516_n651# 1bitblock$1_0/a_11480_63# 0
C627 1bitblock$1_0/m2_24_342# m1_14167_n1145# 0.00373f
C628 1bitblock$3_0/m2_7791_79# 1bitblock$3_0/m2_9431_79# -0.00447f
C629 m2_2396_n2595# 1bitblock$1_0/a_2861_391# 0.00705f
C630 m2_5443_n3913# 1bitblock$3_0/a_4650_n37# 0.00118f
C631 AND4_0/a_704_n441# m2_14516_n651# 0.00119f
C632 1bitblock$3_0/a_2419_63# m2_10721_n3315# 0.02948f
C633 1bitblock$3_0/a_705_407# m1_13543_n1146# 0.00558f
C634 1bitblock$1_0/a_5768_63# m2_1701_n784# 0
C635 m2_1701_n784# 1bitblock$1_0/m2_7791_79# 0
C636 m2_5443_n3913# 1bitblock_0/a_5042_407# 0.05822f
C637 1bitblock_0/a_510_63# 1bitblock$1_0/a_705_407# 0
C638 1bitblock_0/a_705_407# 1bitblock$1_0/a_510_63# 0
C639 1bitblock$3_0/a_10906_n37# m2_10721_n3315# 0.00484f
C640 MUX21_0/a_718_407# m1_12480_n3815# 0.00296f
C641 1bitblock$1_0/a_11922_3# m1_12486_242# 0.01722f
C642 1bitblock$3_0/a_1845_466# 1bitblock$3_0/a_3498_3# -0
C643 1bitblock$3_0/a_3498_3# m1_13543_n1146# 1.66674f
C644 m2_1701_n784# 1bitblock$1_0/a_9609_407# -0
C645 1bitblock$3_0/a_2419_63# m1_13543_n1146# 0.07504f
C646 1bitblock$1_0/m2_24_342# m1_n563_n5091# 0.03103f
C647 m2_5443_n3913# 1bitblock_0/a_3940_63# 0.00286f
C648 1bitblock$3_0/a_160_63# m1_13543_n1146# 0
C649 1bitblock$3_0/a_11480_63# m2_10721_n3315# 0.01269f
C650 m2_1701_n784# m1_12486_242# 0.92821f
C651 m2_5443_n3913# 1bitblock$3_0/a_4290_63# 0.00473f
C652 1bitblock$2_0/m2_6151_79# m2_5443_n3913# 0.01608f
C653 1bitblock_0/a_510_63# 1bitblock$1_0/a_160_63# 0
C654 1bitblock_0/a_160_63# 1bitblock$1_0/a_510_63# 0
C655 1bitblock$1_0/a_2419_63# 1bitblock$1_0/a_3940_63# -0
C656 MUX21_0/a_718_407# m1_15541_n412# 0
C657 m1_13543_n1146# 1bitblock$3_0/m2_9431_79# 0.0201f
C658 1bitblock$1_0/a_11922_391# m1_12486_242# 0.00397f
C659 1bitblock$3_0/a_10906_n37# m1_13543_n1146# 0.00152f
C660 1bitblock$2_0/a_3498_3# m2_5443_n3913# 0.05092f
C661 1bitblock_0/m2_24_342# m1_14167_n1145# 0.0031f
C662 m2_1701_n784# 1bitblock$1_0/a_8361_407# -0
C663 1bitblock$1_0/a_11922_3# m2_1701_n784# 0
C664 m1_8729_n3942# 1bitblock_0/a_7768_n37# 0
C665 m2_2396_n2595# 1bitblock$3_0/a_1845_n37# 0.00179f
C666 m2_1701_n784# 1bitblock$1_0/a_7083_63# 0.03418f
C667 1bitblock$3_0/m2_9431_79# 1bitblock$3_0/a_8723_63# -0
C668 1bitblock$1_0/m2_24_342# m2_2396_n2595# 0
C669 1bitblock$2_0/a_6721_407# m2_5443_n3913# 0.01358f
C670 m1_12480_n3815# m2_10721_n3315# 0.02463f
C671 1bitblock$3_0/a_11480_63# m1_13543_n1146# 0.0097f
C672 m1_12486_242# VSUBS 3.28362f
C673 1bitblock$1_0/a_7083_63# VSUBS 0.85222f
C674 1bitblock$1_0/a_8723_63# VSUBS 0.40722f
C675 1bitblock$1_0/m2_9431_79# VSUBS 0.62597f
C676 1bitblock$1_0/m2_7791_79# VSUBS 0.61991f
C677 1bitblock$1_0/a_9609_407# VSUBS 0.11896f
C678 1bitblock$1_0/a_8361_407# VSUBS 0.05045f
C679 1bitblock$1_0/m2_6151_79# VSUBS 0.6012f
C680 1bitblock$1_0/a_6721_407# VSUBS 0.01523f
C681 1bitblock$1_0/a_5042_407# VSUBS 0.79698f
C682 1bitblock$1_0/a_3940_63# VSUBS 0.46873f
C683 m2_1701_n784# VSUBS 7.90146f
C684 1bitblock$1_0/a_160_63# VSUBS 0.60582f
C685 1bitblock$1_0/a_5243_407# VSUBS 0.01459f
C686 1bitblock$1_0/a_705_407# VSUBS 0.14113f
C687 1bitblock$1_0/a_3498_3# VSUBS 1.27913f
C688 1bitblock$1_0/a_10906_n37# VSUBS 0.02232f
C689 1bitblock$1_0/a_9800_n37# VSUBS 0.01742f
C690 1bitblock$1_0/a_9408_n37# VSUBS 0.01326f
C691 1bitblock$1_0/a_8160_n37# VSUBS 0.01743f
C692 1bitblock$1_0/a_7768_n37# VSUBS 0.01327f
C693 1bitblock$1_0/a_6520_n37# VSUBS 0.01743f
C694 1bitblock$1_0/a_6128_n37# VSUBS 0.01327f
C695 1bitblock$1_0/a_5042_n37# VSUBS 0.01422f
C696 1bitblock$1_0/a_4650_n37# VSUBS 0.01569f
C697 1bitblock$1_0/a_11922_3# VSUBS 0.64605f
C698 1bitblock$1_0/a_11922_391# VSUBS 0.00119f
C699 1bitblock$1_0/a_10906_466# VSUBS 0.59827f
C700 1bitblock$1_0/a_11480_63# VSUBS 0.42359f
C701 1bitblock$1_0/a_10363_63# VSUBS 0.13924f
C702 1bitblock$1_0/a_9050_63# VSUBS 0.55145f
C703 1bitblock$1_0/a_7410_63# VSUBS 0.55612f
C704 1bitblock$1_0/a_5768_63# VSUBS 0.55881f
C705 1bitblock$1_0/a_1845_n37# VSUBS 0.01974f
C706 1bitblock$1_0/a_1262_n37# VSUBS 0.0127f
C707 1bitblock$1_0/a_870_n37# VSUBS 0.01586f
C708 1bitblock$1_0/a_4290_63# VSUBS 0.59067f
C709 1bitblock$1_0/a_2861_3# VSUBS 0.62907f
C710 1bitblock$1_0/a_1845_466# VSUBS 0.59871f
C711 1bitblock$1_0/a_2419_63# VSUBS 6.60418f
C712 1bitblock$1_0/a_510_63# VSUBS 0.58168f
C713 1bitblock$1_0/a_378_271# VSUBS 1.38973f
C714 1bitblock$1_0/m2_24_342# VSUBS 1.99971f
C715 m1_15541_n412# VSUBS 4.90501f
C716 1bitblock_0/a_7083_63# VSUBS 0.85222f
C717 1bitblock_0/a_8723_63# VSUBS 0.40569f
C718 1bitblock_0/m2_9431_79# VSUBS 0.62597f
C719 1bitblock_0/m2_7791_79# VSUBS 0.61991f
C720 1bitblock_0/a_8361_407# VSUBS 0.05045f
C721 1bitblock_0/m2_6151_79# VSUBS 0.6012f
C722 1bitblock_0/a_6721_407# VSUBS 0.01523f
C723 1bitblock_0/a_5042_407# VSUBS 0.79698f
C724 1bitblock_0/a_3940_63# VSUBS 0.46873f
C725 m1_14167_n1145# VSUBS 3.95124f
C726 1bitblock_0/a_160_63# VSUBS 0.59457f
C727 1bitblock_0/a_5243_407# VSUBS 0.01459f
C728 1bitblock_0/a_705_407# VSUBS 0.13654f
C729 1bitblock_0/a_3498_3# VSUBS 1.27913f
C730 1bitblock_0/a_10906_n37# VSUBS 0.02232f
C731 1bitblock_0/a_9800_n37# VSUBS 0.01742f
C732 1bitblock_0/a_9408_n37# VSUBS 0.01326f
C733 1bitblock_0/a_8160_n37# VSUBS 0.01743f
C734 1bitblock_0/a_7768_n37# VSUBS 0.01327f
C735 1bitblock_0/a_6520_n37# VSUBS 0.01743f
C736 1bitblock_0/a_6128_n37# VSUBS 0.01327f
C737 1bitblock_0/a_5042_n37# VSUBS 0.01422f
C738 1bitblock_0/a_4650_n37# VSUBS 0.01569f
C739 1bitblock_0/a_11922_3# VSUBS 0.64588f
C740 1bitblock_0/a_11922_391# VSUBS 0.00119f
C741 1bitblock_0/a_10906_466# VSUBS 0.59827f
C742 1bitblock_0/a_11480_63# VSUBS 0.42359f
C743 1bitblock_0/a_10363_63# VSUBS 0.13924f
C744 1bitblock_0/a_9050_63# VSUBS 0.55145f
C745 1bitblock_0/a_7410_63# VSUBS 0.55612f
C746 1bitblock_0/a_5768_63# VSUBS 0.55881f
C747 1bitblock_0/a_1845_n37# VSUBS 0.01974f
C748 1bitblock_0/a_1262_n37# VSUBS 0.0127f
C749 1bitblock_0/a_870_n37# VSUBS 0.01517f
C750 1bitblock_0/a_4290_63# VSUBS 0.59067f
C751 1bitblock_0/a_2861_3# VSUBS 0.62907f
C752 1bitblock_0/a_1845_466# VSUBS 0.5987f
C753 1bitblock_0/a_2419_63# VSUBS 6.63957f
C754 1bitblock_0/a_510_63# VSUBS 0.58009f
C755 1bitblock_0/a_378_271# VSUBS 1.3862f
C756 1bitblock_0/a_9609_407# VSUBS 0.11896f
C757 1bitblock_0/m2_24_342# VSUBS 1.9762f
C758 m2_10721_n3315# VSUBS 3.33193f
C759 1bitblock$3_0/a_7083_63# VSUBS 0.85964f
C760 1bitblock$3_0/a_8723_63# VSUBS 0.40583f
C761 1bitblock$3_0/m2_9431_79# VSUBS 0.62602f
C762 1bitblock$3_0/m2_7791_79# VSUBS 0.61996f
C763 1bitblock$3_0/a_9609_407# VSUBS 0.11896f
C764 1bitblock$3_0/a_8361_407# VSUBS 0.05045f
C765 1bitblock$3_0/m2_6151_79# VSUBS 0.60126f
C766 1bitblock$3_0/a_6721_407# VSUBS 0.01523f
C767 1bitblock$3_0/a_5042_407# VSUBS 0.80196f
C768 1bitblock$3_0/a_3940_63# VSUBS 0.46874f
C769 m1_13543_n1146# VSUBS 3.96884f
C770 1bitblock$3_0/a_160_63# VSUBS 0.60578f
C771 1bitblock$3_0/a_5243_407# VSUBS 0.01459f
C772 1bitblock$3_0/a_705_407# VSUBS 0.14117f
C773 1bitblock$3_0/a_3498_3# VSUBS 1.27919f
C774 1bitblock$3_0/a_10906_n37# VSUBS 0.02232f
C775 1bitblock$3_0/a_9800_n37# VSUBS 0.01742f
C776 1bitblock$3_0/a_9408_n37# VSUBS 0.01326f
C777 1bitblock$3_0/a_8160_n37# VSUBS 0.01743f
C778 1bitblock$3_0/a_7768_n37# VSUBS 0.01327f
C779 1bitblock$3_0/a_6520_n37# VSUBS 0.01743f
C780 1bitblock$3_0/a_6128_n37# VSUBS 0.01327f
C781 1bitblock$3_0/a_5042_n37# VSUBS 0.01422f
C782 1bitblock$3_0/a_4650_n37# VSUBS 0.01569f
C783 m1_12480_n3815# VSUBS 2.27952f
C784 1bitblock$3_0/a_11922_3# VSUBS 0.64588f
C785 1bitblock$3_0/a_11922_391# VSUBS 0.00119f
C786 1bitblock$3_0/a_10906_466# VSUBS 0.59833f
C787 1bitblock$3_0/a_11480_63# VSUBS 0.42359f
C788 1bitblock$3_0/a_10363_63# VSUBS 0.13924f
C789 1bitblock$3_0/a_9050_63# VSUBS 0.55151f
C790 m1_8729_n3942# VSUBS 2.90486f
C791 1bitblock$3_0/a_7410_63# VSUBS 0.55618f
C792 1bitblock$3_0/a_5768_63# VSUBS 0.55887f
C793 1bitblock$3_0/a_1845_n37# VSUBS 0.01974f
C794 1bitblock$3_0/a_1262_n37# VSUBS 0.0127f
C795 1bitblock$3_0/a_870_n37# VSUBS 0.01586f
C796 1bitblock$3_0/a_4290_63# VSUBS 0.59072f
C797 1bitblock$3_0/a_2861_3# VSUBS 0.62907f
C798 1bitblock$3_0/a_1845_466# VSUBS 0.59877f
C799 1bitblock$3_0/a_2419_63# VSUBS 6.72858f
C800 1bitblock$3_0/a_510_63# VSUBS 0.58169f
C801 1bitblock$3_0/a_378_271# VSUBS 1.3894f
C802 m1_n563_n5091# VSUBS 0.11782p
C803 m2_5443_n3913# VSUBS 5.24763f
C804 1bitblock$3_0/m2_24_342# VSUBS 2.00163f
C805 AND4_0/a_1120_n441# VSUBS 0.02626f
C806 AND4_0/a_912_n441# VSUBS 0.02949f
C807 AND4_0/a_704_n441# VSUBS 0.03642f
C808 m2_14516_n651# VSUBS 2.96054f
C809 AND4_0/a_518_229# VSUBS 0.81913f
C810 m1_12484_n953# VSUBS 3.35772f
C811 1bitblock$2_0/a_7083_63# VSUBS 0.85965f
C812 1bitblock$2_0/a_8723_63# VSUBS 0.40727f
C813 1bitblock$2_0/m2_9431_79# VSUBS 0.62602f
C814 1bitblock$2_0/m2_7791_79# VSUBS 0.61996f
C815 1bitblock$2_0/a_9609_407# VSUBS 0.11896f
C816 1bitblock$2_0/a_8361_407# VSUBS 0.05045f
C817 1bitblock$2_0/m2_6151_79# VSUBS 0.60126f
C818 1bitblock$2_0/a_6721_407# VSUBS 0.01523f
C819 1bitblock$2_0/a_5042_407# VSUBS 0.80196f
C820 1bitblock$2_0/a_3940_63# VSUBS 0.46875f
C821 m2_2396_n2595# VSUBS 3.96636f
C822 1bitblock$2_0/a_160_63# VSUBS 0.60571f
C823 1bitblock$2_0/a_5243_407# VSUBS 0.01459f
C824 1bitblock$2_0/a_705_407# VSUBS 0.14113f
C825 1bitblock$2_0/a_3498_3# VSUBS 1.27919f
C826 1bitblock$2_0/a_10906_n37# VSUBS 0.02232f
C827 1bitblock$2_0/a_9800_n37# VSUBS 0.01742f
C828 1bitblock$2_0/a_9408_n37# VSUBS 0.01326f
C829 1bitblock$2_0/a_8160_n37# VSUBS 0.01743f
C830 1bitblock$2_0/a_7768_n37# VSUBS 0.01327f
C831 1bitblock$2_0/a_6520_n37# VSUBS 0.01743f
C832 1bitblock$2_0/a_6128_n37# VSUBS 0.01327f
C833 1bitblock$2_0/a_5042_n37# VSUBS 0.01422f
C834 1bitblock$2_0/a_4650_n37# VSUBS 0.01569f
C835 1bitblock$2_0/a_11922_3# VSUBS 0.64587f
C836 1bitblock$2_0/a_11922_391# VSUBS 0.00119f
C837 1bitblock$2_0/a_10906_466# VSUBS 0.59833f
C838 1bitblock$2_0/a_11480_63# VSUBS 0.42359f
C839 1bitblock$2_0/a_10363_63# VSUBS 0.13924f
C840 1bitblock$2_0/a_9050_63# VSUBS 0.55151f
C841 1bitblock$2_0/a_7410_63# VSUBS 0.55618f
C842 1bitblock$2_0/a_5768_63# VSUBS 0.55887f
C843 1bitblock$2_0/a_1845_n37# VSUBS 0.01974f
C844 1bitblock$2_0/a_1262_n37# VSUBS 0.0127f
C845 1bitblock$2_0/a_870_n37# VSUBS 0.01586f
C846 1bitblock$2_0/a_4290_63# VSUBS 0.59072f
C847 1bitblock$2_0/a_2861_3# VSUBS 0.62907f
C848 1bitblock$2_0/a_1845_466# VSUBS 0.59875f
C849 1bitblock$2_0/a_2419_63# VSUBS 6.72858f
C850 1bitblock$2_0/a_510_63# VSUBS 0.58168f
C851 1bitblock$2_0/a_378_271# VSUBS 1.38936f
C852 1bitblock$2_0/m2_24_342# VSUBS 2.00127f
C853 MUX21_0/m2_540_79# VSUBS 0.82007f
C854 MUX21_0/a_718_407# VSUBS 0.15145f
C855 MUX21_0/a_909_n37# VSUBS 0.01743f
C856 MUX21_0/a_517_n37# VSUBS 0.01327f
C857 MUX21_0/a_1472_63# VSUBS 0.18031f
C858 MUX21_0/a_157_63# VSUBS 0.65278f
.ends

.subckt XOR$9 a_1262_n37# a_510_63# a_870_n37# a_160_63# a_104_n227# a_705_407# a_1015_n171#
+ m2_1295_79# via_dev$16_2/VSUBS a_378_271# w_n310_281#
X0 via_dev$16_2/VSUBS a_510_63# a_1262_n37# via_dev$16_2/VSUBS nfet_03v3 ad=0.65p pd=3.3u as=0.3625p ps=1.725u w=1u l=0.28u
X1 w_n310_281# a_378_271# a_705_407# w_n310_281# pfet_03v3 ad=0.725p pd=2.725u as=1.09p ps=5.09u w=2u l=0.28u
X2 a_705_407# a_510_63# m2_1295_79# w_n310_281# pfet_03v3 ad=1.3p pd=5.3u as=0.725p ps=2.725u w=2u l=0.28u
X3 a_160_63# a_104_n227# via_dev$16_2/VSUBS via_dev$16_2/VSUBS nfet_03v3 ad=0.315p pd=2.26u as=0.325p ps=2.3u w=0.5u l=0.28u
X4 a_510_63# a_378_271# w_n310_281# w_n310_281# pfet_03v3 ad=0.65p pd=3.3u as=0.56p ps=3.12u w=1u l=0.28u
X5 a_510_63# a_378_271# via_dev$16_2/VSUBS via_dev$16_2/VSUBS nfet_03v3 ad=0.315p pd=2.26u as=0.28p ps=2.12u w=0.5u l=0.28u
X6 a_1262_n37# a_160_63# m2_1295_79# via_dev$16_2/VSUBS nfet_03v3 ad=0.3625p pd=1.725u as=0.3375p ps=1.675u w=1u l=0.28u
X7 a_160_63# a_104_n227# w_n310_281# w_n310_281# pfet_03v3 ad=0.63p pd=3.26u as=0.65p ps=3.3u w=1u l=0.28u
X8 m2_1295_79# a_160_63# a_705_407# w_n310_281# pfet_03v3 ad=0.725p pd=2.725u as=0.675p ps=2.675u w=2u l=0.28u
X9 m2_1295_79# a_1015_n171# a_870_n37# via_dev$16_2/VSUBS nfet_03v3 ad=0.3375p pd=1.675u as=0.3625p ps=1.725u w=1u l=0.28u
X10 a_705_407# a_1015_n171# w_n310_281# w_n310_281# pfet_03v3 ad=0.675p pd=2.675u as=0.725p ps=2.725u w=2u l=0.28u
X11 a_870_n37# a_378_271# via_dev$16_2/VSUBS via_dev$16_2/VSUBS nfet_03v3 ad=0.3625p pd=1.725u as=0.54p ps=3.08u w=1u l=0.28u
C0 a_160_63# a_378_271# 0.07327f
C1 m2_1295_79# a_378_271# 0.00522f
C2 a_705_407# a_378_271# 0.02752f
C3 w_n310_281# a_378_271# 0.45624f
C4 a_1015_n171# a_378_271# 0.04852f
C5 a_104_n227# a_160_63# 0.06988f
C6 a_104_n227# m2_1295_79# 0
C7 a_104_n227# a_705_407# 0
C8 a_510_63# a_378_271# 0.10942f
C9 a_104_n227# w_n310_281# 0.24415f
C10 a_104_n227# a_1015_n171# 0.00464f
C11 a_104_n227# a_510_63# 0
C12 a_1262_n37# m2_1295_79# 0.01511f
C13 a_1262_n37# a_705_407# 0
C14 a_160_63# m2_1295_79# 0.09629f
C15 a_705_407# a_160_63# 0.0958f
C16 a_705_407# m2_1295_79# 0.33758f
C17 a_1262_n37# a_510_63# 0.00898f
C18 a_160_63# w_n310_281# 0.33031f
C19 m2_1295_79# w_n310_281# 0.16742f
C20 a_705_407# w_n310_281# 0.66291f
C21 a_160_63# a_1015_n171# 0.11782f
C22 m2_1295_79# a_1015_n171# 0.01497f
C23 a_160_63# a_870_n37# 0.00441f
C24 a_705_407# a_1015_n171# 0.03374f
C25 m2_1295_79# a_870_n37# 0.00639f
C26 a_1015_n171# w_n310_281# 0.19061f
C27 a_160_63# a_510_63# 0.29647f
C28 m2_1295_79# a_510_63# 0.48501f
C29 a_705_407# a_510_63# 0.13798f
C30 a_510_63# w_n310_281# 0.26525f
C31 a_510_63# a_1015_n171# 0.07629f
C32 a_870_n37# a_510_63# 0.01502f
C33 a_104_n227# a_378_271# 0.02445f
C34 m2_1295_79# via_dev$16_2/VSUBS 0.49506f
C35 a_160_63# via_dev$16_2/VSUBS 0.65127f
C36 a_705_407# via_dev$16_2/VSUBS 0.19588f
C37 a_1262_n37# via_dev$16_2/VSUBS 0.0069f
C38 a_870_n37# via_dev$16_2/VSUBS 0.01517f
C39 a_510_63# via_dev$16_2/VSUBS 0.60964f
C40 a_378_271# via_dev$16_2/VSUBS 0.59801f
C41 w_n310_281# via_dev$16_2/VSUBS 4.3896f
C42 a_1015_n171# via_dev$16_2/VSUBS 0.25952f
C43 a_104_n227# via_dev$16_2/VSUBS 0.47666f
.ends

.subckt x1bitblock$3$2 a_2861_3# a_8361_407# a_6520_n37# a_1262_n37# a_2861_391# a_1845_466#
+ a_10906_n37# a_510_63# a_870_n37# a_6721_407# a_9800_n37# a_11480_63# a_6128_n37#
+ a_5768_63# m2_6151_79# a_11922_391# a_5042_n37# a_9408_n37# a_9609_407# a_5042_407#
+ a_8160_n37# a_4158_271# a_11922_3# a_8918_358# a_2419_63# m2_9431_79# a_10906_466#
+ a_4650_n37# a_9050_63# a_5243_407# a_7768_n37# a_3940_63# m2_7791_79# a_10363_63#
+ a_160_63# a_4290_63# a_7083_63# a_705_407# a_12559_3# a_7410_63# a_1845_n37# m2_5700_324#
+ via_dev$5$3$2_9/VSUBS a_3498_3# m2_1295_79# a_8723_63# a_378_271# w_n310_281# m2_24_342#
X0 a_2419_63# a_1845_466# via_dev$5$3$2_9/VSUBS via_dev$5$3$2_9/VSUBS nfet_03v3 ad=0.315p pd=2.26u as=0.2425p ps=1.97u w=0.5u l=0.28u
X1 a_1845_466# m2_24_342# a_1845_n37# via_dev$5$3$2_9/VSUBS nfet_03v3 ad=0.65p pd=3.3u as=0.42p ps=1.84u w=1u l=0.28u
X2 a_3940_63# m2_1295_79# w_n310_281# w_n310_281# pfet_03v3 ad=0.63p pd=3.26u as=0.65p ps=3.3u w=1u l=0.28u
X3 via_dev$5$3$2_9/VSUBS a_510_63# a_1262_n37# via_dev$5$3$2_9/VSUBS nfet_03v3 ad=0.65p pd=3.3u as=0.3625p ps=1.725u w=1u l=0.28u
X4 a_5243_407# a_4290_63# a_5042_407# w_n310_281# pfet_03v3 ad=1.3p pd=5.3u as=0.725p ps=2.725u w=2u l=0.28u
X5 a_6721_407# a_2419_63# m2_6151_79# w_n310_281# pfet_03v3 ad=0.675p pd=2.675u as=0.725p ps=2.725u w=2u l=0.28u
X6 a_10906_466# a_4158_271# w_n310_281# w_n310_281# pfet_03v3 ad=0.42p pd=1.84u as=0.65p ps=3.3u w=1u l=0.28u
X7 a_4290_63# a_4158_271# via_dev$5$3$2_9/VSUBS via_dev$5$3$2_9/VSUBS nfet_03v3 ad=0.315p pd=2.26u as=0.28p ps=2.12u w=0.5u l=0.28u
X8 w_n310_281# a_378_271# a_705_407# w_n310_281# pfet_03v3 ad=0.725p pd=2.725u as=1.09p ps=5.09u w=2u l=0.28u
X9 a_2861_3# m2_1295_79# via_dev$5$3$2_9/VSUBS via_dev$5$3$2_9/VSUBS nfet_03v3 ad=0.18125p pd=1.225u as=0.325p ps=2.3u w=0.5u l=0.28u
X10 via_dev$5$3$2_9/VSUBS a_2419_63# a_2861_3# via_dev$5$3$2_9/VSUBS nfet_03v3 ad=0.315p pd=2.26u as=0.18125p ps=1.225u w=0.5u l=0.28u
X11 m2_7791_79# m2_1295_79# a_7768_n37# via_dev$5$3$2_9/VSUBS nfet_03v3 ad=0.3375p pd=1.675u as=0.3625p ps=1.725u w=1u l=0.28u
X12 a_10906_n37# a_4158_271# via_dev$5$3$2_9/VSUBS via_dev$5$3$2_9/VSUBS nfet_03v3 ad=0.42p pd=1.84u as=0.63p ps=3.26u w=1u l=0.28u
X13 a_9050_63# a_8918_358# via_dev$5$3$2_9/VSUBS via_dev$5$3$2_9/VSUBS nfet_03v3 ad=0.31p pd=2.24u as=0.24p ps=1.96u w=0.5u l=0.28u
X14 a_11922_3# a_11480_63# via_dev$5$3$2_9/VSUBS via_dev$5$3$2_9/VSUBS nfet_03v3 ad=0.18125p pd=1.225u as=0.325p ps=2.3u w=0.5u l=0.28u
X15 via_dev$5$3$2_9/VSUBS a_2419_63# a_11922_3# via_dev$5$3$2_9/VSUBS nfet_03v3 ad=0.315p pd=2.26u as=0.18125p ps=1.225u w=0.5u l=0.28u
X16 a_705_407# a_510_63# m2_1295_79# w_n310_281# pfet_03v3 ad=1.3p pd=5.3u as=0.725p ps=2.725u w=2u l=0.28u
X17 a_4650_n37# a_4158_271# via_dev$5$3$2_9/VSUBS via_dev$5$3$2_9/VSUBS nfet_03v3 ad=0.3625p pd=1.725u as=0.54p ps=3.08u w=1u l=0.28u
X18 a_2861_3# a_2419_63# a_2861_391# w_n310_281# pfet_03v3 ad=1.3p pd=5.3u as=0.725p ps=2.725u w=2u l=0.28u
X19 a_5768_63# m2_5700_324# via_dev$5$3$2_9/VSUBS via_dev$5$3$2_9/VSUBS nfet_03v3 ad=0.315p pd=2.26u as=0.3175p ps=2.27u w=0.5u l=0.28u
X20 via_dev$5$3$2_9/VSUBS a_9050_63# a_9800_n37# via_dev$5$3$2_9/VSUBS nfet_03v3 ad=0.65p pd=3.3u as=0.3625p ps=1.725u w=1u l=0.28u
X21 a_8361_407# m2_1295_79# m2_7791_79# w_n310_281# pfet_03v3 ad=0.675p pd=2.675u as=0.725p ps=2.725u w=2u l=0.28u
X22 a_9408_n37# a_8918_358# via_dev$5$3$2_9/VSUBS via_dev$5$3$2_9/VSUBS nfet_03v3 ad=0.3625p pd=1.725u as=0.54p ps=3.08u w=1u l=0.28u
X23 a_3498_3# a_2861_3# w_n310_281# w_n310_281# pfet_03v3 ad=0.65p pd=3.3u as=0.675p ps=3.35u w=1u l=0.28u
X24 a_7410_63# m2_5700_324# via_dev$5$3$2_9/VSUBS via_dev$5$3$2_9/VSUBS nfet_03v3 ad=0.31p pd=2.24u as=0.24p ps=1.96u w=0.5u l=0.28u
X25 via_dev$5$3$2_9/VSUBS a_7410_63# a_8160_n37# via_dev$5$3$2_9/VSUBS nfet_03v3 ad=0.65p pd=3.3u as=0.3625p ps=1.725u w=1u l=0.28u
X26 a_8723_63# m2_7791_79# via_dev$5$3$2_9/VSUBS via_dev$5$3$2_9/VSUBS nfet_03v3 ad=0.2625p pd=2.05u as=0.265p ps=2.06u w=0.5u l=0.28u
X27 w_n310_281# a_4158_271# a_5243_407# w_n310_281# pfet_03v3 ad=0.725p pd=2.725u as=1.09p ps=5.09u w=2u l=0.28u
X28 a_5768_63# m2_5700_324# w_n310_281# w_n310_281# pfet_03v3 ad=0.65p pd=3.3u as=0.635p ps=3.27u w=1u l=0.28u
X29 a_9050_63# a_8918_358# w_n310_281# w_n310_281# pfet_03v3 ad=0.64p pd=3.28u as=0.48p ps=2.96u w=1u l=0.28u
X30 a_11922_391# a_11480_63# w_n310_281# w_n310_281# pfet_03v3 ad=0.725p pd=2.725u as=1.3p ps=5.3u w=2u l=0.28u
X31 a_160_63# m2_24_342# via_dev$5$3$2_9/VSUBS via_dev$5$3$2_9/VSUBS nfet_03v3 ad=0.315p pd=2.26u as=0.325p ps=2.3u w=0.5u l=0.28u
X32 a_9609_407# a_9050_63# w_n310_281# w_n310_281# pfet_03v3 ad=1.3p pd=5.3u as=0.725p ps=2.725u w=2u l=0.28u
X33 a_6128_n37# m2_5700_324# via_dev$5$3$2_9/VSUBS via_dev$5$3$2_9/VSUBS nfet_03v3 ad=0.3625p pd=1.725u as=0.54p ps=3.08u w=1u l=0.28u
X34 via_dev$5$3$2_9/VSUBS a_5768_63# a_6520_n37# via_dev$5$3$2_9/VSUBS nfet_03v3 ad=0.65p pd=3.3u as=0.3625p ps=1.725u w=1u l=0.28u
X35 a_7410_63# m2_5700_324# w_n310_281# w_n310_281# pfet_03v3 ad=0.64p pd=3.28u as=0.48p ps=2.96u w=1u l=0.28u
X36 m2_9431_79# a_8918_358# a_9609_407# w_n310_281# pfet_03v3 ad=0.725p pd=2.725u as=1.09p ps=5.09u w=2u l=0.28u
X37 a_11480_63# a_10906_466# via_dev$5$3$2_9/VSUBS via_dev$5$3$2_9/VSUBS nfet_03v3 ad=0.315p pd=2.26u as=0.2425p ps=1.97u w=0.5u l=0.28u
X38 a_1845_466# a_378_271# w_n310_281# w_n310_281# pfet_03v3 ad=0.42p pd=1.84u as=0.65p ps=3.3u w=1u l=0.28u
X39 a_8361_407# a_7410_63# w_n310_281# w_n310_281# pfet_03v3 ad=1.3p pd=5.3u as=0.725p ps=2.725u w=2u l=0.28u
X40 w_n310_281# m2_1295_79# a_10906_466# w_n310_281# pfet_03v3 ad=0.735p pd=2.47u as=0.42p ps=1.84u w=1u l=0.28u
X41 a_7083_63# m2_6151_79# via_dev$5$3$2_9/VSUBS via_dev$5$3$2_9/VSUBS nfet_03v3 ad=0.2625p pd=2.05u as=0.265p ps=2.06u w=0.5u l=0.28u
X42 a_510_63# a_378_271# w_n310_281# w_n310_281# pfet_03v3 ad=0.65p pd=3.3u as=0.56p ps=3.12u w=1u l=0.28u
X43 a_10363_63# m2_9431_79# w_n310_281# w_n310_281# pfet_03v3 ad=0.715p pd=3.43u as=0.53p ps=3.06u w=1u l=0.28u
X44 a_510_63# a_378_271# via_dev$5$3$2_9/VSUBS via_dev$5$3$2_9/VSUBS nfet_03v3 ad=0.315p pd=2.26u as=0.28p ps=2.12u w=0.5u l=0.28u
X45 a_1262_n37# a_160_63# m2_1295_79# via_dev$5$3$2_9/VSUBS nfet_03v3 ad=0.3625p pd=1.725u as=0.3375p ps=1.675u w=1u l=0.28u
X46 a_1845_n37# a_378_271# via_dev$5$3$2_9/VSUBS via_dev$5$3$2_9/VSUBS nfet_03v3 ad=0.42p pd=1.84u as=0.63p ps=3.26u w=1u l=0.28u
X47 m2_6151_79# m2_5700_324# a_6721_407# w_n310_281# pfet_03v3 ad=0.725p pd=2.725u as=1.09p ps=5.09u w=2u l=0.28u
X48 a_6721_407# a_5768_63# w_n310_281# w_n310_281# pfet_03v3 ad=1.3p pd=5.3u as=0.725p ps=2.725u w=2u l=0.28u
X49 a_10363_63# m2_9431_79# via_dev$5$3$2_9/VSUBS via_dev$5$3$2_9/VSUBS nfet_03v3 ad=0.3575p pd=2.43u as=0.265p ps=2.06u w=0.5u l=0.28u
X50 a_10906_466# m2_1295_79# a_10906_n37# via_dev$5$3$2_9/VSUBS nfet_03v3 ad=0.65p pd=3.3u as=0.42p ps=1.84u w=1u l=0.28u
X51 a_8723_63# m2_7791_79# w_n310_281# w_n310_281# pfet_03v3 ad=0.545p pd=3.09u as=0.53p ps=3.06u w=1u l=0.28u
X52 a_11480_63# a_10906_466# w_n310_281# w_n310_281# pfet_03v3 ad=0.65p pd=3.3u as=0.735p ps=2.47u w=1u l=0.28u
X53 a_12559_3# a_11922_3# via_dev$5$3$2_9/VSUBS via_dev$5$3$2_9/VSUBS nfet_03v3 ad=0.315p pd=2.26u as=0.325p ps=2.3u w=0.5u l=0.28u
X54 a_7083_63# m2_6151_79# w_n310_281# w_n310_281# pfet_03v3 ad=0.545p pd=3.09u as=0.53p ps=3.06u w=1u l=0.28u
X55 a_7768_n37# m2_5700_324# via_dev$5$3$2_9/VSUBS via_dev$5$3$2_9/VSUBS nfet_03v3 ad=0.3625p pd=1.725u as=0.54p ps=3.08u w=1u l=0.28u
X56 a_160_63# m2_24_342# w_n310_281# w_n310_281# pfet_03v3 ad=0.63p pd=3.26u as=0.65p ps=3.3u w=1u l=0.28u
X57 m2_1295_79# a_160_63# a_705_407# w_n310_281# pfet_03v3 ad=0.725p pd=2.725u as=0.675p ps=2.675u w=2u l=0.28u
X58 a_5042_n37# a_3940_63# a_5042_407# via_dev$5$3$2_9/VSUBS nfet_03v3 ad=0.3625p pd=1.725u as=0.3375p ps=1.675u w=1u l=0.28u
X59 m2_1295_79# m2_24_342# a_870_n37# via_dev$5$3$2_9/VSUBS nfet_03v3 ad=0.3375p pd=1.675u as=0.3625p ps=1.725u w=1u l=0.28u
X60 a_11922_3# a_2419_63# a_11922_391# w_n310_281# pfet_03v3 ad=1.3p pd=5.3u as=0.725p ps=2.725u w=2u l=0.28u
X61 a_9800_n37# a_7083_63# m2_9431_79# via_dev$5$3$2_9/VSUBS nfet_03v3 ad=0.3625p pd=1.725u as=0.3375p ps=1.675u w=1u l=0.28u
X62 m2_7791_79# m2_5700_324# a_8361_407# w_n310_281# pfet_03v3 ad=0.725p pd=2.725u as=1.09p ps=5.09u w=2u l=0.28u
X63 a_5042_407# a_3940_63# a_5243_407# w_n310_281# pfet_03v3 ad=0.725p pd=2.725u as=0.675p ps=2.675u w=2u l=0.28u
X64 a_3940_63# m2_1295_79# via_dev$5$3$2_9/VSUBS via_dev$5$3$2_9/VSUBS nfet_03v3 ad=0.315p pd=2.26u as=0.325p ps=2.3u w=0.5u l=0.28u
X65 a_8160_n37# a_3498_3# m2_7791_79# via_dev$5$3$2_9/VSUBS nfet_03v3 ad=0.3625p pd=1.725u as=0.3375p ps=1.675u w=1u l=0.28u
X66 a_705_407# m2_24_342# w_n310_281# w_n310_281# pfet_03v3 ad=0.675p pd=2.675u as=0.725p ps=2.725u w=2u l=0.28u
X67 a_5042_407# m2_1295_79# a_4650_n37# via_dev$5$3$2_9/VSUBS nfet_03v3 ad=0.3375p pd=1.675u as=0.3625p ps=1.725u w=1u l=0.28u
X68 a_6520_n37# a_5042_407# m2_6151_79# via_dev$5$3$2_9/VSUBS nfet_03v3 ad=0.3625p pd=1.725u as=0.3375p ps=1.675u w=1u l=0.28u
X69 w_n310_281# a_7083_63# a_9609_407# w_n310_281# pfet_03v3 ad=0.725p pd=2.725u as=0.675p ps=2.675u w=2u l=0.28u
X70 a_2419_63# a_1845_466# w_n310_281# w_n310_281# pfet_03v3 ad=0.65p pd=3.3u as=0.735p ps=2.47u w=1u l=0.28u
X71 m2_9431_79# a_8723_63# a_9408_n37# via_dev$5$3$2_9/VSUBS nfet_03v3 ad=0.3375p pd=1.675u as=0.3625p ps=1.725u w=1u l=0.28u
X72 w_n310_281# a_3498_3# a_8361_407# w_n310_281# pfet_03v3 ad=0.725p pd=2.725u as=0.675p ps=2.675u w=2u l=0.28u
X73 a_2861_391# m2_1295_79# w_n310_281# w_n310_281# pfet_03v3 ad=0.725p pd=2.725u as=1.3p ps=5.3u w=2u l=0.28u
X74 a_4290_63# a_4158_271# w_n310_281# w_n310_281# pfet_03v3 ad=0.65p pd=3.3u as=0.56p ps=3.12u w=1u l=0.28u
X75 a_5243_407# m2_1295_79# w_n310_281# w_n310_281# pfet_03v3 ad=0.675p pd=2.675u as=0.725p ps=2.725u w=2u l=0.28u
X76 w_n310_281# a_5042_407# a_6721_407# w_n310_281# pfet_03v3 ad=0.725p pd=2.725u as=0.675p ps=2.675u w=2u l=0.28u
X77 a_3498_3# a_2861_3# via_dev$5$3$2_9/VSUBS via_dev$5$3$2_9/VSUBS nfet_03v3 ad=0.315p pd=2.26u as=0.325p ps=2.3u w=0.5u l=0.28u
X78 a_9609_407# a_8723_63# m2_9431_79# w_n310_281# pfet_03v3 ad=0.675p pd=2.675u as=0.725p ps=2.725u w=2u l=0.28u
X79 via_dev$5$3$2_9/VSUBS a_4290_63# a_5042_n37# via_dev$5$3$2_9/VSUBS nfet_03v3 ad=0.65p pd=3.3u as=0.3625p ps=1.725u w=1u l=0.28u
X80 m2_6151_79# a_2419_63# a_6128_n37# via_dev$5$3$2_9/VSUBS nfet_03v3 ad=0.3375p pd=1.675u as=0.3625p ps=1.725u w=1u l=0.28u
X81 w_n310_281# m2_24_342# a_1845_466# w_n310_281# pfet_03v3 ad=0.735p pd=2.47u as=0.42p ps=1.84u w=1u l=0.28u
X82 a_870_n37# a_378_271# via_dev$5$3$2_9/VSUBS via_dev$5$3$2_9/VSUBS nfet_03v3 ad=0.3625p pd=1.725u as=0.54p ps=3.08u w=1u l=0.28u
X83 a_12559_3# a_11922_3# w_n310_281# w_n310_281# pfet_03v3 ad=0.65p pd=3.3u as=0.675p ps=3.35u w=1u l=0.28u
C0 a_11480_63# a_4158_271# 0.00295f
C1 w_n310_281# a_8361_407# 0.75753f
C2 w_n310_281# m2_6151_79# 0.44301f
C3 a_3498_3# a_8361_407# 0.12093f
C4 a_3498_3# m2_6151_79# 0
C5 a_7083_63# a_8918_358# 0.01057f
C6 a_4158_271# a_10906_466# 0.03873f
C7 a_8361_407# a_7083_63# 0.01453f
C8 m2_6151_79# a_7083_63# 0.08089f
C9 a_11922_3# a_2419_63# 0.16984f
C10 a_11922_3# w_n310_281# 0.46598f
C11 a_8361_407# a_8918_358# 0
C12 a_160_63# m2_1295_79# 0.09339f
C13 m2_1295_79# a_5042_407# 0.03487f
C14 a_4290_63# a_5042_n37# 0.00898f
C15 a_5768_63# a_4158_271# 0.00573f
C16 m2_9431_79# a_8723_63# 0.13485f
C17 a_10363_63# m2_1295_79# 0.00179f
C18 m2_5700_324# a_5042_407# 0.06917f
C19 a_160_63# a_705_407# 0.06737f
C20 a_1845_n37# m2_1295_79# 0.00942f
C21 m2_1295_79# m2_7791_79# 0.05731f
C22 m2_1295_79# a_5243_407# 0.10989f
C23 a_5042_n37# a_4158_271# 0
C24 a_4290_63# a_5042_407# 0.38112f
C25 a_6128_n37# a_6721_407# 0
C26 m2_1295_79# a_1845_466# 0.09644f
C27 a_5042_407# a_2861_3# 0
C28 a_7083_63# a_9800_n37# 0.00527f
C29 m2_5700_324# m2_7791_79# 0.05245f
C30 a_7410_63# a_8723_63# 0.01398f
C31 m2_5700_324# a_5243_407# 0.01927f
C32 a_510_63# a_378_271# 0.14298f
C33 a_9050_63# a_10363_63# 0.01385f
C34 a_3940_63# a_4650_n37# 0.00441f
C35 a_10363_63# a_9609_407# 0.01306f
C36 a_5042_407# a_4158_271# 0.63867f
C37 a_705_407# a_1845_466# 0.0126f
C38 a_4290_63# a_5243_407# 0.14023f
C39 w_n310_281# a_510_63# 0.28255f
C40 a_2419_63# a_8723_63# 0.00649f
C41 a_9050_63# m2_7791_79# 0.00127f
C42 m2_9431_79# m2_1295_79# 0.0078f
C43 a_378_271# m2_24_342# 0.56715f
C44 a_10363_63# a_11480_63# 0
C45 a_9609_407# m2_7791_79# 0
C46 a_2861_3# a_5243_407# 0
C47 w_n310_281# a_8723_63# 0.33519f
C48 a_3498_3# a_8723_63# 0.00575f
C49 m2_24_342# a_2419_63# 0.00234f
C50 a_10363_63# a_10906_466# 0.02047f
C51 a_5768_63# a_5042_407# 0.22596f
C52 a_2861_3# a_1845_466# 0
C53 a_7083_63# a_8723_63# 0.15796f
C54 w_n310_281# m2_24_342# 0.66878f
C55 a_3498_3# m2_24_342# 0
C56 a_10363_63# a_4158_271# 0.02222f
C57 a_8723_63# a_8918_358# 0.12497f
C58 a_3940_63# m2_1295_79# 0.46061f
C59 a_8361_407# a_8723_63# 0.01268f
C60 a_9408_n37# m2_7791_79# 0
C61 a_4158_271# m2_7791_79# 0
C62 a_2861_391# m2_1295_79# 0.00841f
C63 a_4158_271# a_5243_407# 0.02964f
C64 a_870_n37# a_510_63# 0.01502f
C65 a_12559_3# a_10906_466# 0
C66 a_6520_n37# a_4158_271# 0.00406f
C67 a_10906_n37# a_10906_466# 0.01333f
C68 a_5042_n37# a_5042_407# 0.01726f
C69 a_5768_63# m2_7791_79# 0
C70 a_10906_n37# a_4158_271# 0.00824f
C71 a_5768_63# a_5243_407# 0.00722f
C72 a_2419_63# a_6721_407# 0.01825f
C73 m2_5700_324# a_3940_63# 0.00132f
C74 w_n310_281# a_6721_407# 0.72579f
C75 a_3498_3# a_6721_407# 0
C76 a_9050_63# m2_9431_79# 0.328f
C77 a_7410_63# m2_1295_79# 0.07614f
C78 a_11922_391# a_11480_63# 0.00152f
C79 m2_9431_79# a_9609_407# 0.49779f
C80 a_6520_n37# a_5768_63# 0.01329f
C81 a_7083_63# a_6721_407# 0.01268f
C82 a_4290_63# a_3940_63# 0.28903f
C83 a_2861_391# a_705_407# 0
C84 m2_9431_79# a_11480_63# 0
C85 m2_6151_79# a_6721_407# 0.4935f
C86 a_378_271# m2_1295_79# 0.02669f
C87 a_1262_n37# a_510_63# 0.00898f
C88 m2_9431_79# a_10906_466# 0.00167f
C89 a_3940_63# a_2861_3# 0
C90 m2_1295_79# a_2419_63# 0.3246f
C91 a_9408_n37# m2_9431_79# 0.01733f
C92 a_5768_63# a_6128_n37# 0.00935f
C93 m2_9431_79# a_4158_271# 0.05572f
C94 w_n310_281# m2_1295_79# 2.35222f
C95 a_5042_n37# a_5243_407# 0
C96 a_2861_391# a_2861_3# 0.01616f
C97 a_7410_63# m2_5700_324# 0.14432f
C98 a_3498_3# m2_1295_79# 0.3391f
C99 a_7083_63# m2_1295_79# 0.01071f
C100 m2_1295_79# a_8918_358# 0.01371f
C101 a_8361_407# m2_1295_79# 0.02509f
C102 m2_6151_79# m2_1295_79# 0.00667f
C103 a_3940_63# a_4158_271# 0.16366f
C104 m2_5700_324# a_2419_63# 0.074f
C105 a_378_271# a_705_407# 0.02817f
C106 w_n310_281# m2_5700_324# 1.65678f
C107 a_3498_3# m2_5700_324# 0.55174f
C108 a_11922_3# m2_1295_79# 0
C109 a_2419_63# a_705_407# 0
C110 a_5042_407# m2_7791_79# 0.00555f
C111 a_7083_63# m2_5700_324# 0.12051f
C112 a_870_n37# m2_1295_79# 0.00639f
C113 a_5768_63# a_3940_63# 0
C114 a_4290_63# a_2419_63# 0.00652f
C115 w_n310_281# a_705_407# 0.79414f
C116 a_160_63# a_1845_466# 0
C117 a_5042_407# a_5243_407# 0.29512f
C118 a_4290_63# w_n310_281# 0.2819f
C119 a_4290_63# a_3498_3# 0.00876f
C120 m2_5700_324# a_8918_358# 0
C121 a_8361_407# m2_5700_324# 0.05956f
C122 m2_6151_79# m2_5700_324# 0.14941f
C123 a_2861_3# a_2419_63# 0.21478f
C124 a_6520_n37# a_5042_407# 0.00483f
C125 a_9050_63# a_2419_63# 0.00801f
C126 a_9609_407# a_2419_63# 0
C127 a_7410_63# a_4158_271# 0
C128 w_n310_281# a_2861_3# 0.4655f
C129 a_9050_63# w_n310_281# 0.28931f
C130 a_510_63# m2_24_342# 0.13025f
C131 a_3498_3# a_2861_3# 0.09846f
C132 w_n310_281# a_9609_407# 0.7653f
C133 a_4290_63# m2_6151_79# 0
C134 a_9050_63# a_7083_63# 0.21474f
C135 a_7083_63# a_9609_407# 0.0285f
C136 a_11480_63# a_2419_63# 0.0769f
C137 w_n310_281# a_11480_63# 0.37298f
C138 a_2419_63# a_10906_466# 0.00833f
C139 a_9050_63# a_8918_358# 0.09973f
C140 a_9050_63# a_8361_407# 0
C141 a_9609_407# a_8918_358# 0.02942f
C142 a_6128_n37# a_5042_407# 0.00376f
C143 w_n310_281# a_10906_466# 0.44509f
C144 a_8361_407# a_9609_407# 0.00466f
C145 a_2419_63# a_4158_271# 0.14782f
C146 a_1845_n37# a_1845_466# 0.01333f
C147 a_10906_n37# a_10363_63# 0
C148 a_1262_n37# m2_1295_79# 0.01607f
C149 w_n310_281# a_4158_271# 0.66883f
C150 a_7083_63# a_10906_466# 0
C151 a_3498_3# a_4158_271# 0.00829f
C152 a_9408_n37# a_7083_63# 0.00336f
C153 a_7083_63# a_4158_271# 1.09133f
C154 a_7768_n37# m2_7791_79# 0.01733f
C155 a_5768_63# a_2419_63# 0.07749f
C156 a_4158_271# a_8918_358# 0.00101f
C157 w_n310_281# a_5768_63# 0.31314f
C158 a_3498_3# a_5768_63# 0
C159 m2_6151_79# a_4158_271# 0.04334f
C160 a_11922_3# a_11480_63# 0.04054f
C161 a_7083_63# a_5768_63# 0.01494f
C162 a_11922_3# a_10906_466# 0
C163 m2_9431_79# a_10363_63# 0.07766f
C164 a_3940_63# a_5042_407# 0.0941f
C165 a_11922_3# a_4158_271# 0.0013f
C166 m2_6151_79# a_5768_63# 0.35511f
C167 a_1262_n37# a_705_407# 0
C168 m2_9431_79# m2_7791_79# 0.01571f
C169 a_510_63# m2_1295_79# 0.39896f
C170 m2_1295_79# a_8723_63# 0.00796f
C171 m2_24_342# m2_1295_79# 0.04399f
C172 a_7768_n37# m2_9431_79# 0
C173 a_7410_63# a_5042_407# 0
C174 a_8160_n37# m2_7791_79# 0.01048f
C175 a_9050_63# a_9800_n37# 0.01329f
C176 m2_6151_79# a_5042_n37# 0
C177 a_3940_63# a_5243_407# 0.06737f
C178 a_3940_63# a_1845_466# 0
C179 a_160_63# a_378_271# 0.09182f
C180 a_510_63# a_705_407# 0.13828f
C181 m2_5700_324# a_8723_63# 0
C182 w_n310_281# a_160_63# 0.30515f
C183 a_5042_407# a_2419_63# 0.08051f
C184 w_n310_281# a_5042_407# 0.29911f
C185 a_3498_3# a_5042_407# 0.02015f
C186 a_4158_271# a_9800_n37# 0.00497f
C187 a_7083_63# a_5042_407# 0.02611f
C188 m2_24_342# a_705_407# 0.10607f
C189 a_7410_63# m2_7791_79# 0.36168f
C190 m2_1295_79# a_6721_407# 0.00452f
C191 a_9050_63# a_8723_63# 0.52788f
C192 a_10363_63# a_2419_63# 0.00126f
C193 a_9609_407# a_8723_63# 0.0593f
C194 m2_6151_79# a_5042_407# 0.20459f
C195 w_n310_281# a_10363_63# 0.15741f
C196 a_7768_n37# a_7410_63# 0.00935f
C197 a_10363_63# a_7083_63# 0.00582f
C198 a_8160_n37# m2_9431_79# 0
C199 a_2419_63# m2_7791_79# 0.00843f
C200 a_870_n37# a_160_63# 0.00441f
C201 a_1845_n37# w_n310_281# 0
C202 a_378_271# a_1845_466# 0.01278f
C203 a_2419_63# a_5243_407# 0
C204 w_n310_281# m2_7791_79# 0.45142f
C205 a_3498_3# m2_7791_79# 0.0296f
C206 a_10363_63# a_8918_358# 0
C207 a_2419_63# a_1845_466# 0.10509f
C208 w_n310_281# a_5243_407# 0.78984f
C209 m2_5700_324# a_6721_407# 0.50857f
C210 a_3498_3# a_5243_407# 0.16427f
C211 a_7083_63# m2_7791_79# 0.14708f
C212 a_4158_271# a_8723_63# 0
C213 w_n310_281# a_1845_466# 0.44517f
C214 a_3498_3# a_1845_466# 0.00105f
C215 a_12559_3# a_2419_63# 0
C216 a_4290_63# a_4650_n37# 0.01502f
C217 w_n310_281# a_12559_3# 0.08598f
C218 m2_7791_79# a_8918_358# 0.02764f
C219 m2_6151_79# m2_7791_79# 0.00114f
C220 a_8361_407# m2_7791_79# 0.49779f
C221 a_7083_63# a_6520_n37# 0.00272f
C222 a_10906_n37# w_n310_281# 0
C223 a_7768_n37# a_7083_63# 0.0028f
C224 m2_9431_79# a_7410_63# 0.00105f
C225 m2_6151_79# a_6520_n37# 0.00766f
C226 a_7768_n37# a_8361_407# 0
C227 m2_5700_324# m2_1295_79# 0.07849f
C228 a_11922_391# a_2419_63# 0.00754f
C229 w_n310_281# a_11922_391# 0.03535f
C230 m2_1295_79# a_705_407# 0.30816f
C231 a_870_n37# a_1845_466# 0
C232 a_4290_63# m2_1295_79# 0.13519f
C233 a_11922_3# a_12559_3# 0.0899f
C234 a_8160_n37# a_7410_63# 0.01329f
C235 m2_9431_79# a_2419_63# 0.00832f
C236 a_4650_n37# a_4158_271# 0.00383f
C237 w_n310_281# m2_9431_79# 0.46253f
C238 a_3498_3# m2_9431_79# 0
C239 m2_6151_79# a_6128_n37# 0.01733f
C240 m2_1295_79# a_2861_3# 0.15381f
C241 a_9050_63# m2_1295_79# 0.00716f
C242 m2_9431_79# a_7083_63# 0.19293f
C243 a_9609_407# m2_1295_79# 0.0093f
C244 m2_9431_79# a_8918_358# 0.03217f
C245 a_3940_63# a_2419_63# 0.00879f
C246 a_5768_63# a_6721_407# 0.14017f
C247 m2_9431_79# a_8361_407# 0
C248 a_11480_63# m2_1295_79# 0.00126f
C249 a_11922_3# a_11922_391# 0.01891f
C250 w_n310_281# a_3940_63# 0.30087f
C251 a_4290_63# m2_5700_324# 0.01531f
C252 a_3498_3# a_3940_63# 0.04602f
C253 a_2861_391# a_2419_63# 0.0163f
C254 m2_1295_79# a_10906_466# 0.0692f
C255 a_2861_391# w_n310_281# 0.03535f
C256 a_8160_n37# a_7083_63# 0.00507f
C257 a_160_63# a_510_63# 0.28903f
C258 m2_1295_79# a_4158_271# 0.16058f
C259 a_2861_391# a_3498_3# 0.00454f
C260 a_1262_n37# a_1845_466# 0
C261 a_2861_3# a_705_407# 0
C262 a_4290_63# a_2861_3# 0
C263 a_160_63# m2_24_342# 0.42316f
C264 a_5768_63# m2_1295_79# 0.00766f
C265 a_7410_63# a_2419_63# 0.00801f
C266 w_n310_281# a_7410_63# 0.31086f
C267 a_3498_3# a_7410_63# 0.11774f
C268 m2_5700_324# a_4158_271# 0.00861f
C269 a_9050_63# a_9609_407# 0.1261f
C270 a_7083_63# a_7410_63# 0.07718f
C271 a_10363_63# a_8723_63# 0
C272 a_1845_n37# a_510_63# 0.0011f
C273 a_7410_63# a_8918_358# 0
C274 w_n310_281# a_378_271# 0.63374f
C275 a_4290_63# a_4158_271# 0.11363f
C276 m2_6151_79# a_7410_63# 0
C277 a_8361_407# a_7410_63# 0.1423f
C278 a_9609_407# a_11480_63# 0
C279 w_n310_281# a_2419_63# 0.75125f
C280 a_5768_63# m2_5700_324# 0.16447f
C281 a_3498_3# a_2419_63# 0.01177f
C282 a_510_63# a_1845_466# 0.01433f
C283 a_8723_63# m2_7791_79# 0.08381f
C284 a_9609_407# a_10906_466# 0
C285 a_9050_63# a_9408_n37# 0.00935f
C286 w_n310_281# a_3498_3# 1.03377f
C287 a_7083_63# a_2419_63# 0.01345f
C288 a_9050_63# a_4158_271# 0.00717f
C289 a_9408_n37# a_9609_407# 0
C290 a_9609_407# a_4158_271# 0
C291 a_4650_n37# a_5042_407# 0.00712f
C292 w_n310_281# a_7083_63# 0.31663f
C293 a_4290_63# a_5768_63# 0.01093f
C294 a_3498_3# a_7083_63# 0.01356f
C295 a_5042_407# a_6721_407# 0.03265f
C296 a_11480_63# a_10906_466# 0.1131f
C297 a_2419_63# a_8918_358# 0.01449f
C298 m2_9431_79# a_9800_n37# 0.0074f
C299 m2_24_342# a_1845_466# 0.06999f
C300 a_8361_407# a_2419_63# 0
C301 m2_6151_79# a_2419_63# 0.05852f
C302 w_n310_281# a_8918_358# 0.49498f
C303 a_4158_271# via_dev$5$3$2_9/VSUBS 2.63856f
C304 a_7083_63# via_dev$5$3$2_9/VSUBS 0.86585f
C305 a_8723_63# via_dev$5$3$2_9/VSUBS 0.40977f
C306 m2_9431_79# via_dev$5$3$2_9/VSUBS 0.75255f
C307 m2_7791_79# via_dev$5$3$2_9/VSUBS 0.74612f
C308 a_9609_407# via_dev$5$3$2_9/VSUBS 0.11967f
C309 a_8361_407# via_dev$5$3$2_9/VSUBS 0.05216f
C310 m2_6151_79# via_dev$5$3$2_9/VSUBS 0.72815f
C311 a_6721_407# via_dev$5$3$2_9/VSUBS 0.01698f
C312 a_5042_407# via_dev$5$3$2_9/VSUBS 0.88916f
C313 a_3940_63# via_dev$5$3$2_9/VSUBS 0.46864f
C314 m2_1295_79# via_dev$5$3$2_9/VSUBS 3.34703f
C315 a_160_63# via_dev$5$3$2_9/VSUBS 0.5921f
C316 a_5243_407# via_dev$5$3$2_9/VSUBS 0.01661f
C317 a_705_407# via_dev$5$3$2_9/VSUBS 0.13677f
C318 a_3498_3# via_dev$5$3$2_9/VSUBS 1.27724f
C319 a_10906_n37# via_dev$5$3$2_9/VSUBS 0.02232f
C320 a_9800_n37# via_dev$5$3$2_9/VSUBS 0.01742f
C321 a_9408_n37# via_dev$5$3$2_9/VSUBS 0.007f
C322 a_8160_n37# via_dev$5$3$2_9/VSUBS 0.01743f
C323 a_7768_n37# via_dev$5$3$2_9/VSUBS 0.007f
C324 a_6520_n37# via_dev$5$3$2_9/VSUBS 0.01743f
C325 a_6128_n37# via_dev$5$3$2_9/VSUBS 0.007f
C326 a_5042_n37# via_dev$5$3$2_9/VSUBS 0.00833f
C327 a_4650_n37# via_dev$5$3$2_9/VSUBS 0.01565f
C328 a_12559_3# via_dev$5$3$2_9/VSUBS 0.19481f
C329 a_11922_3# via_dev$5$3$2_9/VSUBS 0.64569f
C330 a_11922_391# via_dev$5$3$2_9/VSUBS 0.00119f
C331 a_10906_466# via_dev$5$3$2_9/VSUBS 0.59796f
C332 a_11480_63# via_dev$5$3$2_9/VSUBS 0.42359f
C333 a_10363_63# via_dev$5$3$2_9/VSUBS 0.13924f
C334 a_9050_63# via_dev$5$3$2_9/VSUBS 0.53264f
C335 a_8918_358# via_dev$5$3$2_9/VSUBS 0.5203f
C336 a_7410_63# via_dev$5$3$2_9/VSUBS 0.53731f
C337 a_5768_63# via_dev$5$3$2_9/VSUBS 0.54f
C338 a_1845_n37# via_dev$5$3$2_9/VSUBS 0.01974f
C339 a_1262_n37# via_dev$5$3$2_9/VSUBS 0.0069f
C340 a_870_n37# via_dev$5$3$2_9/VSUBS 0.01517f
C341 a_4290_63# via_dev$5$3$2_9/VSUBS 0.57048f
C342 a_2861_3# via_dev$5$3$2_9/VSUBS 0.62907f
C343 a_1845_466# via_dev$5$3$2_9/VSUBS 0.59853f
C344 a_2419_63# via_dev$5$3$2_9/VSUBS 6.64114f
C345 a_510_63# via_dev$5$3$2_9/VSUBS 0.55998f
C346 a_378_271# via_dev$5$3$2_9/VSUBS 1.37769f
C347 w_n310_281# via_dev$5$3$2_9/VSUBS 27.06676f
C348 m2_5700_324# via_dev$5$3$2_9/VSUBS 1.14834f
C349 m2_24_342# via_dev$5$3$2_9/VSUBS 1.98211f
.ends

.subckt x1bitblock$2$2 a_2861_3# a_8361_407# a_6520_n37# a_1262_n37# a_2861_391# a_1845_466#
+ a_10906_n37# a_510_63# a_870_n37# a_6721_407# a_9800_n37# a_11480_63# a_6128_n37#
+ a_5768_63# a_8919_367# m2_6151_79# a_11922_391# a_5042_n37# a_9408_n37# a_9609_407#
+ a_5042_407# a_8160_n37# a_4158_271# a_11922_3# a_2419_63# m2_9431_79# a_10906_466#
+ a_4650_n37# a_9050_63# a_5243_407# a_7768_n37# a_3940_63# m2_7791_79# a_10363_63#
+ a_160_63# a_4290_63# a_7083_63# a_705_407# a_12559_3# a_7410_63# m2_5700_324# a_1845_n37#
+ via_dev$5$2$2_9/VSUBS m2_1295_79# a_8723_63# a_378_271# a_3498_3# w_n310_281# m2_24_342#
X0 a_2419_63# a_1845_466# via_dev$5$2$2_9/VSUBS via_dev$5$2$2_9/VSUBS nfet_03v3 ad=0.315p pd=2.26u as=0.2425p ps=1.97u w=0.5u l=0.28u
X1 a_1845_466# m2_24_342# a_1845_n37# via_dev$5$2$2_9/VSUBS nfet_03v3 ad=0.65p pd=3.3u as=0.42p ps=1.84u w=1u l=0.28u
X2 a_3940_63# m2_1295_79# w_n310_281# w_n310_281# pfet_03v3 ad=0.63p pd=3.26u as=0.65p ps=3.3u w=1u l=0.28u
X3 via_dev$5$2$2_9/VSUBS a_510_63# a_1262_n37# via_dev$5$2$2_9/VSUBS nfet_03v3 ad=0.65p pd=3.3u as=0.3625p ps=1.725u w=1u l=0.28u
X4 a_5243_407# a_4290_63# a_5042_407# w_n310_281# pfet_03v3 ad=1.3p pd=5.3u as=0.725p ps=2.725u w=2u l=0.28u
X5 a_6721_407# a_2419_63# m2_6151_79# w_n310_281# pfet_03v3 ad=0.675p pd=2.675u as=0.725p ps=2.725u w=2u l=0.28u
X6 a_10906_466# a_4158_271# w_n310_281# w_n310_281# pfet_03v3 ad=0.42p pd=1.84u as=0.65p ps=3.3u w=1u l=0.28u
X7 a_4290_63# a_4158_271# via_dev$5$2$2_9/VSUBS via_dev$5$2$2_9/VSUBS nfet_03v3 ad=0.315p pd=2.26u as=0.28p ps=2.12u w=0.5u l=0.28u
X8 w_n310_281# a_378_271# a_705_407# w_n310_281# pfet_03v3 ad=0.725p pd=2.725u as=1.09p ps=5.09u w=2u l=0.28u
X9 a_2861_3# m2_1295_79# via_dev$5$2$2_9/VSUBS via_dev$5$2$2_9/VSUBS nfet_03v3 ad=0.18125p pd=1.225u as=0.325p ps=2.3u w=0.5u l=0.28u
X10 via_dev$5$2$2_9/VSUBS a_2419_63# a_2861_3# via_dev$5$2$2_9/VSUBS nfet_03v3 ad=0.315p pd=2.26u as=0.18125p ps=1.225u w=0.5u l=0.28u
X11 m2_7791_79# m2_1295_79# a_7768_n37# via_dev$5$2$2_9/VSUBS nfet_03v3 ad=0.3375p pd=1.675u as=0.3625p ps=1.725u w=1u l=0.28u
X12 a_10906_n37# a_4158_271# via_dev$5$2$2_9/VSUBS via_dev$5$2$2_9/VSUBS nfet_03v3 ad=0.42p pd=1.84u as=0.63p ps=3.26u w=1u l=0.28u
X13 a_9050_63# a_8919_367# via_dev$5$2$2_9/VSUBS via_dev$5$2$2_9/VSUBS nfet_03v3 ad=0.31p pd=2.24u as=0.24p ps=1.96u w=0.5u l=0.28u
X14 a_11922_3# a_11480_63# via_dev$5$2$2_9/VSUBS via_dev$5$2$2_9/VSUBS nfet_03v3 ad=0.18125p pd=1.225u as=0.325p ps=2.3u w=0.5u l=0.28u
X15 via_dev$5$2$2_9/VSUBS a_2419_63# a_11922_3# via_dev$5$2$2_9/VSUBS nfet_03v3 ad=0.315p pd=2.26u as=0.18125p ps=1.225u w=0.5u l=0.28u
X16 a_705_407# a_510_63# m2_1295_79# w_n310_281# pfet_03v3 ad=1.3p pd=5.3u as=0.725p ps=2.725u w=2u l=0.28u
X17 a_4650_n37# a_4158_271# via_dev$5$2$2_9/VSUBS via_dev$5$2$2_9/VSUBS nfet_03v3 ad=0.3625p pd=1.725u as=0.54p ps=3.08u w=1u l=0.28u
X18 a_2861_3# a_2419_63# a_2861_391# w_n310_281# pfet_03v3 ad=1.3p pd=5.3u as=0.725p ps=2.725u w=2u l=0.28u
X19 a_5768_63# m2_5700_324# via_dev$5$2$2_9/VSUBS via_dev$5$2$2_9/VSUBS nfet_03v3 ad=0.315p pd=2.26u as=0.3175p ps=2.27u w=0.5u l=0.28u
X20 via_dev$5$2$2_9/VSUBS a_9050_63# a_9800_n37# via_dev$5$2$2_9/VSUBS nfet_03v3 ad=0.65p pd=3.3u as=0.3625p ps=1.725u w=1u l=0.28u
X21 a_8361_407# m2_1295_79# m2_7791_79# w_n310_281# pfet_03v3 ad=0.675p pd=2.675u as=0.725p ps=2.725u w=2u l=0.28u
X22 a_9408_n37# a_8919_367# via_dev$5$2$2_9/VSUBS via_dev$5$2$2_9/VSUBS nfet_03v3 ad=0.3625p pd=1.725u as=0.54p ps=3.08u w=1u l=0.28u
X23 a_3498_3# a_2861_3# w_n310_281# w_n310_281# pfet_03v3 ad=0.65p pd=3.3u as=0.675p ps=3.35u w=1u l=0.28u
X24 a_7410_63# m2_5700_324# via_dev$5$2$2_9/VSUBS via_dev$5$2$2_9/VSUBS nfet_03v3 ad=0.31p pd=2.24u as=0.24p ps=1.96u w=0.5u l=0.28u
X25 via_dev$5$2$2_9/VSUBS a_7410_63# a_8160_n37# via_dev$5$2$2_9/VSUBS nfet_03v3 ad=0.65p pd=3.3u as=0.3625p ps=1.725u w=1u l=0.28u
X26 a_8723_63# m2_7791_79# via_dev$5$2$2_9/VSUBS via_dev$5$2$2_9/VSUBS nfet_03v3 ad=0.2625p pd=2.05u as=0.265p ps=2.06u w=0.5u l=0.28u
X27 w_n310_281# a_4158_271# a_5243_407# w_n310_281# pfet_03v3 ad=0.725p pd=2.725u as=1.09p ps=5.09u w=2u l=0.28u
X28 a_5768_63# m2_5700_324# w_n310_281# w_n310_281# pfet_03v3 ad=0.65p pd=3.3u as=0.635p ps=3.27u w=1u l=0.28u
X29 a_9050_63# a_8919_367# w_n310_281# w_n310_281# pfet_03v3 ad=0.64p pd=3.28u as=0.48p ps=2.96u w=1u l=0.28u
X30 a_11922_391# a_11480_63# w_n310_281# w_n310_281# pfet_03v3 ad=0.725p pd=2.725u as=1.3p ps=5.3u w=2u l=0.28u
X31 a_160_63# m2_24_342# via_dev$5$2$2_9/VSUBS via_dev$5$2$2_9/VSUBS nfet_03v3 ad=0.315p pd=2.26u as=0.325p ps=2.3u w=0.5u l=0.28u
X32 a_9609_407# a_9050_63# w_n310_281# w_n310_281# pfet_03v3 ad=1.3p pd=5.3u as=0.725p ps=2.725u w=2u l=0.28u
X33 a_6128_n37# m2_5700_324# via_dev$5$2$2_9/VSUBS via_dev$5$2$2_9/VSUBS nfet_03v3 ad=0.3625p pd=1.725u as=0.54p ps=3.08u w=1u l=0.28u
X34 via_dev$5$2$2_9/VSUBS a_5768_63# a_6520_n37# via_dev$5$2$2_9/VSUBS nfet_03v3 ad=0.65p pd=3.3u as=0.3625p ps=1.725u w=1u l=0.28u
X35 a_7410_63# m2_5700_324# w_n310_281# w_n310_281# pfet_03v3 ad=0.64p pd=3.28u as=0.48p ps=2.96u w=1u l=0.28u
X36 m2_9431_79# a_8919_367# a_9609_407# w_n310_281# pfet_03v3 ad=0.725p pd=2.725u as=1.09p ps=5.09u w=2u l=0.28u
X37 a_11480_63# a_10906_466# via_dev$5$2$2_9/VSUBS via_dev$5$2$2_9/VSUBS nfet_03v3 ad=0.315p pd=2.26u as=0.2425p ps=1.97u w=0.5u l=0.28u
X38 a_1845_466# a_378_271# w_n310_281# w_n310_281# pfet_03v3 ad=0.42p pd=1.84u as=0.65p ps=3.3u w=1u l=0.28u
X39 a_8361_407# a_7410_63# w_n310_281# w_n310_281# pfet_03v3 ad=1.3p pd=5.3u as=0.725p ps=2.725u w=2u l=0.28u
X40 w_n310_281# m2_1295_79# a_10906_466# w_n310_281# pfet_03v3 ad=0.735p pd=2.47u as=0.42p ps=1.84u w=1u l=0.28u
X41 a_7083_63# m2_6151_79# via_dev$5$2$2_9/VSUBS via_dev$5$2$2_9/VSUBS nfet_03v3 ad=0.2625p pd=2.05u as=0.265p ps=2.06u w=0.5u l=0.28u
X42 a_510_63# a_378_271# w_n310_281# w_n310_281# pfet_03v3 ad=0.65p pd=3.3u as=0.56p ps=3.12u w=1u l=0.28u
X43 a_10363_63# m2_9431_79# w_n310_281# w_n310_281# pfet_03v3 ad=0.715p pd=3.43u as=0.53p ps=3.06u w=1u l=0.28u
X44 a_510_63# a_378_271# via_dev$5$2$2_9/VSUBS via_dev$5$2$2_9/VSUBS nfet_03v3 ad=0.315p pd=2.26u as=0.28p ps=2.12u w=0.5u l=0.28u
X45 a_1262_n37# a_160_63# m2_1295_79# via_dev$5$2$2_9/VSUBS nfet_03v3 ad=0.3625p pd=1.725u as=0.3375p ps=1.675u w=1u l=0.28u
X46 a_1845_n37# a_378_271# via_dev$5$2$2_9/VSUBS via_dev$5$2$2_9/VSUBS nfet_03v3 ad=0.42p pd=1.84u as=0.63p ps=3.26u w=1u l=0.28u
X47 m2_6151_79# m2_5700_324# a_6721_407# w_n310_281# pfet_03v3 ad=0.725p pd=2.725u as=1.09p ps=5.09u w=2u l=0.28u
X48 a_6721_407# a_5768_63# w_n310_281# w_n310_281# pfet_03v3 ad=1.3p pd=5.3u as=0.725p ps=2.725u w=2u l=0.28u
X49 a_10363_63# m2_9431_79# via_dev$5$2$2_9/VSUBS via_dev$5$2$2_9/VSUBS nfet_03v3 ad=0.3575p pd=2.43u as=0.265p ps=2.06u w=0.5u l=0.28u
X50 a_10906_466# m2_1295_79# a_10906_n37# via_dev$5$2$2_9/VSUBS nfet_03v3 ad=0.65p pd=3.3u as=0.42p ps=1.84u w=1u l=0.28u
X51 a_8723_63# m2_7791_79# w_n310_281# w_n310_281# pfet_03v3 ad=0.545p pd=3.09u as=0.53p ps=3.06u w=1u l=0.28u
X52 a_11480_63# a_10906_466# w_n310_281# w_n310_281# pfet_03v3 ad=0.65p pd=3.3u as=0.735p ps=2.47u w=1u l=0.28u
X53 a_12559_3# a_11922_3# via_dev$5$2$2_9/VSUBS via_dev$5$2$2_9/VSUBS nfet_03v3 ad=0.315p pd=2.26u as=0.325p ps=2.3u w=0.5u l=0.28u
X54 a_7083_63# m2_6151_79# w_n310_281# w_n310_281# pfet_03v3 ad=0.545p pd=3.09u as=0.53p ps=3.06u w=1u l=0.28u
X55 a_7768_n37# m2_5700_324# via_dev$5$2$2_9/VSUBS via_dev$5$2$2_9/VSUBS nfet_03v3 ad=0.3625p pd=1.725u as=0.54p ps=3.08u w=1u l=0.28u
X56 a_160_63# m2_24_342# w_n310_281# w_n310_281# pfet_03v3 ad=0.63p pd=3.26u as=0.65p ps=3.3u w=1u l=0.28u
X57 m2_1295_79# a_160_63# a_705_407# w_n310_281# pfet_03v3 ad=0.725p pd=2.725u as=0.675p ps=2.675u w=2u l=0.28u
X58 a_5042_n37# a_3940_63# a_5042_407# via_dev$5$2$2_9/VSUBS nfet_03v3 ad=0.3625p pd=1.725u as=0.3375p ps=1.675u w=1u l=0.28u
X59 m2_1295_79# m2_24_342# a_870_n37# via_dev$5$2$2_9/VSUBS nfet_03v3 ad=0.3375p pd=1.675u as=0.3625p ps=1.725u w=1u l=0.28u
X60 a_11922_3# a_2419_63# a_11922_391# w_n310_281# pfet_03v3 ad=1.3p pd=5.3u as=0.725p ps=2.725u w=2u l=0.28u
X61 a_9800_n37# a_7083_63# m2_9431_79# via_dev$5$2$2_9/VSUBS nfet_03v3 ad=0.3625p pd=1.725u as=0.3375p ps=1.675u w=1u l=0.28u
X62 m2_7791_79# m2_5700_324# a_8361_407# w_n310_281# pfet_03v3 ad=0.725p pd=2.725u as=1.09p ps=5.09u w=2u l=0.28u
X63 a_5042_407# a_3940_63# a_5243_407# w_n310_281# pfet_03v3 ad=0.725p pd=2.725u as=0.675p ps=2.675u w=2u l=0.28u
X64 a_3940_63# m2_1295_79# via_dev$5$2$2_9/VSUBS via_dev$5$2$2_9/VSUBS nfet_03v3 ad=0.315p pd=2.26u as=0.325p ps=2.3u w=0.5u l=0.28u
X65 a_8160_n37# a_3498_3# m2_7791_79# via_dev$5$2$2_9/VSUBS nfet_03v3 ad=0.3625p pd=1.725u as=0.3375p ps=1.675u w=1u l=0.28u
X66 a_705_407# m2_24_342# w_n310_281# w_n310_281# pfet_03v3 ad=0.675p pd=2.675u as=0.725p ps=2.725u w=2u l=0.28u
X67 a_5042_407# m2_1295_79# a_4650_n37# via_dev$5$2$2_9/VSUBS nfet_03v3 ad=0.3375p pd=1.675u as=0.3625p ps=1.725u w=1u l=0.28u
X68 a_6520_n37# a_5042_407# m2_6151_79# via_dev$5$2$2_9/VSUBS nfet_03v3 ad=0.3625p pd=1.725u as=0.3375p ps=1.675u w=1u l=0.28u
X69 w_n310_281# a_7083_63# a_9609_407# w_n310_281# pfet_03v3 ad=0.725p pd=2.725u as=0.675p ps=2.675u w=2u l=0.28u
X70 a_2419_63# a_1845_466# w_n310_281# w_n310_281# pfet_03v3 ad=0.65p pd=3.3u as=0.735p ps=2.47u w=1u l=0.28u
X71 m2_9431_79# a_8723_63# a_9408_n37# via_dev$5$2$2_9/VSUBS nfet_03v3 ad=0.3375p pd=1.675u as=0.3625p ps=1.725u w=1u l=0.28u
X72 w_n310_281# a_3498_3# a_8361_407# w_n310_281# pfet_03v3 ad=0.725p pd=2.725u as=0.675p ps=2.675u w=2u l=0.28u
X73 a_2861_391# m2_1295_79# w_n310_281# w_n310_281# pfet_03v3 ad=0.725p pd=2.725u as=1.3p ps=5.3u w=2u l=0.28u
X74 a_4290_63# a_4158_271# w_n310_281# w_n310_281# pfet_03v3 ad=0.65p pd=3.3u as=0.56p ps=3.12u w=1u l=0.28u
X75 a_5243_407# m2_1295_79# w_n310_281# w_n310_281# pfet_03v3 ad=0.675p pd=2.675u as=0.725p ps=2.725u w=2u l=0.28u
X76 w_n310_281# a_5042_407# a_6721_407# w_n310_281# pfet_03v3 ad=0.725p pd=2.725u as=0.675p ps=2.675u w=2u l=0.28u
X77 a_3498_3# a_2861_3# via_dev$5$2$2_9/VSUBS via_dev$5$2$2_9/VSUBS nfet_03v3 ad=0.315p pd=2.26u as=0.325p ps=2.3u w=0.5u l=0.28u
X78 a_9609_407# a_8723_63# m2_9431_79# w_n310_281# pfet_03v3 ad=0.675p pd=2.675u as=0.725p ps=2.725u w=2u l=0.28u
X79 via_dev$5$2$2_9/VSUBS a_4290_63# a_5042_n37# via_dev$5$2$2_9/VSUBS nfet_03v3 ad=0.65p pd=3.3u as=0.3625p ps=1.725u w=1u l=0.28u
X80 m2_6151_79# a_2419_63# a_6128_n37# via_dev$5$2$2_9/VSUBS nfet_03v3 ad=0.3375p pd=1.675u as=0.3625p ps=1.725u w=1u l=0.28u
X81 w_n310_281# m2_24_342# a_1845_466# w_n310_281# pfet_03v3 ad=0.735p pd=2.47u as=0.42p ps=1.84u w=1u l=0.28u
X82 a_870_n37# a_378_271# via_dev$5$2$2_9/VSUBS via_dev$5$2$2_9/VSUBS nfet_03v3 ad=0.3625p pd=1.725u as=0.54p ps=3.08u w=1u l=0.28u
X83 a_12559_3# a_11922_3# w_n310_281# w_n310_281# pfet_03v3 ad=0.65p pd=3.3u as=0.675p ps=3.35u w=1u l=0.28u
C0 a_8919_367# a_10363_63# 0
C1 a_8361_407# m2_7791_79# 0.49779f
C2 a_7083_63# m2_7791_79# 0.14708f
C3 a_705_407# a_1262_n37# 0
C4 a_6520_n37# a_5042_407# 0.00483f
C5 a_10906_466# a_9609_407# 0
C6 a_4158_271# m2_1295_79# 0.16058f
C7 m2_9431_79# a_8160_n37# 0
C8 a_11480_63# a_11922_3# 0.04054f
C9 a_4158_271# a_4650_n37# 0.00383f
C10 m2_1295_79# m2_7791_79# 0.05731f
C11 a_8919_367# a_9050_63# 0.10006f
C12 a_3498_3# m2_9431_79# 0
C13 m2_5700_324# w_n310_281# 1.65678f
C14 a_4158_271# a_5042_407# 0.63867f
C15 a_4290_63# a_5243_407# 0.14023f
C16 a_2419_63# m2_24_342# 0.00234f
C17 w_n310_281# a_8919_367# 0.49838f
C18 a_3498_3# a_5243_407# 0.16427f
C19 a_3940_63# a_5768_63# 0
C20 m2_7791_79# a_5042_407# 0.00555f
C21 m2_9431_79# a_9609_407# 0.49779f
C22 a_10906_466# a_11922_3# 0
C23 a_9408_n37# m2_7791_79# 0
C24 m2_1295_79# a_1262_n37# 0.01607f
C25 a_2419_63# a_7410_63# 0.00801f
C26 a_4158_271# a_9800_n37# 0.00497f
C27 a_10363_63# a_9609_407# 0.01306f
C28 m2_6151_79# a_7083_63# 0.08089f
C29 a_5042_n37# m2_6151_79# 0
C30 a_1845_466# a_705_407# 0.0126f
C31 a_5768_63# a_7083_63# 0.01494f
C32 a_1845_466# a_3940_63# 0
C33 a_6721_407# m2_6151_79# 0.4935f
C34 a_6721_407# a_5768_63# 0.14017f
C35 a_4158_271# a_11480_63# 0.00295f
C36 w_n310_281# a_4290_63# 0.2819f
C37 m2_1295_79# m2_6151_79# 0.00667f
C38 a_2861_3# a_5243_407# 0
C39 a_1845_466# a_160_63# 0
C40 w_n310_281# a_3498_3# 1.03377f
C41 a_7410_63# a_7768_n37# 0.00935f
C42 m2_1295_79# a_5768_63# 0.00766f
C43 a_9050_63# a_9609_407# 0.1261f
C44 m2_5700_324# a_2419_63# 0.074f
C45 a_510_63# a_1262_n37# 0.00898f
C46 m2_5700_324# a_7410_63# 0.14432f
C47 m2_6151_79# a_5042_407# 0.20459f
C48 w_n310_281# a_9609_407# 0.7653f
C49 a_2419_63# a_8919_367# 0.01445f
C50 a_7410_63# a_8919_367# 0
C51 a_4158_271# a_10906_466# 0.03873f
C52 a_5768_63# a_5042_407# 0.22596f
C53 a_12559_3# a_11922_3# 0.0899f
C54 a_378_271# w_n310_281# 0.6337f
C55 a_2861_391# a_705_407# 0
C56 a_1845_466# m2_1295_79# 0.09644f
C57 a_705_407# a_160_63# 0.06737f
C58 a_8361_407# a_8723_63# 0.01268f
C59 a_7083_63# a_8723_63# 0.15796f
C60 w_n310_281# a_2861_3# 0.4655f
C61 a_3498_3# m2_24_342# 0
C62 a_7410_63# a_8160_n37# 0.01329f
C63 w_n310_281# a_11922_3# 0.46598f
C64 a_4158_271# m2_9431_79# 0.05572f
C65 a_2419_63# a_4290_63# 0.00652f
C66 m2_5700_324# a_8919_367# 0
C67 a_8361_407# a_7083_63# 0.01453f
C68 m2_1295_79# a_705_407# 0.30816f
C69 a_4158_271# a_5243_407# 0.02964f
C70 a_4158_271# a_10906_n37# 0.00824f
C71 a_2419_63# a_3498_3# 0.01177f
C72 a_4158_271# a_10363_63# 0.02222f
C73 a_3498_3# a_7410_63# 0.11774f
C74 m2_9431_79# m2_7791_79# 0.01571f
C75 m2_1295_79# a_3940_63# 0.46061f
C76 a_510_63# a_1845_466# 0.01433f
C77 a_6721_407# a_7083_63# 0.01268f
C78 m2_1295_79# a_8723_63# 0.00803f
C79 a_4650_n37# a_3940_63# 0.00441f
C80 a_378_271# m2_24_342# 0.56715f
C81 a_6128_n37# m2_6151_79# 0.01733f
C82 a_2419_63# a_9609_407# 0
C83 a_2861_391# m2_1295_79# 0.00841f
C84 a_6128_n37# a_5768_63# 0.00935f
C85 a_3940_63# a_5042_407# 0.0941f
C86 m2_1295_79# a_8361_407# 0.02509f
C87 m2_1295_79# a_160_63# 0.09339f
C88 m2_1295_79# a_7083_63# 0.01071f
C89 m2_5700_324# a_4290_63# 0.01531f
C90 a_870_n37# a_1845_466# 0
C91 a_510_63# a_705_407# 0.13828f
C92 a_4158_271# a_9050_63# 0.00717f
C93 m2_1295_79# a_6721_407# 0.00452f
C94 a_7083_63# a_5042_407# 0.02611f
C95 a_5042_n37# a_5042_407# 0.01726f
C96 m2_5700_324# a_3498_3# 0.55174f
C97 a_2419_63# a_2861_3# 0.21478f
C98 w_n310_281# a_4158_271# 0.66883f
C99 a_9050_63# m2_7791_79# 0.00127f
C100 a_9408_n37# a_7083_63# 0.00336f
C101 a_2419_63# a_11922_3# 0.16984f
C102 a_6721_407# a_5042_407# 0.03265f
C103 w_n310_281# m2_7791_79# 0.45139f
C104 a_9800_n37# a_7083_63# 0.00527f
C105 a_510_63# a_160_63# 0.28903f
C106 a_8919_367# a_9609_407# 0.02942f
C107 m2_1295_79# a_5042_407# 0.03487f
C108 a_5768_63# a_5243_407# 0.00722f
C109 a_11480_63# a_11922_391# 0.00152f
C110 a_4650_n37# a_5042_407# 0.00712f
C111 a_3498_3# a_4290_63# 0.00876f
C112 a_510_63# m2_1295_79# 0.39896f
C113 a_870_n37# a_160_63# 0.00441f
C114 a_1845_466# a_1845_n37# 0.01333f
C115 a_2419_63# a_4158_271# 0.14782f
C116 a_7410_63# a_4158_271# 0
C117 a_10906_466# a_7083_63# 0
C118 m2_1295_79# a_11480_63# 0.00126f
C119 w_n310_281# m2_6151_79# 0.44301f
C120 a_6128_n37# a_6721_407# 0
C121 a_2419_63# m2_7791_79# 0.00843f
C122 w_n310_281# a_5768_63# 0.31314f
C123 a_870_n37# m2_1295_79# 0.00639f
C124 a_7410_63# m2_7791_79# 0.36168f
C125 m2_9431_79# a_8723_63# 0.13485f
C126 a_4290_63# a_2861_3# 0
C127 a_3940_63# a_5243_407# 0.06737f
C128 m2_1295_79# a_10906_466# 0.0692f
C129 a_3498_3# a_2861_3# 0.09846f
C130 w_n310_281# a_1845_466# 0.44517f
C131 a_10363_63# a_8723_63# 0
C132 a_6128_n37# a_5042_407# 0.00376f
C133 m2_9431_79# a_8361_407# 0
C134 m2_9431_79# a_7083_63# 0.19293f
C135 m2_5700_324# a_4158_271# 0.00861f
C136 a_7768_n37# m2_7791_79# 0.01733f
C137 a_5042_n37# a_5243_407# 0
C138 a_10363_63# a_7083_63# 0.00582f
C139 a_4158_271# a_8919_367# 0.001f
C140 a_510_63# a_870_n37# 0.01502f
C141 m2_5700_324# m2_7791_79# 0.05245f
C142 a_8919_367# m2_7791_79# 0.02774f
C143 m2_1295_79# m2_9431_79# 0.0078f
C144 w_n310_281# a_705_407# 0.79414f
C145 a_2419_63# m2_6151_79# 0.05852f
C146 a_7410_63# m2_6151_79# 0
C147 m2_1295_79# a_1845_n37# 0.00942f
C148 a_9050_63# a_8723_63# 0.53121f
C149 a_2419_63# a_5768_63# 0.07749f
C150 w_n310_281# a_3940_63# 0.30087f
C151 m2_1295_79# a_5243_407# 0.10989f
C152 a_10363_63# m2_1295_79# 0.00179f
C153 w_n310_281# a_8723_63# 0.33584f
C154 w_n310_281# a_11922_391# 0.03535f
C155 a_1845_466# m2_24_342# 0.06999f
C156 a_8361_407# a_9050_63# 0
C157 a_9050_63# a_7083_63# 0.21474f
C158 w_n310_281# a_2861_391# 0.03535f
C159 a_4158_271# a_4290_63# 0.11363f
C160 m2_9431_79# a_9408_n37# 0.01733f
C161 a_5243_407# a_5042_407# 0.29512f
C162 w_n310_281# a_8361_407# 0.75753f
C163 a_11480_63# a_10906_466# 0.1131f
C164 w_n310_281# a_160_63# 0.30515f
C165 w_n310_281# a_7083_63# 0.31663f
C166 a_8160_n37# m2_7791_79# 0.01048f
C167 a_3498_3# a_4158_271# 0.00829f
C168 a_2419_63# a_1845_466# 0.10509f
C169 a_9800_n37# m2_9431_79# 0.0074f
C170 w_n310_281# a_6721_407# 0.72579f
C171 a_3498_3# m2_7791_79# 0.0296f
C172 m2_5700_324# m2_6151_79# 0.14941f
C173 a_4158_271# a_9609_407# 0
C174 a_510_63# a_1845_n37# 0.0011f
C175 m2_1295_79# a_9050_63# 0.00716f
C176 m2_5700_324# a_5768_63# 0.16447f
C177 m2_24_342# a_705_407# 0.10607f
C178 w_n310_281# m2_1295_79# 2.3522f
C179 m2_7791_79# a_9609_407# 0
C180 a_11480_63# m2_9431_79# 0
C181 a_2419_63# a_705_407# 0
C182 a_2419_63# a_3940_63# 0.00879f
C183 w_n310_281# a_5042_407# 0.29911f
C184 a_10363_63# a_11480_63# 0
C185 a_9408_n37# a_9050_63# 0.00935f
C186 m2_24_342# a_160_63# 0.42316f
C187 a_2419_63# a_8723_63# 0.00661f
C188 a_7410_63# a_8723_63# 0.01398f
C189 a_2419_63# a_11922_391# 0.00754f
C190 a_4158_271# a_11922_3# 0.0013f
C191 a_2419_63# a_2861_391# 0.0163f
C192 a_9800_n37# a_9050_63# 0.01329f
C193 a_2419_63# a_8361_407# 0
C194 m2_9431_79# a_10906_466# 0.00167f
C195 a_2419_63# a_7083_63# 0.01345f
C196 a_7410_63# a_8361_407# 0.1423f
C197 a_7410_63# a_7083_63# 0.07718f
C198 m2_6151_79# a_4290_63# 0
C199 a_510_63# w_n310_281# 0.28255f
C200 a_5768_63# a_4290_63# 0.01093f
C201 a_10906_n37# a_10906_466# 0.01333f
C202 a_3498_3# m2_6151_79# 0
C203 a_10363_63# a_10906_466# 0.02047f
C204 a_3498_3# a_5768_63# 0
C205 m2_24_342# m2_1295_79# 0.04399f
C206 a_2419_63# a_6721_407# 0.01825f
C207 a_6520_n37# a_4158_271# 0.00406f
C208 m2_5700_324# a_3940_63# 0.00132f
C209 a_10906_466# a_12559_3# 0
C210 w_n310_281# a_11480_63# 0.37298f
C211 a_2419_63# m2_1295_79# 0.32461f
C212 m2_5700_324# a_8723_63# 0
C213 a_7410_63# m2_1295_79# 0.07614f
C214 a_8361_407# a_7768_n37# 0
C215 a_7768_n37# a_7083_63# 0.0028f
C216 a_8919_367# a_8723_63# 0.12587f
C217 a_3498_3# a_1845_466# 0.00105f
C218 m2_5700_324# a_8361_407# 0.05956f
C219 m2_5700_324# a_7083_63# 0.12051f
C220 a_2419_63# a_5042_407# 0.08051f
C221 a_10363_63# m2_9431_79# 0.07766f
C222 a_7410_63# a_5042_407# 0
C223 a_8919_367# a_8361_407# 0
C224 a_8919_367# a_7083_63# 0.01057f
C225 a_10363_63# a_10906_n37# 0
C226 a_510_63# m2_24_342# 0.13025f
C227 w_n310_281# a_10906_466# 0.44509f
C228 m2_5700_324# a_6721_407# 0.50857f
C229 a_4158_271# m2_7791_79# 0
C230 a_378_271# a_1845_466# 0.01278f
C231 m2_5700_324# m2_1295_79# 0.07849f
C232 a_3940_63# a_4290_63# 0.28903f
C233 a_8919_367# m2_1295_79# 0.01372f
C234 a_3498_3# a_3940_63# 0.04602f
C235 m2_9431_79# a_9050_63# 0.328f
C236 a_3498_3# a_8723_63# 0.00575f
C237 a_1845_466# a_2861_3# 0
C238 a_8160_n37# a_7083_63# 0.00507f
C239 m2_5700_324# a_5042_407# 0.06917f
C240 a_6520_n37# m2_6151_79# 0.00766f
C241 w_n310_281# m2_9431_79# 0.46254f
C242 a_2419_63# a_11480_63# 0.0769f
C243 a_5042_n37# a_4290_63# 0.00898f
C244 a_6520_n37# a_5768_63# 0.01329f
C245 a_10363_63# a_9050_63# 0.01385f
C246 a_3498_3# a_2861_391# 0.00454f
C247 w_n310_281# a_1845_n37# 0
C248 a_3498_3# a_8361_407# 0.12093f
C249 a_378_271# a_705_407# 0.02817f
C250 a_3498_3# a_7083_63# 0.01356f
C251 w_n310_281# a_5243_407# 0.78984f
C252 a_8723_63# a_9609_407# 0.0593f
C253 w_n310_281# a_10906_n37# 0
C254 w_n310_281# a_10363_63# 0.15741f
C255 a_8361_407# a_9609_407# 0.00466f
C256 a_3498_3# a_6721_407# 0
C257 a_7083_63# a_9609_407# 0.0285f
C258 w_n310_281# a_12559_3# 0.08598f
C259 a_705_407# a_2861_3# 0
C260 a_2419_63# a_10906_466# 0.00833f
C261 a_4158_271# m2_6151_79# 0.04334f
C262 m2_1295_79# a_4290_63# 0.13519f
C263 a_3940_63# a_2861_3# 0
C264 a_378_271# a_160_63# 0.09182f
C265 a_4158_271# a_5768_63# 0.00573f
C266 a_3498_3# m2_1295_79# 0.3391f
C267 a_4650_n37# a_4290_63# 0.01502f
C268 m2_6151_79# m2_7791_79# 0.00114f
C269 a_5768_63# m2_7791_79# 0
C270 a_4290_63# a_5042_407# 0.38112f
C271 w_n310_281# a_9050_63# 0.28931f
C272 a_2861_391# a_2861_3# 0.01616f
C273 a_11922_391# a_11922_3# 0.01891f
C274 m2_1295_79# a_9609_407# 0.0093f
C275 a_3498_3# a_5042_407# 0.02015f
C276 a_378_271# m2_1295_79# 0.02669f
C277 a_2419_63# m2_9431_79# 0.00832f
C278 a_7410_63# m2_9431_79# 0.00105f
C279 a_2419_63# a_5243_407# 0
C280 a_2419_63# a_10363_63# 0.00126f
C281 a_9408_n37# a_9609_407# 0
C282 m2_1295_79# a_2861_3# 0.15381f
C283 a_6520_n37# a_7083_63# 0.00272f
C284 a_2419_63# a_12559_3# 0
C285 m2_1295_79# a_11922_3# 0
C286 a_4158_271# a_3940_63# 0.16366f
C287 a_1845_466# a_1262_n37# 0
C288 a_2861_3# a_5042_407# 0
C289 m2_9431_79# a_7768_n37# 0
C290 a_510_63# a_378_271# 0.14298f
C291 a_5768_63# m2_6151_79# 0.35511f
C292 a_4158_271# a_8723_63# 0
C293 w_n310_281# m2_24_342# 0.66878f
C294 a_2419_63# a_9050_63# 0.00801f
C295 a_8919_367# m2_9431_79# 0.03216f
C296 a_11480_63# a_9609_407# 0
C297 m2_5700_324# a_5243_407# 0.01927f
C298 a_8723_63# m2_7791_79# 0.08396f
C299 a_4158_271# a_7083_63# 1.09132f
C300 a_4158_271# a_5042_n37# 0
C301 w_n310_281# a_2419_63# 0.75129f
C302 w_n310_281# a_7410_63# 0.31086f
C303 a_4158_271# via_dev$5$2$2_9/VSUBS 2.63898f
C304 a_7083_63# via_dev$5$2$2_9/VSUBS 0.86585f
C305 a_8723_63# via_dev$5$2$2_9/VSUBS 0.41121f
C306 m2_9431_79# via_dev$5$2$2_9/VSUBS 0.75255f
C307 m2_7791_79# via_dev$5$2$2_9/VSUBS 0.74612f
C308 a_9609_407# via_dev$5$2$2_9/VSUBS 0.11967f
C309 a_8361_407# via_dev$5$2$2_9/VSUBS 0.05216f
C310 m2_6151_79# via_dev$5$2$2_9/VSUBS 0.72815f
C311 a_6721_407# via_dev$5$2$2_9/VSUBS 0.01698f
C312 a_5042_407# via_dev$5$2$2_9/VSUBS 0.88916f
C313 a_3940_63# via_dev$5$2$2_9/VSUBS 0.46864f
C314 m2_1295_79# via_dev$5$2$2_9/VSUBS 3.37184f
C315 a_160_63# via_dev$5$2$2_9/VSUBS 0.5921f
C316 a_5243_407# via_dev$5$2$2_9/VSUBS 0.01661f
C317 a_705_407# via_dev$5$2$2_9/VSUBS 0.13677f
C318 a_3498_3# via_dev$5$2$2_9/VSUBS 1.27724f
C319 a_10906_n37# via_dev$5$2$2_9/VSUBS 0.02232f
C320 a_9800_n37# via_dev$5$2$2_9/VSUBS 0.01742f
C321 a_9408_n37# via_dev$5$2$2_9/VSUBS 0.007f
C322 a_8160_n37# via_dev$5$2$2_9/VSUBS 0.01743f
C323 a_7768_n37# via_dev$5$2$2_9/VSUBS 0.007f
C324 a_6520_n37# via_dev$5$2$2_9/VSUBS 0.01743f
C325 a_6128_n37# via_dev$5$2$2_9/VSUBS 0.007f
C326 a_5042_n37# via_dev$5$2$2_9/VSUBS 0.00833f
C327 a_4650_n37# via_dev$5$2$2_9/VSUBS 0.01565f
C328 a_12559_3# via_dev$5$2$2_9/VSUBS 0.19481f
C329 a_11922_3# via_dev$5$2$2_9/VSUBS 0.64569f
C330 a_11922_391# via_dev$5$2$2_9/VSUBS 0.00119f
C331 a_10906_466# via_dev$5$2$2_9/VSUBS 0.59796f
C332 a_11480_63# via_dev$5$2$2_9/VSUBS 0.42359f
C333 a_10363_63# via_dev$5$2$2_9/VSUBS 0.13924f
C334 a_9050_63# via_dev$5$2$2_9/VSUBS 0.53264f
C335 a_8919_367# via_dev$5$2$2_9/VSUBS 0.51866f
C336 a_7410_63# via_dev$5$2$2_9/VSUBS 0.53731f
C337 a_5768_63# via_dev$5$2$2_9/VSUBS 0.54f
C338 a_1845_n37# via_dev$5$2$2_9/VSUBS 0.01974f
C339 a_1262_n37# via_dev$5$2$2_9/VSUBS 0.0069f
C340 a_870_n37# via_dev$5$2$2_9/VSUBS 0.01517f
C341 a_4290_63# via_dev$5$2$2_9/VSUBS 0.57048f
C342 a_2861_3# via_dev$5$2$2_9/VSUBS 0.62907f
C343 a_1845_466# via_dev$5$2$2_9/VSUBS 0.59853f
C344 a_2419_63# via_dev$5$2$2_9/VSUBS 6.64114f
C345 a_510_63# via_dev$5$2$2_9/VSUBS 0.55998f
C346 a_378_271# via_dev$5$2$2_9/VSUBS 1.37769f
C347 w_n310_281# via_dev$5$2$2_9/VSUBS 27.01716f
C348 m2_24_342# via_dev$5$2$2_9/VSUBS 1.98211f
C349 m2_5700_324# via_dev$5$2$2_9/VSUBS 1.14834f
.ends

.subckt MUX21$2 a_1472_63# a_157_63# a_25_271# a_909_n37# a_650_n277# a_517_n37# a_718_407#
+ m2_540_79# via_dev$11$2_4/VSUBS a_846_955# w_n310_281#
X0 a_1472_63# m2_540_79# via_dev$11$2_4/VSUBS via_dev$11$2_4/VSUBS nfet_03v3 ad=0.2625p pd=2.05u as=0.265p ps=2.06u w=0.5u l=0.28u
X1 a_157_63# a_25_271# w_n310_281# w_n310_281# pfet_03v3 ad=0.65p pd=3.3u as=0.635p ps=3.27u w=1u l=0.28u
X2 a_718_407# a_650_n277# m2_540_79# w_n310_281# pfet_03v3 ad=0.675p pd=2.675u as=0.725p ps=2.725u w=2u l=0.28u
X3 a_517_n37# a_25_271# via_dev$11$2_4/VSUBS via_dev$11$2_4/VSUBS nfet_03v3 ad=0.3625p pd=1.725u as=0.54p ps=3.08u w=1u l=0.28u
X4 via_dev$11$2_4/VSUBS a_157_63# a_909_n37# via_dev$11$2_4/VSUBS nfet_03v3 ad=0.65p pd=3.3u as=0.3625p ps=1.725u w=1u l=0.28u
X5 m2_540_79# a_25_271# a_718_407# w_n310_281# pfet_03v3 ad=0.725p pd=2.725u as=1.09p ps=5.09u w=2u l=0.28u
X6 a_157_63# a_25_271# via_dev$11$2_4/VSUBS via_dev$11$2_4/VSUBS nfet_03v3 ad=0.315p pd=2.26u as=0.3175p ps=2.27u w=0.5u l=0.28u
X7 a_718_407# a_157_63# w_n310_281# w_n310_281# pfet_03v3 ad=1.3p pd=5.3u as=0.725p ps=2.725u w=2u l=0.28u
X8 a_909_n37# a_846_955# m2_540_79# via_dev$11$2_4/VSUBS nfet_03v3 ad=0.3625p pd=1.725u as=0.3375p ps=1.675u w=1u l=0.28u
X9 w_n310_281# a_846_955# a_718_407# w_n310_281# pfet_03v3 ad=0.725p pd=2.725u as=0.675p ps=2.675u w=2u l=0.28u
X10 a_1472_63# m2_540_79# w_n310_281# w_n310_281# pfet_03v3 ad=0.545p pd=3.09u as=0.53p ps=3.06u w=1u l=0.28u
X11 m2_540_79# a_650_n277# a_517_n37# via_dev$11$2_4/VSUBS nfet_03v3 ad=0.3375p pd=1.675u as=0.3625p ps=1.725u w=1u l=0.28u
C0 a_157_63# a_517_n37# 0.00935f
C1 a_909_n37# m2_540_79# 0.01048f
C2 a_718_407# m2_540_79# 0.49779f
C3 w_n310_281# m2_540_79# 0.45246f
C4 a_157_63# m2_540_79# 0.36591f
C5 a_1472_63# m2_540_79# 0.0785f
C6 m2_540_79# a_846_955# 0.017f
C7 a_650_n277# m2_540_79# 0.03687f
C8 m2_540_79# a_25_271# 0.03352f
C9 m2_540_79# a_517_n37# 0.01733f
C10 a_909_n37# a_157_63# 0.01329f
C11 a_718_407# w_n310_281# 0.7633f
C12 a_718_407# a_157_63# 0.14486f
C13 a_718_407# a_1472_63# 0.01268f
C14 a_718_407# a_846_955# 0.01845f
C15 a_650_n277# a_718_407# 0.01687f
C16 w_n310_281# a_157_63# 0.32925f
C17 w_n310_281# a_1472_63# 0.10269f
C18 a_157_63# a_1472_63# 0.0156f
C19 w_n310_281# a_846_955# 0.19275f
C20 a_718_407# a_25_271# 0.03028f
C21 a_157_63# a_846_955# 0.07151f
C22 a_1472_63# a_846_955# 0
C23 a_650_n277# w_n310_281# 0.11257f
C24 a_650_n277# a_157_63# 0.02096f
C25 a_650_n277# a_1472_63# 0
C26 w_n310_281# a_25_271# 0.47695f
C27 a_650_n277# a_846_955# 0.04128f
C28 a_157_63# a_25_271# 0.11031f
C29 a_1472_63# a_25_271# 0
C30 a_718_407# a_517_n37# 0
C31 a_650_n277# a_25_271# 0.03814f
C32 m2_540_79# via_dev$11$2_4/VSUBS 0.94595f
C33 a_718_407# via_dev$11$2_4/VSUBS 0.15332f
C34 a_909_n37# via_dev$11$2_4/VSUBS 0.01743f
C35 a_517_n37# via_dev$11$2_4/VSUBS 0.007f
C36 a_1472_63# via_dev$11$2_4/VSUBS 0.17252f
C37 a_157_63# via_dev$11$2_4/VSUBS 0.63396f
C38 a_650_n277# via_dev$11$2_4/VSUBS 0.37069f
C39 a_25_271# via_dev$11$2_4/VSUBS 0.66513f
C40 a_846_955# via_dev$11$2_4/VSUBS 0.36058f
C41 w_n310_281# via_dev$11$2_4/VSUBS 4.41885f
.ends

.subckt AND4$2 w_237_91# a_992_79# a_372_n441# a_1200_79# a_1686_n317# a_784_79# a_704_n441#
+ a_576_79# a_912_n441# a_518_229# a_1120_n441#
X0 w_237_91# a_992_79# a_518_229# w_237_91# pfet_03v3 ad=0.38p pd=1.76u as=0.38p ps=1.76u w=1u l=0.28u
X1 a_518_229# a_784_79# w_237_91# w_237_91# pfet_03v3 ad=0.38p pd=1.76u as=0.38p ps=1.76u w=1u l=0.28u
X2 a_1686_n317# a_518_229# w_237_91# w_237_91# pfet_03v3 ad=0.65p pd=3.3u as=0.65p ps=3.3u w=1u l=0.28u
X3 a_912_n441# a_784_79# a_704_n441# a_372_n441# nfet_03v3 ad=0.76p pd=2.76u as=0.76p ps=2.76u w=2u l=0.28u
X4 w_237_91# a_576_79# a_518_229# w_237_91# pfet_03v3 ad=0.38p pd=1.76u as=0.65p ps=3.3u w=1u l=0.28u
X5 a_704_n441# a_576_79# a_372_n441# a_372_n441# nfet_03v3 ad=0.76p pd=2.76u as=1.34p ps=5.34u w=2u l=0.28u
X6 a_518_229# a_1200_79# a_1120_n441# a_372_n441# nfet_03v3 ad=1.14p pd=5.14u as=0.76p ps=2.76u w=2u l=0.28u
X7 a_1686_n317# a_518_229# a_372_n441# a_372_n441# nfet_03v3 ad=0.315p pd=2.26u as=0.295p ps=2.18u w=0.5u l=0.28u
X8 a_518_229# a_1200_79# w_237_91# w_237_91# pfet_03v3 ad=0.55p pd=3.1u as=0.38p ps=1.76u w=1u l=0.28u
X9 a_1120_n441# a_992_79# a_912_n441# a_372_n441# nfet_03v3 ad=0.76p pd=2.76u as=0.76p ps=2.76u w=2u l=0.28u
C0 a_992_79# a_1200_79# 0.06396f
C1 a_518_229# a_1200_79# 0.20239f
C2 a_784_79# w_237_91# 0.14715f
C3 a_518_229# a_1120_n441# 0.02253f
C4 a_784_79# a_992_79# 0.06396f
C5 a_784_79# a_518_229# 0.11673f
C6 a_992_79# w_237_91# 0.1469f
C7 a_518_229# w_237_91# 1.12672f
C8 a_992_79# a_518_229# 0.12168f
C9 a_784_79# a_576_79# 0.06396f
C10 a_784_79# a_704_n441# 0.00663f
C11 a_576_79# w_237_91# 0.16514f
C12 a_1120_n441# a_1200_79# 0.00663f
C13 w_237_91# a_1686_n317# 0.1612f
C14 a_518_229# a_576_79# 0.11544f
C15 a_518_229# a_704_n441# 0.01032f
C16 a_992_79# a_912_n441# 0.00663f
C17 a_912_n441# a_518_229# 0.01471f
C18 a_518_229# a_1686_n317# 0.12995f
C19 a_1200_79# w_237_91# 0.15686f
C20 a_1120_n441# a_372_n441# 0.02626f
C21 a_912_n441# a_372_n441# 0.02949f
C22 a_704_n441# a_372_n441# 0.03642f
C23 a_1686_n317# a_372_n441# 0.20646f
C24 a_518_229# a_372_n441# 0.81795f
C25 a_1200_79# a_372_n441# 0.2334f
C26 a_992_79# a_372_n441# 0.22559f
C27 a_784_79# a_372_n441# 0.22803f
C28 a_576_79# a_372_n441# 0.27946f
C29 w_237_91# a_372_n441# 2.88366f
.ends

.subckt x1bitblock$5 a_2861_3# a_8361_407# a_6520_n37# a_1262_n37# a_2861_391# a_1845_466#
+ a_10906_n37# a_510_63# a_870_n37# a_6721_407# a_9800_n37# a_11480_63# a_6128_n37#
+ a_5768_63# m2_6151_79# a_11922_391# a_5042_n37# a_9408_n37# a_8918_357# a_9609_407#
+ a_5042_407# a_8160_n37# a_4158_271# a_11922_3# a_2419_63# m2_9431_79# a_10906_466#
+ a_4650_n37# a_3498_3# a_9050_63# a_5243_407# a_7768_n37# a_3940_63# m2_7791_79#
+ a_10363_63# a_160_63# a_4290_63# a_7083_63# a_705_407# a_12559_3# a_7410_63# a_1845_n37#
+ via_dev$5$5_9/VSUBS m2_1295_79# a_8723_63# a_378_271# m2_5700_324# w_n310_281# m2_24_342#
X0 a_2419_63# a_1845_466# via_dev$5$5_9/VSUBS via_dev$5$5_9/VSUBS nfet_03v3 ad=0.315p pd=2.26u as=0.2425p ps=1.97u w=0.5u l=0.28u
X1 a_1845_466# m2_24_342# a_1845_n37# via_dev$5$5_9/VSUBS nfet_03v3 ad=0.65p pd=3.3u as=0.42p ps=1.84u w=1u l=0.28u
X2 a_3940_63# m2_1295_79# w_n310_281# w_n310_281# pfet_03v3 ad=0.63p pd=3.26u as=0.65p ps=3.3u w=1u l=0.28u
X3 via_dev$5$5_9/VSUBS a_510_63# a_1262_n37# via_dev$5$5_9/VSUBS nfet_03v3 ad=0.65p pd=3.3u as=0.3625p ps=1.725u w=1u l=0.28u
X4 a_5243_407# a_4290_63# a_5042_407# w_n310_281# pfet_03v3 ad=1.3p pd=5.3u as=0.725p ps=2.725u w=2u l=0.28u
X5 a_6721_407# a_2419_63# m2_6151_79# w_n310_281# pfet_03v3 ad=0.675p pd=2.675u as=0.725p ps=2.725u w=2u l=0.28u
X6 a_10906_466# a_4158_271# w_n310_281# w_n310_281# pfet_03v3 ad=0.42p pd=1.84u as=0.65p ps=3.3u w=1u l=0.28u
X7 a_4290_63# a_4158_271# via_dev$5$5_9/VSUBS via_dev$5$5_9/VSUBS nfet_03v3 ad=0.315p pd=2.26u as=0.28p ps=2.12u w=0.5u l=0.28u
X8 w_n310_281# a_378_271# a_705_407# w_n310_281# pfet_03v3 ad=0.725p pd=2.725u as=1.09p ps=5.09u w=2u l=0.28u
X9 a_2861_3# m2_1295_79# via_dev$5$5_9/VSUBS via_dev$5$5_9/VSUBS nfet_03v3 ad=0.18125p pd=1.225u as=0.325p ps=2.3u w=0.5u l=0.28u
X10 via_dev$5$5_9/VSUBS a_2419_63# a_2861_3# via_dev$5$5_9/VSUBS nfet_03v3 ad=0.315p pd=2.26u as=0.18125p ps=1.225u w=0.5u l=0.28u
X11 m2_7791_79# m2_1295_79# a_7768_n37# via_dev$5$5_9/VSUBS nfet_03v3 ad=0.3375p pd=1.675u as=0.3625p ps=1.725u w=1u l=0.28u
X12 a_10906_n37# a_4158_271# via_dev$5$5_9/VSUBS via_dev$5$5_9/VSUBS nfet_03v3 ad=0.42p pd=1.84u as=0.63p ps=3.26u w=1u l=0.28u
X13 a_9050_63# a_8918_357# via_dev$5$5_9/VSUBS via_dev$5$5_9/VSUBS nfet_03v3 ad=0.31p pd=2.24u as=0.24p ps=1.96u w=0.5u l=0.28u
X14 a_11922_3# a_11480_63# via_dev$5$5_9/VSUBS via_dev$5$5_9/VSUBS nfet_03v3 ad=0.18125p pd=1.225u as=0.325p ps=2.3u w=0.5u l=0.28u
X15 via_dev$5$5_9/VSUBS a_2419_63# a_11922_3# via_dev$5$5_9/VSUBS nfet_03v3 ad=0.315p pd=2.26u as=0.18125p ps=1.225u w=0.5u l=0.28u
X16 a_705_407# a_510_63# m2_1295_79# w_n310_281# pfet_03v3 ad=1.3p pd=5.3u as=0.725p ps=2.725u w=2u l=0.28u
X17 a_4650_n37# a_4158_271# via_dev$5$5_9/VSUBS via_dev$5$5_9/VSUBS nfet_03v3 ad=0.3625p pd=1.725u as=0.54p ps=3.08u w=1u l=0.28u
X18 a_2861_3# a_2419_63# a_2861_391# w_n310_281# pfet_03v3 ad=1.3p pd=5.3u as=0.725p ps=2.725u w=2u l=0.28u
X19 a_5768_63# m2_5700_324# via_dev$5$5_9/VSUBS via_dev$5$5_9/VSUBS nfet_03v3 ad=0.315p pd=2.26u as=0.3175p ps=2.27u w=0.5u l=0.28u
X20 via_dev$5$5_9/VSUBS a_9050_63# a_9800_n37# via_dev$5$5_9/VSUBS nfet_03v3 ad=0.65p pd=3.3u as=0.3625p ps=1.725u w=1u l=0.28u
X21 a_8361_407# m2_1295_79# m2_7791_79# w_n310_281# pfet_03v3 ad=0.675p pd=2.675u as=0.725p ps=2.725u w=2u l=0.28u
X22 a_9408_n37# a_8918_357# via_dev$5$5_9/VSUBS via_dev$5$5_9/VSUBS nfet_03v3 ad=0.3625p pd=1.725u as=0.54p ps=3.08u w=1u l=0.28u
X23 a_3498_3# a_2861_3# w_n310_281# w_n310_281# pfet_03v3 ad=0.65p pd=3.3u as=0.675p ps=3.35u w=1u l=0.28u
X24 a_7410_63# m2_5700_324# via_dev$5$5_9/VSUBS via_dev$5$5_9/VSUBS nfet_03v3 ad=0.31p pd=2.24u as=0.24p ps=1.96u w=0.5u l=0.28u
X25 via_dev$5$5_9/VSUBS a_7410_63# a_8160_n37# via_dev$5$5_9/VSUBS nfet_03v3 ad=0.65p pd=3.3u as=0.3625p ps=1.725u w=1u l=0.28u
X26 a_8723_63# m2_7791_79# via_dev$5$5_9/VSUBS via_dev$5$5_9/VSUBS nfet_03v3 ad=0.2625p pd=2.05u as=0.265p ps=2.06u w=0.5u l=0.28u
X27 w_n310_281# a_4158_271# a_5243_407# w_n310_281# pfet_03v3 ad=0.725p pd=2.725u as=1.09p ps=5.09u w=2u l=0.28u
X28 a_5768_63# m2_5700_324# w_n310_281# w_n310_281# pfet_03v3 ad=0.65p pd=3.3u as=0.635p ps=3.27u w=1u l=0.28u
X29 a_9050_63# a_8918_357# w_n310_281# w_n310_281# pfet_03v3 ad=0.64p pd=3.28u as=0.48p ps=2.96u w=1u l=0.28u
X30 a_11922_391# a_11480_63# w_n310_281# w_n310_281# pfet_03v3 ad=0.725p pd=2.725u as=1.3p ps=5.3u w=2u l=0.28u
X31 a_160_63# m2_24_342# via_dev$5$5_9/VSUBS via_dev$5$5_9/VSUBS nfet_03v3 ad=0.315p pd=2.26u as=0.325p ps=2.3u w=0.5u l=0.28u
X32 a_9609_407# a_9050_63# w_n310_281# w_n310_281# pfet_03v3 ad=1.3p pd=5.3u as=0.725p ps=2.725u w=2u l=0.28u
X33 a_6128_n37# m2_5700_324# via_dev$5$5_9/VSUBS via_dev$5$5_9/VSUBS nfet_03v3 ad=0.3625p pd=1.725u as=0.54p ps=3.08u w=1u l=0.28u
X34 via_dev$5$5_9/VSUBS a_5768_63# a_6520_n37# via_dev$5$5_9/VSUBS nfet_03v3 ad=0.65p pd=3.3u as=0.3625p ps=1.725u w=1u l=0.28u
X35 a_7410_63# m2_5700_324# w_n310_281# w_n310_281# pfet_03v3 ad=0.64p pd=3.28u as=0.48p ps=2.96u w=1u l=0.28u
X36 m2_9431_79# a_8918_357# a_9609_407# w_n310_281# pfet_03v3 ad=0.725p pd=2.725u as=1.09p ps=5.09u w=2u l=0.28u
X37 a_11480_63# a_10906_466# via_dev$5$5_9/VSUBS via_dev$5$5_9/VSUBS nfet_03v3 ad=0.315p pd=2.26u as=0.2425p ps=1.97u w=0.5u l=0.28u
X38 a_1845_466# a_378_271# w_n310_281# w_n310_281# pfet_03v3 ad=0.42p pd=1.84u as=0.65p ps=3.3u w=1u l=0.28u
X39 a_8361_407# a_7410_63# w_n310_281# w_n310_281# pfet_03v3 ad=1.3p pd=5.3u as=0.725p ps=2.725u w=2u l=0.28u
X40 w_n310_281# m2_1295_79# a_10906_466# w_n310_281# pfet_03v3 ad=0.735p pd=2.47u as=0.42p ps=1.84u w=1u l=0.28u
X41 a_7083_63# m2_6151_79# via_dev$5$5_9/VSUBS via_dev$5$5_9/VSUBS nfet_03v3 ad=0.2625p pd=2.05u as=0.265p ps=2.06u w=0.5u l=0.28u
X42 a_510_63# a_378_271# w_n310_281# w_n310_281# pfet_03v3 ad=0.65p pd=3.3u as=0.56p ps=3.12u w=1u l=0.28u
X43 a_10363_63# m2_9431_79# w_n310_281# w_n310_281# pfet_03v3 ad=0.715p pd=3.43u as=0.53p ps=3.06u w=1u l=0.28u
X44 a_510_63# a_378_271# via_dev$5$5_9/VSUBS via_dev$5$5_9/VSUBS nfet_03v3 ad=0.315p pd=2.26u as=0.28p ps=2.12u w=0.5u l=0.28u
X45 a_1262_n37# a_160_63# m2_1295_79# via_dev$5$5_9/VSUBS nfet_03v3 ad=0.3625p pd=1.725u as=0.3375p ps=1.675u w=1u l=0.28u
X46 a_1845_n37# a_378_271# via_dev$5$5_9/VSUBS via_dev$5$5_9/VSUBS nfet_03v3 ad=0.42p pd=1.84u as=0.63p ps=3.26u w=1u l=0.28u
X47 m2_6151_79# m2_5700_324# a_6721_407# w_n310_281# pfet_03v3 ad=0.725p pd=2.725u as=1.09p ps=5.09u w=2u l=0.28u
X48 a_6721_407# a_5768_63# w_n310_281# w_n310_281# pfet_03v3 ad=1.3p pd=5.3u as=0.725p ps=2.725u w=2u l=0.28u
X49 a_10363_63# m2_9431_79# via_dev$5$5_9/VSUBS via_dev$5$5_9/VSUBS nfet_03v3 ad=0.3575p pd=2.43u as=0.265p ps=2.06u w=0.5u l=0.28u
X50 a_10906_466# m2_1295_79# a_10906_n37# via_dev$5$5_9/VSUBS nfet_03v3 ad=0.65p pd=3.3u as=0.42p ps=1.84u w=1u l=0.28u
X51 a_8723_63# m2_7791_79# w_n310_281# w_n310_281# pfet_03v3 ad=0.545p pd=3.09u as=0.53p ps=3.06u w=1u l=0.28u
X52 a_11480_63# a_10906_466# w_n310_281# w_n310_281# pfet_03v3 ad=0.65p pd=3.3u as=0.735p ps=2.47u w=1u l=0.28u
X53 a_12559_3# a_11922_3# via_dev$5$5_9/VSUBS via_dev$5$5_9/VSUBS nfet_03v3 ad=0.315p pd=2.26u as=0.325p ps=2.3u w=0.5u l=0.28u
X54 a_7083_63# m2_6151_79# w_n310_281# w_n310_281# pfet_03v3 ad=0.545p pd=3.09u as=0.53p ps=3.06u w=1u l=0.28u
X55 a_7768_n37# m2_5700_324# via_dev$5$5_9/VSUBS via_dev$5$5_9/VSUBS nfet_03v3 ad=0.3625p pd=1.725u as=0.54p ps=3.08u w=1u l=0.28u
X56 a_160_63# m2_24_342# w_n310_281# w_n310_281# pfet_03v3 ad=0.63p pd=3.26u as=0.65p ps=3.3u w=1u l=0.28u
X57 m2_1295_79# a_160_63# a_705_407# w_n310_281# pfet_03v3 ad=0.725p pd=2.725u as=0.675p ps=2.675u w=2u l=0.28u
X58 a_5042_n37# a_3940_63# a_5042_407# via_dev$5$5_9/VSUBS nfet_03v3 ad=0.3625p pd=1.725u as=0.3375p ps=1.675u w=1u l=0.28u
X59 m2_1295_79# m2_24_342# a_870_n37# via_dev$5$5_9/VSUBS nfet_03v3 ad=0.3375p pd=1.675u as=0.3625p ps=1.725u w=1u l=0.28u
X60 a_11922_3# a_2419_63# a_11922_391# w_n310_281# pfet_03v3 ad=1.3p pd=5.3u as=0.725p ps=2.725u w=2u l=0.28u
X61 a_9800_n37# a_7083_63# m2_9431_79# via_dev$5$5_9/VSUBS nfet_03v3 ad=0.3625p pd=1.725u as=0.3375p ps=1.675u w=1u l=0.28u
X62 m2_7791_79# m2_5700_324# a_8361_407# w_n310_281# pfet_03v3 ad=0.725p pd=2.725u as=1.09p ps=5.09u w=2u l=0.28u
X63 a_5042_407# a_3940_63# a_5243_407# w_n310_281# pfet_03v3 ad=0.725p pd=2.725u as=0.675p ps=2.675u w=2u l=0.28u
X64 a_3940_63# m2_1295_79# via_dev$5$5_9/VSUBS via_dev$5$5_9/VSUBS nfet_03v3 ad=0.315p pd=2.26u as=0.325p ps=2.3u w=0.5u l=0.28u
X65 a_8160_n37# a_3498_3# m2_7791_79# via_dev$5$5_9/VSUBS nfet_03v3 ad=0.3625p pd=1.725u as=0.3375p ps=1.675u w=1u l=0.28u
X66 a_705_407# m2_24_342# w_n310_281# w_n310_281# pfet_03v3 ad=0.675p pd=2.675u as=0.725p ps=2.725u w=2u l=0.28u
X67 a_5042_407# m2_1295_79# a_4650_n37# via_dev$5$5_9/VSUBS nfet_03v3 ad=0.3375p pd=1.675u as=0.3625p ps=1.725u w=1u l=0.28u
X68 a_6520_n37# a_5042_407# m2_6151_79# via_dev$5$5_9/VSUBS nfet_03v3 ad=0.3625p pd=1.725u as=0.3375p ps=1.675u w=1u l=0.28u
X69 w_n310_281# a_7083_63# a_9609_407# w_n310_281# pfet_03v3 ad=0.725p pd=2.725u as=0.675p ps=2.675u w=2u l=0.28u
X70 a_2419_63# a_1845_466# w_n310_281# w_n310_281# pfet_03v3 ad=0.65p pd=3.3u as=0.735p ps=2.47u w=1u l=0.28u
X71 m2_9431_79# a_8723_63# a_9408_n37# via_dev$5$5_9/VSUBS nfet_03v3 ad=0.3375p pd=1.675u as=0.3625p ps=1.725u w=1u l=0.28u
X72 w_n310_281# a_3498_3# a_8361_407# w_n310_281# pfet_03v3 ad=0.725p pd=2.725u as=0.675p ps=2.675u w=2u l=0.28u
X73 a_2861_391# m2_1295_79# w_n310_281# w_n310_281# pfet_03v3 ad=0.725p pd=2.725u as=1.3p ps=5.3u w=2u l=0.28u
X74 a_4290_63# a_4158_271# w_n310_281# w_n310_281# pfet_03v3 ad=0.65p pd=3.3u as=0.56p ps=3.12u w=1u l=0.28u
X75 a_5243_407# m2_1295_79# w_n310_281# w_n310_281# pfet_03v3 ad=0.675p pd=2.675u as=0.725p ps=2.725u w=2u l=0.28u
X76 w_n310_281# a_5042_407# a_6721_407# w_n310_281# pfet_03v3 ad=0.725p pd=2.725u as=0.675p ps=2.675u w=2u l=0.28u
X77 a_3498_3# a_2861_3# via_dev$5$5_9/VSUBS via_dev$5$5_9/VSUBS nfet_03v3 ad=0.315p pd=2.26u as=0.325p ps=2.3u w=0.5u l=0.28u
X78 a_9609_407# a_8723_63# m2_9431_79# w_n310_281# pfet_03v3 ad=0.675p pd=2.675u as=0.725p ps=2.725u w=2u l=0.28u
X79 via_dev$5$5_9/VSUBS a_4290_63# a_5042_n37# via_dev$5$5_9/VSUBS nfet_03v3 ad=0.65p pd=3.3u as=0.3625p ps=1.725u w=1u l=0.28u
X80 m2_6151_79# a_2419_63# a_6128_n37# via_dev$5$5_9/VSUBS nfet_03v3 ad=0.3375p pd=1.675u as=0.3625p ps=1.725u w=1u l=0.28u
X81 w_n310_281# m2_24_342# a_1845_466# w_n310_281# pfet_03v3 ad=0.735p pd=2.47u as=0.42p ps=1.84u w=1u l=0.28u
X82 a_870_n37# a_378_271# via_dev$5$5_9/VSUBS via_dev$5$5_9/VSUBS nfet_03v3 ad=0.3625p pd=1.725u as=0.54p ps=3.08u w=1u l=0.28u
X83 a_12559_3# a_11922_3# w_n310_281# w_n310_281# pfet_03v3 ad=0.65p pd=3.3u as=0.675p ps=3.35u w=1u l=0.28u
C0 a_9050_63# a_7083_63# 0.21474f
C1 a_2419_63# w_n310_281# 0.7514f
C2 a_1845_466# a_3940_63# 0
C3 a_7768_n37# a_7083_63# 0.0028f
C4 a_2861_3# w_n310_281# 0.4655f
C5 m2_5700_324# a_7083_63# 0.12051f
C6 m2_5700_324# a_5768_63# 0.16447f
C7 m2_7791_79# a_7083_63# 0.14708f
C8 a_5768_63# m2_7791_79# 0
C9 a_2419_63# a_10363_63# 0.00126f
C10 a_1262_n37# m2_1295_79# 0.01607f
C11 a_8361_407# a_7083_63# 0.01453f
C12 a_2419_63# m2_1295_79# 0.3246f
C13 a_10906_466# a_12559_3# 0
C14 w_n310_281# a_6721_407# 0.72579f
C15 a_2861_3# m2_1295_79# 0.15381f
C16 a_3498_3# a_7410_63# 0.11774f
C17 a_8723_63# a_7083_63# 0.15796f
C18 a_5042_407# a_5243_407# 0.29512f
C19 a_4158_271# a_11480_63# 0.00295f
C20 a_4158_271# a_9800_n37# 0.00497f
C21 a_6721_407# m2_1295_79# 0.00452f
C22 m2_24_342# a_1845_466# 0.06999f
C23 a_1845_466# a_378_271# 0.01278f
C24 a_11922_391# a_11480_63# 0.00152f
C25 m2_6151_79# a_6520_n37# 0.00766f
C26 a_10906_466# a_11480_63# 0.1131f
C27 a_4290_63# w_n310_281# 0.2819f
C28 a_5768_63# a_7083_63# 0.01494f
C29 w_n310_281# m2_6151_79# 0.44301f
C30 a_5243_407# a_5042_n37# 0
C31 a_2419_63# a_7410_63# 0.00801f
C32 a_510_63# a_870_n37# 0.01502f
C33 m2_5700_324# a_3940_63# 0.00132f
C34 a_9609_407# a_9050_63# 0.1261f
C35 a_5243_407# a_4158_271# 0.02964f
C36 a_1845_466# w_n310_281# 0.44517f
C37 a_5042_407# a_5042_n37# 0.01726f
C38 m2_7791_79# a_9609_407# 0
C39 m2_9431_79# a_9050_63# 0.328f
C40 a_4290_63# m2_1295_79# 0.13519f
C41 m2_1295_79# m2_6151_79# 0.00667f
C42 a_5042_407# a_4158_271# 0.63867f
C43 a_2419_63# a_12559_3# 0
C44 a_8918_357# a_4158_271# 0.00101f
C45 a_8361_407# a_9609_407# 0.00466f
C46 m2_9431_79# a_7768_n37# 0
C47 m2_7791_79# m2_9431_79# 0.01571f
C48 a_1845_466# m2_1295_79# 0.09644f
C49 a_4290_63# a_4650_n37# 0.01502f
C50 m2_24_342# a_705_407# 0.10607f
C51 a_705_407# a_378_271# 0.02817f
C52 a_8723_63# a_9609_407# 0.0593f
C53 a_8361_407# m2_9431_79# 0
C54 a_10906_n37# w_n310_281# 0
C55 a_5042_n37# a_4158_271# 0
C56 a_2861_391# a_3498_3# 0.00454f
C57 a_8723_63# m2_9431_79# 0.13485f
C58 a_3498_3# a_5243_407# 0.16427f
C59 a_2419_63# a_11480_63# 0.0769f
C60 a_3940_63# a_5768_63# 0
C61 a_10906_n37# a_10363_63# 0
C62 a_705_407# w_n310_281# 0.79414f
C63 a_510_63# a_1262_n37# 0.00898f
C64 w_n310_281# a_9050_63# 0.28931f
C65 a_7410_63# m2_6151_79# 0
C66 a_3498_3# a_5042_407# 0.02015f
C67 a_9609_407# a_7083_63# 0.0285f
C68 a_6128_n37# a_6721_407# 0
C69 a_10906_466# a_4158_271# 0.03873f
C70 m2_5700_324# w_n310_281# 1.65678f
C71 m2_7791_79# w_n310_281# 0.45143f
C72 m2_9431_79# a_7083_63# 0.19293f
C73 a_2861_391# a_2419_63# 0.0163f
C74 a_10363_63# a_9050_63# 0.01385f
C75 a_705_407# m2_1295_79# 0.30816f
C76 a_8361_407# w_n310_281# 0.75753f
C77 a_9050_63# m2_1295_79# 0.00716f
C78 a_2419_63# a_5243_407# 0
C79 a_2861_391# a_2861_3# 0.01616f
C80 m2_24_342# a_160_63# 0.42316f
C81 m2_5700_324# m2_1295_79# 0.07849f
C82 a_378_271# a_160_63# 0.09182f
C83 a_2861_3# a_5243_407# 0
C84 a_8723_63# w_n310_281# 0.33516f
C85 m2_7791_79# m2_1295_79# 0.05731f
C86 a_3498_3# a_4158_271# 0.00829f
C87 a_2419_63# a_5042_407# 0.08051f
C88 a_2419_63# a_8918_357# 0.01449f
C89 a_9408_n37# a_9050_63# 0.00935f
C90 a_6128_n37# m2_6151_79# 0.01733f
C91 a_8361_407# m2_1295_79# 0.02509f
C92 a_2861_3# a_5042_407# 0
C93 a_10363_63# a_8723_63# 0
C94 m2_7791_79# a_9408_n37# 0
C95 w_n310_281# a_160_63# 0.30515f
C96 a_8723_63# m2_1295_79# 0.00796f
C97 a_7083_63# a_6520_n37# 0.00272f
C98 a_5768_63# a_6520_n37# 0.01329f
C99 w_n310_281# a_7083_63# 0.31663f
C100 a_5768_63# w_n310_281# 0.31314f
C101 a_5042_407# a_6721_407# 0.03265f
C102 a_2419_63# a_4158_271# 0.14782f
C103 a_7410_63# a_7768_n37# 0.00935f
C104 m2_5700_324# a_7410_63# 0.14432f
C105 a_160_63# m2_1295_79# 0.09339f
C106 m2_7791_79# a_7410_63# 0.36168f
C107 a_10363_63# a_7083_63# 0.00582f
C108 a_1845_466# a_510_63# 0.01433f
C109 m2_1295_79# a_7083_63# 0.01071f
C110 a_2419_63# a_11922_391# 0.00754f
C111 a_1845_n37# w_n310_281# 0
C112 a_5768_63# m2_1295_79# 0.00766f
C113 a_8361_407# a_7410_63# 0.1423f
C114 a_2419_63# a_10906_466# 0.00833f
C115 a_4290_63# a_5243_407# 0.14023f
C116 m2_9431_79# a_9609_407# 0.49779f
C117 a_8160_n37# m2_7791_79# 0.01048f
C118 a_8723_63# a_7410_63# 0.01398f
C119 a_9408_n37# a_7083_63# 0.00336f
C120 a_4290_63# a_5042_407# 0.38112f
C121 a_5042_407# m2_6151_79# 0.20459f
C122 a_1845_n37# m2_1295_79# 0.00942f
C123 a_2419_63# a_3498_3# 0.01177f
C124 a_2861_3# a_3498_3# 0.09846f
C125 a_3940_63# w_n310_281# 0.30087f
C126 a_4290_63# a_5042_n37# 0.00898f
C127 a_5042_n37# m2_6151_79# 0
C128 a_7410_63# a_7083_63# 0.07718f
C129 a_510_63# a_705_407# 0.13828f
C130 a_9050_63# a_9800_n37# 0.01329f
C131 a_9609_407# w_n310_281# 0.7653f
C132 a_4290_63# a_4158_271# 0.11363f
C133 a_4158_271# m2_6151_79# 0.04334f
C134 a_3498_3# a_6721_407# 0
C135 a_2861_391# a_705_407# 0
C136 a_8160_n37# a_7083_63# 0.00507f
C137 a_3940_63# m2_1295_79# 0.46061f
C138 m2_24_342# a_378_271# 0.56715f
C139 m2_9431_79# w_n310_281# 0.46253f
C140 a_10363_63# a_9609_407# 0.01306f
C141 a_9609_407# m2_1295_79# 0.0093f
C142 a_2419_63# a_2861_3# 0.21478f
C143 a_3940_63# a_4650_n37# 0.00441f
C144 a_1845_466# a_870_n37# 0
C145 m2_5700_324# a_5243_407# 0.01927f
C146 a_10363_63# m2_9431_79# 0.07766f
C147 m2_24_342# w_n310_281# 0.66878f
C148 a_8918_357# a_9050_63# 0.09973f
C149 a_378_271# w_n310_281# 0.63374f
C150 m2_9431_79# m2_1295_79# 0.0078f
C151 a_9609_407# a_9408_n37# 0
C152 a_6128_n37# a_5768_63# 0.00935f
C153 a_11922_3# w_n310_281# 0.46598f
C154 m2_5700_324# a_5042_407# 0.06917f
C155 m2_5700_324# a_8918_357# 0
C156 a_4290_63# a_3498_3# 0.00876f
C157 a_10906_n37# a_4158_271# 0.00824f
C158 a_2419_63# a_6721_407# 0.01825f
C159 a_3498_3# m2_6151_79# 0
C160 m2_7791_79# a_5042_407# 0.00555f
C161 m2_7791_79# a_8918_357# 0.02763f
C162 a_510_63# a_160_63# 0.28903f
C163 m2_9431_79# a_9408_n37# 0.01733f
C164 a_8361_407# a_8918_357# 0
C165 m2_24_342# m2_1295_79# 0.04399f
C166 a_9800_n37# a_7083_63# 0.00527f
C167 a_378_271# m2_1295_79# 0.02669f
C168 a_1845_466# a_3498_3# 0.00105f
C169 a_11922_3# m2_1295_79# 0
C170 a_10906_n37# a_10906_466# 0.01333f
C171 a_4158_271# a_9050_63# 0.00717f
C172 a_8723_63# a_8918_357# 0.1249f
C173 m2_5700_324# a_4158_271# 0.00861f
C174 a_10363_63# w_n310_281# 0.15741f
C175 a_4290_63# a_2419_63# 0.00652f
C176 m2_7791_79# a_4158_271# 0
C177 m2_9431_79# a_7410_63# 0.00105f
C178 a_2419_63# m2_6151_79# 0.05852f
C179 w_n310_281# m2_1295_79# 2.35223f
C180 a_510_63# a_1845_n37# 0.0011f
C181 a_5768_63# a_5243_407# 0.00722f
C182 a_4290_63# a_2861_3# 0
C183 a_1845_466# a_1262_n37# 0
C184 a_2419_63# a_1845_466# 0.10509f
C185 a_5042_407# a_7083_63# 0.02611f
C186 a_8918_357# a_7083_63# 0.01057f
C187 a_8160_n37# m2_9431_79# 0
C188 a_5768_63# a_5042_407# 0.22596f
C189 a_10363_63# m2_1295_79# 0.00179f
C190 a_8723_63# a_4158_271# 0
C191 a_1845_466# a_2861_3# 0
C192 a_6721_407# m2_6151_79# 0.4935f
C193 m2_5700_324# a_3498_3# 0.55174f
C194 a_3498_3# m2_7791_79# 0.0296f
C195 w_n310_281# a_7410_63# 0.31086f
C196 a_9609_407# a_11480_63# 0
C197 a_4158_271# a_7083_63# 1.09133f
C198 a_11922_3# a_12559_3# 0.0899f
C199 a_5768_63# a_4158_271# 0.00573f
C200 a_3498_3# a_8361_407# 0.12093f
C201 a_870_n37# a_160_63# 0.00441f
C202 m2_9431_79# a_11480_63# 0
C203 a_705_407# a_1262_n37# 0
C204 a_2419_63# a_705_407# 0
C205 a_4290_63# m2_6151_79# 0
C206 m2_9431_79# a_9800_n37# 0.0074f
C207 a_3940_63# a_5243_407# 0.06737f
C208 a_3498_3# a_8723_63# 0.00575f
C209 a_10906_466# a_7083_63# 0
C210 a_2419_63# a_9050_63# 0.00801f
C211 a_7410_63# m2_1295_79# 0.07614f
C212 a_12559_3# w_n310_281# 0.08598f
C213 a_2861_3# a_705_407# 0
C214 a_2419_63# m2_5700_324# 0.074f
C215 a_3940_63# a_5042_407# 0.0941f
C216 a_2419_63# m2_7791_79# 0.00843f
C217 a_11922_3# a_11480_63# 0.04054f
C218 a_2419_63# a_8361_407# 0
C219 m2_24_342# a_510_63# 0.13025f
C220 a_9609_407# a_8918_357# 0.02942f
C221 a_510_63# a_378_271# 0.14298f
C222 a_3498_3# a_7083_63# 0.01356f
C223 a_3498_3# a_5768_63# 0
C224 a_2419_63# a_8723_63# 0.00649f
C225 m2_9431_79# a_8918_357# 0.03217f
C226 w_n310_281# a_11480_63# 0.37298f
C227 m2_5700_324# a_6721_407# 0.50857f
C228 a_3940_63# a_4158_271# 0.16366f
C229 a_510_63# w_n310_281# 0.28255f
C230 a_9609_407# a_4158_271# 0
C231 a_10363_63# a_11480_63# 0
C232 a_11480_63# m2_1295_79# 0.00126f
C233 a_2861_391# w_n310_281# 0.03535f
C234 a_2419_63# a_7083_63# 0.01345f
C235 a_8160_n37# a_7410_63# 0.01329f
C236 a_2419_63# a_5768_63# 0.07749f
C237 a_5243_407# w_n310_281# 0.78984f
C238 a_510_63# m2_1295_79# 0.39896f
C239 m2_9431_79# a_4158_271# 0.05572f
C240 a_4290_63# m2_5700_324# 0.01531f
C241 a_10906_466# a_9609_407# 0
C242 m2_5700_324# m2_6151_79# 0.14941f
C243 a_1845_466# a_705_407# 0.0126f
C244 a_5042_407# a_6520_n37# 0.00483f
C245 m2_7791_79# m2_6151_79# 0.00114f
C246 a_5042_407# w_n310_281# 0.29911f
C247 w_n310_281# a_8918_357# 0.49453f
C248 a_2861_391# m2_1295_79# 0.00841f
C249 a_10906_466# m2_9431_79# 0.00167f
C250 a_3498_3# a_3940_63# 0.04602f
C251 a_5243_407# m2_1295_79# 0.10989f
C252 a_6721_407# a_7083_63# 0.01268f
C253 a_5768_63# a_6721_407# 0.14017f
C254 a_11922_3# a_4158_271# 0.0013f
C255 a_10363_63# a_8918_357# 0
C256 a_5042_407# m2_1295_79# 0.03487f
C257 a_8918_357# m2_1295_79# 0.01371f
C258 a_4158_271# a_6520_n37# 0.00406f
C259 a_11922_3# a_11922_391# 0.01891f
C260 a_11922_3# a_10906_466# 0
C261 a_3498_3# m2_9431_79# 0
C262 w_n310_281# a_4158_271# 0.66883f
C263 a_5042_407# a_4650_n37# 0.00712f
C264 a_2419_63# a_3940_63# 0.00879f
C265 m2_6151_79# a_7083_63# 0.08089f
C266 w_n310_281# a_11922_391# 0.03535f
C267 a_4290_63# a_5768_63# 0.01093f
C268 a_5768_63# m2_6151_79# 0.35511f
C269 a_10363_63# a_4158_271# 0.02222f
C270 a_10906_466# w_n310_281# 0.44509f
C271 a_1845_466# a_160_63# 0
C272 a_2861_3# a_3940_63# 0
C273 a_2419_63# a_9609_407# 0
C274 m2_24_342# a_3498_3# 0
C275 a_4158_271# m2_1295_79# 0.16058f
C276 m2_7791_79# a_9050_63# 0.00127f
C277 a_5042_407# a_7410_63# 0
C278 a_8918_357# a_7410_63# 0
C279 a_2419_63# m2_9431_79# 0.00832f
C280 a_10906_466# a_10363_63# 0.02047f
C281 a_4158_271# a_4650_n37# 0.00383f
C282 a_870_n37# m2_1295_79# 0.00639f
C283 m2_7791_79# a_7768_n37# 0.01733f
C284 a_8361_407# a_9050_63# 0
C285 m2_5700_324# m2_7791_79# 0.05245f
C286 a_10906_466# m2_1295_79# 0.0692f
C287 a_3498_3# w_n310_281# 1.03377f
C288 a_8361_407# a_7768_n37# 0
C289 m2_5700_324# a_8361_407# 0.05956f
C290 a_1845_466# a_1845_n37# 0.01333f
C291 m2_7791_79# a_8361_407# 0.49779f
C292 a_8723_63# a_9050_63# 0.5277f
C293 m2_24_342# a_2419_63# 0.00234f
C294 m2_5700_324# a_8723_63# 0
C295 a_2419_63# a_11922_3# 0.16984f
C296 m2_7791_79# a_8723_63# 0.08381f
C297 a_4158_271# a_7410_63# 0
C298 a_3498_3# m2_1295_79# 0.3391f
C299 a_705_407# a_160_63# 0.06737f
C300 a_8723_63# a_8361_407# 0.01268f
C301 a_4290_63# a_3940_63# 0.28903f
C302 a_6128_n37# a_5042_407# 0.00376f
C303 a_4158_271# via_dev$5$5_9/VSUBS 2.6385f
C304 a_7083_63# via_dev$5$5_9/VSUBS 0.86585f
C305 a_8723_63# via_dev$5$5_9/VSUBS 0.40969f
C306 m2_9431_79# via_dev$5$5_9/VSUBS 0.75255f
C307 m2_7791_79# via_dev$5$5_9/VSUBS 0.74612f
C308 a_8361_407# via_dev$5$5_9/VSUBS 0.05216f
C309 m2_6151_79# via_dev$5$5_9/VSUBS 0.72815f
C310 a_6721_407# via_dev$5$5_9/VSUBS 0.01698f
C311 a_5042_407# via_dev$5$5_9/VSUBS 0.88916f
C312 a_3940_63# via_dev$5$5_9/VSUBS 0.46864f
C313 m2_1295_79# via_dev$5$5_9/VSUBS 3.34416f
C314 a_160_63# via_dev$5$5_9/VSUBS 0.5921f
C315 a_5243_407# via_dev$5$5_9/VSUBS 0.01661f
C316 a_705_407# via_dev$5$5_9/VSUBS 0.13677f
C317 a_3498_3# via_dev$5$5_9/VSUBS 1.27724f
C318 a_10906_n37# via_dev$5$5_9/VSUBS 0.02232f
C319 a_9800_n37# via_dev$5$5_9/VSUBS 0.01742f
C320 a_9408_n37# via_dev$5$5_9/VSUBS 0.007f
C321 a_8160_n37# via_dev$5$5_9/VSUBS 0.01743f
C322 a_7768_n37# via_dev$5$5_9/VSUBS 0.007f
C323 a_6520_n37# via_dev$5$5_9/VSUBS 0.01743f
C324 a_6128_n37# via_dev$5$5_9/VSUBS 0.007f
C325 a_5042_n37# via_dev$5$5_9/VSUBS 0.00833f
C326 a_4650_n37# via_dev$5$5_9/VSUBS 0.01565f
C327 a_12559_3# via_dev$5$5_9/VSUBS 0.19481f
C328 a_11922_3# via_dev$5$5_9/VSUBS 0.64569f
C329 a_11922_391# via_dev$5$5_9/VSUBS 0.00119f
C330 a_10906_466# via_dev$5$5_9/VSUBS 0.59796f
C331 a_11480_63# via_dev$5$5_9/VSUBS 0.42359f
C332 a_10363_63# via_dev$5$5_9/VSUBS 0.13924f
C333 a_9050_63# via_dev$5$5_9/VSUBS 0.53264f
C334 a_8918_357# via_dev$5$5_9/VSUBS 0.52045f
C335 a_7410_63# via_dev$5$5_9/VSUBS 0.53731f
C336 a_5768_63# via_dev$5$5_9/VSUBS 0.54f
C337 a_1845_n37# via_dev$5$5_9/VSUBS 0.01974f
C338 a_1262_n37# via_dev$5$5_9/VSUBS 0.0069f
C339 a_870_n37# via_dev$5$5_9/VSUBS 0.01517f
C340 a_4290_63# via_dev$5$5_9/VSUBS 0.57048f
C341 a_2861_3# via_dev$5$5_9/VSUBS 0.62907f
C342 a_1845_466# via_dev$5$5_9/VSUBS 0.59853f
C343 a_2419_63# via_dev$5$5_9/VSUBS 6.64114f
C344 a_510_63# via_dev$5$5_9/VSUBS 0.55998f
C345 a_378_271# via_dev$5$5_9/VSUBS 1.37769f
C346 w_n310_281# via_dev$5$5_9/VSUBS 27.13356f
C347 m2_5700_324# via_dev$5$5_9/VSUBS 1.14834f
C348 m2_24_342# via_dev$5$5_9/VSUBS 1.98211f
C349 a_9609_407# via_dev$5$5_9/VSUBS 0.11967f
.ends

.subckt x1bitblock$1$2 a_2861_3# a_8361_407# a_6520_n37# a_1262_n37# a_2861_391# a_1845_466#
+ a_10906_n37# a_510_63# a_870_n37# a_6721_407# a_9800_n37# a_11480_63# a_6128_n37#
+ a_5768_63# m2_6151_79# a_11922_391# a_5042_n37# m2_24_342# a_9408_n37# a_9609_407#
+ a_5042_407# a_8160_n37# a_4158_271# a_11922_3# a_2419_63# m2_9431_79# a_10906_466#
+ a_4650_n37# a_9050_63# a_5243_407# a_7768_n37# a_160_63# a_3940_63# a_8919_370#
+ m2_7791_79# a_10363_63# a_4290_63# a_7083_63# a_3498_3# a_705_407# a_12559_3# a_7410_63#
+ m2_5700_324# a_1845_n37# via_dev$5$1$2_9/VSUBS m2_1295_79# a_8723_63# a_378_271#
+ w_n310_281#
X0 a_2419_63# a_1845_466# via_dev$5$1$2_9/VSUBS via_dev$5$1$2_9/VSUBS nfet_03v3 ad=0.315p pd=2.26u as=0.2425p ps=1.97u w=0.5u l=0.28u
X1 a_1845_466# m2_24_342# a_1845_n37# via_dev$5$1$2_9/VSUBS nfet_03v3 ad=0.65p pd=3.3u as=0.42p ps=1.84u w=1u l=0.28u
X2 a_3940_63# m2_1295_79# w_n310_281# w_n310_281# pfet_03v3 ad=0.63p pd=3.26u as=0.65p ps=3.3u w=1u l=0.28u
X3 via_dev$5$1$2_9/VSUBS a_510_63# a_1262_n37# via_dev$5$1$2_9/VSUBS nfet_03v3 ad=0.65p pd=3.3u as=0.3625p ps=1.725u w=1u l=0.28u
X4 a_5243_407# a_4290_63# a_5042_407# w_n310_281# pfet_03v3 ad=1.3p pd=5.3u as=0.725p ps=2.725u w=2u l=0.28u
X5 a_6721_407# a_2419_63# m2_6151_79# w_n310_281# pfet_03v3 ad=0.675p pd=2.675u as=0.725p ps=2.725u w=2u l=0.28u
X6 a_10906_466# a_4158_271# w_n310_281# w_n310_281# pfet_03v3 ad=0.42p pd=1.84u as=0.65p ps=3.3u w=1u l=0.28u
X7 a_4290_63# a_4158_271# via_dev$5$1$2_9/VSUBS via_dev$5$1$2_9/VSUBS nfet_03v3 ad=0.315p pd=2.26u as=0.28p ps=2.12u w=0.5u l=0.28u
X8 w_n310_281# a_378_271# a_705_407# w_n310_281# pfet_03v3 ad=0.725p pd=2.725u as=1.09p ps=5.09u w=2u l=0.28u
X9 a_2861_3# m2_1295_79# via_dev$5$1$2_9/VSUBS via_dev$5$1$2_9/VSUBS nfet_03v3 ad=0.18125p pd=1.225u as=0.325p ps=2.3u w=0.5u l=0.28u
X10 via_dev$5$1$2_9/VSUBS a_2419_63# a_2861_3# via_dev$5$1$2_9/VSUBS nfet_03v3 ad=0.315p pd=2.26u as=0.18125p ps=1.225u w=0.5u l=0.28u
X11 m2_7791_79# m2_1295_79# a_7768_n37# via_dev$5$1$2_9/VSUBS nfet_03v3 ad=0.3375p pd=1.675u as=0.3625p ps=1.725u w=1u l=0.28u
X12 a_10906_n37# a_4158_271# via_dev$5$1$2_9/VSUBS via_dev$5$1$2_9/VSUBS nfet_03v3 ad=0.42p pd=1.84u as=0.63p ps=3.26u w=1u l=0.28u
X13 a_9050_63# a_8919_370# via_dev$5$1$2_9/VSUBS via_dev$5$1$2_9/VSUBS nfet_03v3 ad=0.31p pd=2.24u as=0.24p ps=1.96u w=0.5u l=0.28u
X14 a_11922_3# a_11480_63# via_dev$5$1$2_9/VSUBS via_dev$5$1$2_9/VSUBS nfet_03v3 ad=0.18125p pd=1.225u as=0.325p ps=2.3u w=0.5u l=0.28u
X15 via_dev$5$1$2_9/VSUBS a_2419_63# a_11922_3# via_dev$5$1$2_9/VSUBS nfet_03v3 ad=0.315p pd=2.26u as=0.18125p ps=1.225u w=0.5u l=0.28u
X16 a_705_407# a_510_63# m2_1295_79# w_n310_281# pfet_03v3 ad=1.3p pd=5.3u as=0.725p ps=2.725u w=2u l=0.28u
X17 a_4650_n37# a_4158_271# via_dev$5$1$2_9/VSUBS via_dev$5$1$2_9/VSUBS nfet_03v3 ad=0.3625p pd=1.725u as=0.54p ps=3.08u w=1u l=0.28u
X18 a_2861_3# a_2419_63# a_2861_391# w_n310_281# pfet_03v3 ad=1.3p pd=5.3u as=0.725p ps=2.725u w=2u l=0.28u
X19 a_5768_63# m2_5700_324# via_dev$5$1$2_9/VSUBS via_dev$5$1$2_9/VSUBS nfet_03v3 ad=0.315p pd=2.26u as=0.3175p ps=2.27u w=0.5u l=0.28u
X20 via_dev$5$1$2_9/VSUBS a_9050_63# a_9800_n37# via_dev$5$1$2_9/VSUBS nfet_03v3 ad=0.65p pd=3.3u as=0.3625p ps=1.725u w=1u l=0.28u
X21 a_8361_407# m2_1295_79# m2_7791_79# w_n310_281# pfet_03v3 ad=0.675p pd=2.675u as=0.725p ps=2.725u w=2u l=0.28u
X22 a_9408_n37# a_8919_370# via_dev$5$1$2_9/VSUBS via_dev$5$1$2_9/VSUBS nfet_03v3 ad=0.3625p pd=1.725u as=0.54p ps=3.08u w=1u l=0.28u
X23 a_3498_3# a_2861_3# w_n310_281# w_n310_281# pfet_03v3 ad=0.65p pd=3.3u as=0.675p ps=3.35u w=1u l=0.28u
X24 a_7410_63# m2_5700_324# via_dev$5$1$2_9/VSUBS via_dev$5$1$2_9/VSUBS nfet_03v3 ad=0.31p pd=2.24u as=0.24p ps=1.96u w=0.5u l=0.28u
X25 via_dev$5$1$2_9/VSUBS a_7410_63# a_8160_n37# via_dev$5$1$2_9/VSUBS nfet_03v3 ad=0.65p pd=3.3u as=0.3625p ps=1.725u w=1u l=0.28u
X26 a_8723_63# m2_7791_79# via_dev$5$1$2_9/VSUBS via_dev$5$1$2_9/VSUBS nfet_03v3 ad=0.2625p pd=2.05u as=0.265p ps=2.06u w=0.5u l=0.28u
X27 w_n310_281# a_4158_271# a_5243_407# w_n310_281# pfet_03v3 ad=0.725p pd=2.725u as=1.09p ps=5.09u w=2u l=0.28u
X28 a_5768_63# m2_5700_324# w_n310_281# w_n310_281# pfet_03v3 ad=0.65p pd=3.3u as=0.635p ps=3.27u w=1u l=0.28u
X29 a_9050_63# a_8919_370# w_n310_281# w_n310_281# pfet_03v3 ad=0.64p pd=3.28u as=0.48p ps=2.96u w=1u l=0.28u
X30 a_11922_391# a_11480_63# w_n310_281# w_n310_281# pfet_03v3 ad=0.725p pd=2.725u as=1.3p ps=5.3u w=2u l=0.28u
X31 a_160_63# m2_24_342# via_dev$5$1$2_9/VSUBS via_dev$5$1$2_9/VSUBS nfet_03v3 ad=0.315p pd=2.26u as=0.325p ps=2.3u w=0.5u l=0.28u
X32 a_9609_407# a_9050_63# w_n310_281# w_n310_281# pfet_03v3 ad=1.3p pd=5.3u as=0.725p ps=2.725u w=2u l=0.28u
X33 a_6128_n37# m2_5700_324# via_dev$5$1$2_9/VSUBS via_dev$5$1$2_9/VSUBS nfet_03v3 ad=0.3625p pd=1.725u as=0.54p ps=3.08u w=1u l=0.28u
X34 via_dev$5$1$2_9/VSUBS a_5768_63# a_6520_n37# via_dev$5$1$2_9/VSUBS nfet_03v3 ad=0.65p pd=3.3u as=0.3625p ps=1.725u w=1u l=0.28u
X35 a_7410_63# m2_5700_324# w_n310_281# w_n310_281# pfet_03v3 ad=0.64p pd=3.28u as=0.48p ps=2.96u w=1u l=0.28u
X36 m2_9431_79# a_8919_370# a_9609_407# w_n310_281# pfet_03v3 ad=0.725p pd=2.725u as=1.09p ps=5.09u w=2u l=0.28u
X37 a_11480_63# a_10906_466# via_dev$5$1$2_9/VSUBS via_dev$5$1$2_9/VSUBS nfet_03v3 ad=0.315p pd=2.26u as=0.2425p ps=1.97u w=0.5u l=0.28u
X38 a_1845_466# a_378_271# w_n310_281# w_n310_281# pfet_03v3 ad=0.42p pd=1.84u as=0.65p ps=3.3u w=1u l=0.28u
X39 a_8361_407# a_7410_63# w_n310_281# w_n310_281# pfet_03v3 ad=1.3p pd=5.3u as=0.725p ps=2.725u w=2u l=0.28u
X40 w_n310_281# m2_1295_79# a_10906_466# w_n310_281# pfet_03v3 ad=0.735p pd=2.47u as=0.42p ps=1.84u w=1u l=0.28u
X41 a_7083_63# m2_6151_79# via_dev$5$1$2_9/VSUBS via_dev$5$1$2_9/VSUBS nfet_03v3 ad=0.2625p pd=2.05u as=0.265p ps=2.06u w=0.5u l=0.28u
X42 a_510_63# a_378_271# w_n310_281# w_n310_281# pfet_03v3 ad=0.65p pd=3.3u as=0.56p ps=3.12u w=1u l=0.28u
X43 a_10363_63# m2_9431_79# w_n310_281# w_n310_281# pfet_03v3 ad=0.715p pd=3.43u as=0.53p ps=3.06u w=1u l=0.28u
X44 a_510_63# a_378_271# via_dev$5$1$2_9/VSUBS via_dev$5$1$2_9/VSUBS nfet_03v3 ad=0.315p pd=2.26u as=0.28p ps=2.12u w=0.5u l=0.28u
X45 a_1262_n37# a_160_63# m2_1295_79# via_dev$5$1$2_9/VSUBS nfet_03v3 ad=0.3625p pd=1.725u as=0.3375p ps=1.675u w=1u l=0.28u
X46 a_1845_n37# a_378_271# via_dev$5$1$2_9/VSUBS via_dev$5$1$2_9/VSUBS nfet_03v3 ad=0.42p pd=1.84u as=0.63p ps=3.26u w=1u l=0.28u
X47 m2_6151_79# m2_5700_324# a_6721_407# w_n310_281# pfet_03v3 ad=0.725p pd=2.725u as=1.09p ps=5.09u w=2u l=0.28u
X48 a_6721_407# a_5768_63# w_n310_281# w_n310_281# pfet_03v3 ad=1.3p pd=5.3u as=0.725p ps=2.725u w=2u l=0.28u
X49 a_10363_63# m2_9431_79# via_dev$5$1$2_9/VSUBS via_dev$5$1$2_9/VSUBS nfet_03v3 ad=0.3575p pd=2.43u as=0.265p ps=2.06u w=0.5u l=0.28u
X50 a_10906_466# m2_1295_79# a_10906_n37# via_dev$5$1$2_9/VSUBS nfet_03v3 ad=0.65p pd=3.3u as=0.42p ps=1.84u w=1u l=0.28u
X51 a_8723_63# m2_7791_79# w_n310_281# w_n310_281# pfet_03v3 ad=0.545p pd=3.09u as=0.53p ps=3.06u w=1u l=0.28u
X52 a_11480_63# a_10906_466# w_n310_281# w_n310_281# pfet_03v3 ad=0.65p pd=3.3u as=0.735p ps=2.47u w=1u l=0.28u
X53 a_12559_3# a_11922_3# via_dev$5$1$2_9/VSUBS via_dev$5$1$2_9/VSUBS nfet_03v3 ad=0.315p pd=2.26u as=0.325p ps=2.3u w=0.5u l=0.28u
X54 a_7083_63# m2_6151_79# w_n310_281# w_n310_281# pfet_03v3 ad=0.545p pd=3.09u as=0.53p ps=3.06u w=1u l=0.28u
X55 a_7768_n37# m2_5700_324# via_dev$5$1$2_9/VSUBS via_dev$5$1$2_9/VSUBS nfet_03v3 ad=0.3625p pd=1.725u as=0.54p ps=3.08u w=1u l=0.28u
X56 a_160_63# m2_24_342# w_n310_281# w_n310_281# pfet_03v3 ad=0.63p pd=3.26u as=0.65p ps=3.3u w=1u l=0.28u
X57 m2_1295_79# a_160_63# a_705_407# w_n310_281# pfet_03v3 ad=0.725p pd=2.725u as=0.675p ps=2.675u w=2u l=0.28u
X58 a_5042_n37# a_3940_63# a_5042_407# via_dev$5$1$2_9/VSUBS nfet_03v3 ad=0.3625p pd=1.725u as=0.3375p ps=1.675u w=1u l=0.28u
X59 m2_1295_79# m2_24_342# a_870_n37# via_dev$5$1$2_9/VSUBS nfet_03v3 ad=0.3375p pd=1.675u as=0.3625p ps=1.725u w=1u l=0.28u
X60 a_11922_3# a_2419_63# a_11922_391# w_n310_281# pfet_03v3 ad=1.3p pd=5.3u as=0.725p ps=2.725u w=2u l=0.28u
X61 a_9800_n37# a_7083_63# m2_9431_79# via_dev$5$1$2_9/VSUBS nfet_03v3 ad=0.3625p pd=1.725u as=0.3375p ps=1.675u w=1u l=0.28u
X62 m2_7791_79# m2_5700_324# a_8361_407# w_n310_281# pfet_03v3 ad=0.725p pd=2.725u as=1.09p ps=5.09u w=2u l=0.28u
X63 a_5042_407# a_3940_63# a_5243_407# w_n310_281# pfet_03v3 ad=0.725p pd=2.725u as=0.675p ps=2.675u w=2u l=0.28u
X64 a_3940_63# m2_1295_79# via_dev$5$1$2_9/VSUBS via_dev$5$1$2_9/VSUBS nfet_03v3 ad=0.315p pd=2.26u as=0.325p ps=2.3u w=0.5u l=0.28u
X65 a_8160_n37# a_3498_3# m2_7791_79# via_dev$5$1$2_9/VSUBS nfet_03v3 ad=0.3625p pd=1.725u as=0.3375p ps=1.675u w=1u l=0.28u
X66 a_705_407# m2_24_342# w_n310_281# w_n310_281# pfet_03v3 ad=0.675p pd=2.675u as=0.725p ps=2.725u w=2u l=0.28u
X67 a_5042_407# m2_1295_79# a_4650_n37# via_dev$5$1$2_9/VSUBS nfet_03v3 ad=0.3375p pd=1.675u as=0.3625p ps=1.725u w=1u l=0.28u
X68 a_6520_n37# a_5042_407# m2_6151_79# via_dev$5$1$2_9/VSUBS nfet_03v3 ad=0.3625p pd=1.725u as=0.3375p ps=1.675u w=1u l=0.28u
X69 w_n310_281# a_7083_63# a_9609_407# w_n310_281# pfet_03v3 ad=0.725p pd=2.725u as=0.675p ps=2.675u w=2u l=0.28u
X70 a_2419_63# a_1845_466# w_n310_281# w_n310_281# pfet_03v3 ad=0.65p pd=3.3u as=0.735p ps=2.47u w=1u l=0.28u
X71 m2_9431_79# a_8723_63# a_9408_n37# via_dev$5$1$2_9/VSUBS nfet_03v3 ad=0.3375p pd=1.675u as=0.3625p ps=1.725u w=1u l=0.28u
X72 w_n310_281# a_3498_3# a_8361_407# w_n310_281# pfet_03v3 ad=0.725p pd=2.725u as=0.675p ps=2.675u w=2u l=0.28u
X73 a_2861_391# m2_1295_79# w_n310_281# w_n310_281# pfet_03v3 ad=0.725p pd=2.725u as=1.3p ps=5.3u w=2u l=0.28u
X74 a_4290_63# a_4158_271# w_n310_281# w_n310_281# pfet_03v3 ad=0.65p pd=3.3u as=0.56p ps=3.12u w=1u l=0.28u
X75 a_5243_407# m2_1295_79# w_n310_281# w_n310_281# pfet_03v3 ad=0.675p pd=2.675u as=0.725p ps=2.725u w=2u l=0.28u
X76 w_n310_281# a_5042_407# a_6721_407# w_n310_281# pfet_03v3 ad=0.725p pd=2.725u as=0.675p ps=2.675u w=2u l=0.28u
X77 a_3498_3# a_2861_3# via_dev$5$1$2_9/VSUBS via_dev$5$1$2_9/VSUBS nfet_03v3 ad=0.315p pd=2.26u as=0.325p ps=2.3u w=0.5u l=0.28u
X78 a_9609_407# a_8723_63# m2_9431_79# w_n310_281# pfet_03v3 ad=0.675p pd=2.675u as=0.725p ps=2.725u w=2u l=0.28u
X79 via_dev$5$1$2_9/VSUBS a_4290_63# a_5042_n37# via_dev$5$1$2_9/VSUBS nfet_03v3 ad=0.65p pd=3.3u as=0.3625p ps=1.725u w=1u l=0.28u
X80 m2_6151_79# a_2419_63# a_6128_n37# via_dev$5$1$2_9/VSUBS nfet_03v3 ad=0.3375p pd=1.675u as=0.3625p ps=1.725u w=1u l=0.28u
X81 w_n310_281# m2_24_342# a_1845_466# w_n310_281# pfet_03v3 ad=0.735p pd=2.47u as=0.42p ps=1.84u w=1u l=0.28u
X82 a_870_n37# a_378_271# via_dev$5$1$2_9/VSUBS via_dev$5$1$2_9/VSUBS nfet_03v3 ad=0.3625p pd=1.725u as=0.54p ps=3.08u w=1u l=0.28u
X83 a_12559_3# a_11922_3# w_n310_281# w_n310_281# pfet_03v3 ad=0.65p pd=3.3u as=0.675p ps=3.35u w=1u l=0.28u
C0 m2_9431_79# a_10363_63# 0.07766f
C1 w_n310_281# a_3940_63# 0.30087f
C2 a_870_n37# a_160_63# 0.00441f
C3 m2_7791_79# a_5042_407# 0.00555f
C4 a_7768_n37# a_7083_63# 0.0028f
C5 w_n310_281# a_10363_63# 0.15741f
C6 m2_1295_79# a_160_63# 0.09339f
C7 a_2419_63# a_11922_3# 0.16984f
C8 a_4290_63# a_5243_407# 0.14023f
C9 m2_5700_324# m2_1295_79# 0.07849f
C10 a_7410_63# a_7768_n37# 0.00935f
C11 a_6520_n37# a_5768_63# 0.01329f
C12 m2_6151_79# a_5042_407# 0.20459f
C13 a_2861_3# w_n310_281# 0.4655f
C14 a_2419_63# a_3498_3# 0.01177f
C15 a_5768_63# a_6721_407# 0.14017f
C16 a_378_271# w_n310_281# 0.6337f
C17 a_3498_3# a_3940_63# 0.04602f
C18 a_7083_63# a_5042_407# 0.02611f
C19 m2_24_342# a_705_407# 0.10607f
C20 a_7410_63# a_5042_407# 0
C21 a_5768_63# m2_7791_79# 0
C22 a_160_63# w_n310_281# 0.30515f
C23 m2_5700_324# w_n310_281# 1.65678f
C24 a_2861_3# a_3498_3# 0.09846f
C25 a_5768_63# m2_6151_79# 0.35511f
C26 a_4158_271# a_5042_407# 0.63867f
C27 a_5768_63# a_7083_63# 0.01494f
C28 m2_1295_79# a_9050_63# 0.00716f
C29 a_5042_n37# a_5042_407# 0.01726f
C30 a_870_n37# m2_1295_79# 0.00639f
C31 m2_5700_324# a_3498_3# 0.55174f
C32 a_2419_63# a_8361_407# 0
C33 a_9050_63# m2_9431_79# 0.328f
C34 a_5768_63# a_4158_271# 0.00573f
C35 a_4650_n37# a_4158_271# 0.00383f
C36 m2_1295_79# a_1262_n37# 0.01607f
C37 m2_1295_79# m2_9431_79# 0.0078f
C38 a_9050_63# w_n310_281# 0.28931f
C39 m2_1295_79# w_n310_281# 2.35219f
C40 a_2419_63# a_2861_391# 0.0163f
C41 a_10906_n37# w_n310_281# 0
C42 a_510_63# a_378_271# 0.14298f
C43 a_2419_63# a_5042_407# 0.08051f
C44 a_11922_3# m2_1295_79# 0
C45 w_n310_281# m2_9431_79# 0.46254f
C46 a_3940_63# a_5042_407# 0.0941f
C47 a_9050_63# a_9408_n37# 0.00935f
C48 m2_5700_324# a_8361_407# 0.05956f
C49 m2_1295_79# a_3498_3# 0.3391f
C50 a_510_63# a_160_63# 0.28903f
C51 a_2861_3# a_2861_391# 0.01616f
C52 a_2861_3# a_5042_407# 0
C53 a_2419_63# a_5768_63# 0.07749f
C54 a_3498_3# m2_9431_79# 0
C55 a_11922_3# w_n310_281# 0.46598f
C56 a_11922_391# a_11480_63# 0.00152f
C57 a_9800_n37# a_9050_63# 0.01329f
C58 a_5768_63# a_3940_63# 0
C59 a_4650_n37# a_3940_63# 0.00441f
C60 m2_9431_79# a_9408_n37# 0.01733f
C61 a_3498_3# w_n310_281# 1.03377f
C62 m2_5700_324# a_5042_407# 0.06917f
C63 a_2419_63# a_11922_391# 0.00754f
C64 a_4158_271# a_5243_407# 0.02964f
C65 a_4290_63# m2_6151_79# 0
C66 a_9050_63# a_8361_407# 0
C67 a_2419_63# a_1845_466# 0.10509f
C68 a_9800_n37# m2_9431_79# 0.0074f
C69 a_5042_n37# a_5243_407# 0
C70 m2_1295_79# a_8361_407# 0.02509f
C71 a_870_n37# a_510_63# 0.01502f
C72 a_1845_466# a_3940_63# 0
C73 a_510_63# m2_1295_79# 0.39896f
C74 a_5768_63# m2_5700_324# 0.16447f
C75 a_8919_370# m2_7791_79# 0.02774f
C76 a_8919_370# a_8723_63# 0.12581f
C77 a_2861_3# a_1845_466# 0
C78 a_9609_407# a_8919_370# 0.02942f
C79 m2_9431_79# a_8361_407# 0
C80 a_510_63# a_1262_n37# 0.00898f
C81 a_12559_3# a_10906_466# 0
C82 a_1845_466# a_378_271# 0.01278f
C83 a_4158_271# a_4290_63# 0.11363f
C84 w_n310_281# a_8361_407# 0.75753f
C85 m2_1295_79# a_2861_391# 0.00841f
C86 a_510_63# w_n310_281# 0.28255f
C87 a_8919_370# a_7083_63# 0.01057f
C88 a_5042_n37# a_4290_63# 0.00898f
C89 m2_9431_79# a_7768_n37# 0
C90 m2_1295_79# a_5042_407# 0.03487f
C91 a_1845_466# a_160_63# 0
C92 a_7410_63# a_8919_370# 0
C93 a_2419_63# a_5243_407# 0
C94 a_3498_3# a_8361_407# 0.12093f
C95 a_4158_271# a_8919_370# 0.001f
C96 a_3940_63# a_5243_407# 0.06737f
C97 a_2861_391# w_n310_281# 0.03535f
C98 a_5768_63# m2_1295_79# 0.00766f
C99 w_n310_281# a_5042_407# 0.29911f
C100 a_2419_63# m2_24_342# 0.00234f
C101 a_2861_3# a_5243_407# 0
C102 a_10906_466# a_9609_407# 0
C103 a_6520_n37# m2_6151_79# 0.00766f
C104 a_2861_391# a_3498_3# 0.00454f
C105 a_2419_63# a_705_407# 0
C106 a_2419_63# a_4290_63# 0.00652f
C107 a_6721_407# m2_6151_79# 0.4935f
C108 a_3498_3# a_5042_407# 0.02015f
C109 a_870_n37# a_1845_466# 0
C110 a_8723_63# m2_7791_79# 0.08396f
C111 a_6520_n37# a_7083_63# 0.00272f
C112 a_5768_63# w_n310_281# 0.31314f
C113 a_4290_63# a_3940_63# 0.28903f
C114 a_9609_407# m2_7791_79# 0
C115 a_6128_n37# a_5042_407# 0.00376f
C116 a_10906_466# a_7083_63# 0
C117 m2_5700_324# a_5243_407# 0.01927f
C118 a_1845_466# m2_1295_79# 0.09644f
C119 a_9609_407# a_8723_63# 0.0593f
C120 m2_7791_79# m2_6151_79# 0.00114f
C121 a_6721_407# a_7083_63# 0.01268f
C122 m2_24_342# a_378_271# 0.56715f
C123 a_2861_3# a_705_407# 0
C124 a_2861_3# a_4290_63# 0
C125 a_1845_466# a_1262_n37# 0
C126 m2_7791_79# a_7083_63# 0.14708f
C127 a_8723_63# a_7083_63# 0.15796f
C128 a_378_271# a_705_407# 0.02817f
C129 m2_24_342# a_160_63# 0.42316f
C130 a_6520_n37# a_4158_271# 0.00406f
C131 a_9609_407# a_7083_63# 0.0285f
C132 a_5768_63# a_3498_3# 0
C133 a_2419_63# a_8919_370# 0.01445f
C134 w_n310_281# a_11922_391# 0.03535f
C135 a_7410_63# m2_7791_79# 0.36168f
C136 a_10906_466# a_4158_271# 0.03873f
C137 a_7083_63# m2_6151_79# 0.08089f
C138 a_7410_63# a_8723_63# 0.01398f
C139 a_6128_n37# a_5768_63# 0.00935f
C140 a_1845_466# w_n310_281# 0.44517f
C141 a_7768_n37# a_8361_407# 0
C142 a_7410_63# m2_6151_79# 0
C143 a_160_63# a_705_407# 0.06737f
C144 a_8919_370# a_10363_63# 0
C145 m2_5700_324# a_4290_63# 0.01531f
C146 a_11922_3# a_11922_391# 0.01891f
C147 a_4158_271# m2_7791_79# 0
C148 a_4158_271# a_8723_63# 0
C149 a_7410_63# a_7083_63# 0.07718f
C150 a_4158_271# a_9609_407# 0
C151 a_2419_63# a_12559_3# 0
C152 a_4158_271# m2_6151_79# 0.04334f
C153 a_1845_466# a_3498_3# 0.00105f
C154 m2_1295_79# a_5243_407# 0.10989f
C155 a_5042_n37# m2_6151_79# 0
C156 a_4158_271# a_7083_63# 1.09133f
C157 a_10906_466# a_11480_63# 0.1131f
C158 a_8160_n37# m2_7791_79# 0.01048f
C159 a_7410_63# a_4158_271# 0
C160 m2_5700_324# a_8919_370# 0
C161 m2_24_342# m2_1295_79# 0.04399f
C162 a_2419_63# a_10906_466# 0.00833f
C163 a_9609_407# a_11480_63# 0
C164 w_n310_281# a_5243_407# 0.78984f
C165 a_8160_n37# a_7083_63# 0.00507f
C166 a_2419_63# a_6721_407# 0.01825f
C167 m2_1295_79# a_705_407# 0.30816f
C168 a_5042_n37# a_4158_271# 0
C169 a_7410_63# a_8160_n37# 0.01329f
C170 m2_1295_79# a_4290_63# 0.13519f
C171 a_10906_466# a_10363_63# 0.02047f
C172 a_2419_63# m2_7791_79# 0.00843f
C173 a_2419_63# a_8723_63# 0.00661f
C174 a_1262_n37# a_705_407# 0
C175 a_2419_63# a_9609_407# 0
C176 m2_24_342# w_n310_281# 0.66878f
C177 a_3498_3# a_5243_407# 0.16427f
C178 a_2419_63# m2_6151_79# 0.05852f
C179 a_1845_466# a_510_63# 0.01433f
C180 a_5768_63# a_5042_407# 0.22596f
C181 a_9050_63# a_8919_370# 0.10006f
C182 a_4650_n37# a_5042_407# 0.00712f
C183 a_10363_63# a_8723_63# 0
C184 a_1845_n37# m2_1295_79# 0.00942f
C185 w_n310_281# a_705_407# 0.79414f
C186 a_9609_407# a_10363_63# 0.01306f
C187 a_2419_63# a_7083_63# 0.01345f
C188 a_4290_63# w_n310_281# 0.2819f
C189 a_4158_271# a_11480_63# 0.00295f
C190 m2_1295_79# a_8919_370# 0.01372f
C191 a_2419_63# a_7410_63# 0.00801f
C192 m2_24_342# a_3498_3# 0
C193 m2_5700_324# a_6721_407# 0.50857f
C194 a_10363_63# a_7083_63# 0.00582f
C195 a_8919_370# m2_9431_79# 0.03216f
C196 a_2419_63# a_4158_271# 0.14782f
C197 a_3498_3# a_4290_63# 0.00876f
C198 m2_5700_324# m2_7791_79# 0.05245f
C199 a_1845_n37# w_n310_281# 0
C200 m2_5700_324# a_8723_63# 0
C201 a_4158_271# a_3940_63# 0.16366f
C202 a_8919_370# w_n310_281# 0.50001f
C203 m2_5700_324# m2_6151_79# 0.14941f
C204 a_4158_271# a_10363_63# 0.02222f
C205 m2_5700_324# a_7083_63# 0.12051f
C206 m2_5700_324# a_7410_63# 0.14432f
C207 a_12559_3# w_n310_281# 0.08598f
C208 a_2419_63# a_11480_63# 0.0769f
C209 a_10906_466# m2_1295_79# 0.0692f
C210 m2_24_342# a_510_63# 0.13025f
C211 m2_5700_324# a_4158_271# 0.00861f
C212 m2_1295_79# a_6721_407# 0.00452f
C213 a_12559_3# a_11922_3# 0.0899f
C214 a_9050_63# m2_7791_79# 0.00127f
C215 a_9050_63# a_8723_63# 0.53121f
C216 a_10906_466# a_10906_n37# 0.01333f
C217 a_9050_63# a_9609_407# 0.1261f
C218 a_10363_63# a_11480_63# 0
C219 a_5243_407# a_5042_407# 0.29512f
C220 m2_1295_79# m2_7791_79# 0.05731f
C221 a_510_63# a_705_407# 0.13828f
C222 m2_1295_79# a_8723_63# 0.00803f
C223 a_10906_466# m2_9431_79# 0.00167f
C224 m2_1295_79# a_9609_407# 0.0093f
C225 m2_1295_79# m2_6151_79# 0.00667f
C226 a_2419_63# a_3940_63# 0.00879f
C227 a_9050_63# a_7083_63# 0.21474f
C228 a_10906_466# w_n310_281# 0.44509f
C229 w_n310_281# a_6721_407# 0.72579f
C230 a_2419_63# a_10363_63# 0.00126f
C231 m2_9431_79# m2_7791_79# 0.01571f
C232 m2_9431_79# a_8723_63# 0.13485f
C233 m2_1295_79# a_7083_63# 0.01071f
C234 a_9609_407# m2_9431_79# 0.49779f
C235 a_2861_391# a_705_407# 0
C236 a_2419_63# a_2861_3# 0.21478f
C237 a_5768_63# a_5243_407# 0.00722f
C238 m2_1295_79# a_7410_63# 0.07614f
C239 a_11922_3# a_10906_466# 0
C240 w_n310_281# m2_7791_79# 0.45139f
C241 a_510_63# a_1845_n37# 0.0011f
C242 a_8919_370# a_8361_407# 0
C243 w_n310_281# a_8723_63# 0.33581f
C244 a_2861_3# a_3940_63# 0
C245 a_9609_407# w_n310_281# 0.7653f
C246 a_9050_63# a_4158_271# 0.00717f
C247 w_n310_281# m2_6151_79# 0.44301f
C248 a_4290_63# a_5042_407# 0.38112f
C249 m2_9431_79# a_7083_63# 0.19293f
C250 a_3498_3# a_6721_407# 0
C251 m2_1295_79# a_4158_271# 0.16058f
C252 a_7410_63# m2_9431_79# 0.00105f
C253 a_6128_n37# a_6721_407# 0
C254 a_2419_63# m2_5700_324# 0.074f
C255 w_n310_281# a_7083_63# 0.31663f
C256 a_3498_3# m2_7791_79# 0.0296f
C257 a_4158_271# a_10906_n37# 0.00824f
C258 a_3498_3# a_8723_63# 0.00575f
C259 a_7410_63# w_n310_281# 0.31086f
C260 m2_5700_324# a_3940_63# 0.00132f
C261 a_9408_n37# m2_7791_79# 0
C262 a_3498_3# m2_6151_79# 0
C263 a_4158_271# m2_9431_79# 0.05572f
C264 a_5768_63# a_4290_63# 0.01093f
C265 a_4650_n37# a_4290_63# 0.01502f
C266 a_9609_407# a_9408_n37# 0
C267 a_6128_n37# m2_6151_79# 0.01733f
C268 a_4158_271# w_n310_281# 0.66883f
C269 a_3498_3# a_7083_63# 0.01356f
C270 a_378_271# a_160_63# 0.09182f
C271 m2_24_342# a_1845_466# 0.06999f
C272 a_7410_63# a_3498_3# 0.11774f
C273 a_9408_n37# a_7083_63# 0.00336f
C274 m2_1295_79# a_11480_63# 0.00126f
C275 a_11922_3# a_4158_271# 0.0013f
C276 a_8160_n37# m2_9431_79# 0
C277 a_1845_466# a_705_407# 0.0126f
C278 a_2419_63# a_9050_63# 0.00801f
C279 a_4158_271# a_3498_3# 0.00829f
C280 m2_9431_79# a_11480_63# 0
C281 a_9800_n37# a_7083_63# 0.00527f
C282 a_2419_63# m2_1295_79# 0.32461f
C283 m2_7791_79# a_8361_407# 0.49779f
C284 a_8723_63# a_8361_407# 0.01268f
C285 a_9050_63# a_10363_63# 0.01385f
C286 m2_1295_79# a_3940_63# 0.46061f
C287 w_n310_281# a_11480_63# 0.37298f
C288 a_9609_407# a_8361_407# 0.00466f
C289 m2_1295_79# a_10363_63# 0.00179f
C290 a_1845_466# a_1845_n37# 0.01333f
C291 a_2419_63# m2_9431_79# 0.00832f
C292 a_7768_n37# m2_7791_79# 0.01733f
C293 a_6520_n37# a_5042_407# 0.00483f
C294 a_9800_n37# a_4158_271# 0.00497f
C295 a_2861_3# m2_1295_79# 0.15381f
C296 a_10906_n37# a_10363_63# 0
C297 a_11922_3# a_11480_63# 0.04054f
C298 a_8361_407# a_7083_63# 0.01453f
C299 a_2419_63# w_n310_281# 0.75141f
C300 a_6721_407# a_5042_407# 0.03265f
C301 a_7410_63# a_8361_407# 0.1423f
C302 a_378_271# m2_1295_79# 0.02669f
C303 a_4158_271# via_dev$5$1$2_9/VSUBS 2.63898f
C304 a_7083_63# via_dev$5$1$2_9/VSUBS 0.86585f
C305 a_8723_63# via_dev$5$1$2_9/VSUBS 0.41121f
C306 m2_9431_79# via_dev$5$1$2_9/VSUBS 0.75255f
C307 m2_7791_79# via_dev$5$1$2_9/VSUBS 0.74612f
C308 a_9609_407# via_dev$5$1$2_9/VSUBS 0.11967f
C309 a_8361_407# via_dev$5$1$2_9/VSUBS 0.05216f
C310 m2_6151_79# via_dev$5$1$2_9/VSUBS 0.72815f
C311 a_6721_407# via_dev$5$1$2_9/VSUBS 0.01698f
C312 a_5042_407# via_dev$5$1$2_9/VSUBS 0.88916f
C313 a_3940_63# via_dev$5$1$2_9/VSUBS 0.46864f
C314 m2_1295_79# via_dev$5$1$2_9/VSUBS 3.37184f
C315 a_160_63# via_dev$5$1$2_9/VSUBS 0.5921f
C316 a_5243_407# via_dev$5$1$2_9/VSUBS 0.01661f
C317 a_705_407# via_dev$5$1$2_9/VSUBS 0.13677f
C318 a_3498_3# via_dev$5$1$2_9/VSUBS 1.27724f
C319 a_10906_n37# via_dev$5$1$2_9/VSUBS 0.02232f
C320 a_9800_n37# via_dev$5$1$2_9/VSUBS 0.01742f
C321 a_9408_n37# via_dev$5$1$2_9/VSUBS 0.007f
C322 a_8160_n37# via_dev$5$1$2_9/VSUBS 0.01743f
C323 a_7768_n37# via_dev$5$1$2_9/VSUBS 0.007f
C324 a_6520_n37# via_dev$5$1$2_9/VSUBS 0.01743f
C325 a_6128_n37# via_dev$5$1$2_9/VSUBS 0.007f
C326 a_5042_n37# via_dev$5$1$2_9/VSUBS 0.00833f
C327 a_4650_n37# via_dev$5$1$2_9/VSUBS 0.01565f
C328 a_12559_3# via_dev$5$1$2_9/VSUBS 0.19481f
C329 a_11922_3# via_dev$5$1$2_9/VSUBS 0.64569f
C330 a_11922_391# via_dev$5$1$2_9/VSUBS 0.00119f
C331 a_10906_466# via_dev$5$1$2_9/VSUBS 0.59796f
C332 a_11480_63# via_dev$5$1$2_9/VSUBS 0.42359f
C333 a_10363_63# via_dev$5$1$2_9/VSUBS 0.13924f
C334 a_9050_63# via_dev$5$1$2_9/VSUBS 0.53264f
C335 a_8919_370# via_dev$5$1$2_9/VSUBS 0.51824f
C336 a_7410_63# via_dev$5$1$2_9/VSUBS 0.53731f
C337 a_5768_63# via_dev$5$1$2_9/VSUBS 0.54f
C338 a_1845_n37# via_dev$5$1$2_9/VSUBS 0.01974f
C339 a_1262_n37# via_dev$5$1$2_9/VSUBS 0.0069f
C340 a_870_n37# via_dev$5$1$2_9/VSUBS 0.01517f
C341 a_4290_63# via_dev$5$1$2_9/VSUBS 0.57048f
C342 a_2861_3# via_dev$5$1$2_9/VSUBS 0.62907f
C343 a_1845_466# via_dev$5$1$2_9/VSUBS 0.59853f
C344 a_2419_63# via_dev$5$1$2_9/VSUBS 6.64124f
C345 a_510_63# via_dev$5$1$2_9/VSUBS 0.55998f
C346 a_378_271# via_dev$5$1$2_9/VSUBS 1.37769f
C347 w_n310_281# via_dev$5$1$2_9/VSUBS 27.06296f
C348 m2_24_342# via_dev$5$1$2_9/VSUBS 1.98211f
C349 m2_5700_324# via_dev$5$1$2_9/VSUBS 1.14834f
.ends

.subckt x4bitblock$2 1bitblock$5_0/m2_6151_79# 1bitblock$3$2_0/a_8160_n37# 1bitblock$3$2_0/a_5042_407#
+ 1bitblock$1$2_0/a_8361_407# 1bitblock$2$2_0/m2_24_342# 1bitblock$3$2_0/m2_9431_79#
+ 1bitblock$1$2_0/a_8723_63# 1bitblock$3$2_0/a_4650_n37# 1bitblock$1$2_0/a_378_271#
+ 1bitblock$3$2_0/a_11922_3# 1bitblock$2$2_0/m2_6151_79# 1bitblock$3$2_0/a_2419_63#
+ 1bitblock$5_0/a_5042_n37# 1bitblock$2$2_0/a_4290_63# 1bitblock$3$2_0/a_2861_3# 1bitblock$5_0/a_9609_407#
+ 1bitblock$5_0/a_510_63# 1bitblock$3$2_0/a_5243_407# 1bitblock$5_0/a_5042_407# 1bitblock$5_0/a_8160_n37#
+ MUX21$2_0/a_909_n37# 1bitblock$2$2_0/a_7083_63# 1bitblock$3$2_0/a_7768_n37# 1bitblock$5_0/a_11922_3#
+ 1bitblock$2$2_0/a_7410_63# 1bitblock$2$2_0/a_5042_n37# 1bitblock$3$2_0/a_9050_63#
+ 1bitblock$5_0/m2_9431_79# 1bitblock$5_0/a_2419_63# 1bitblock$5_0/a_4650_n37# 1bitblock$2$2_0/a_9609_407#
+ 1bitblock$2$2_0/a_5042_407# 1bitblock$2$2_0/a_8160_n37# 1bitblock$3$2_0/m2_7791_79#
+ 1bitblock$2$2_0/m2_9431_79# 1bitblock$3$2_0/a_3940_63# 1bitblock$5_0/a_5243_407#
+ 1bitblock$5_0/a_9050_63# 1bitblock$3$2_0/a_10363_63# 1bitblock$2$2_0/a_4650_n37#
+ 1bitblock$1$2_0/m2_6151_79# 1bitblock$5_0/a_7768_n37# MUX21$2_0/a_517_n37# MUX21$2_0/a_718_407#
+ 1bitblock$3$2_0/a_510_63# 1bitblock$2$2_0/a_5243_407# 1bitblock$2$2_0/a_8723_63#
+ 1bitblock$2$2_0/a_378_271# 1bitblock$5_0/a_3940_63# 1bitblock$5_0/m2_7791_79# 1bitblock$2$2_0/a_7768_n37#
+ 1bitblock$1$2_0/a_5042_n37# 1bitblock$1$2_0/a_5768_63# 1bitblock$3$2_0/a_4290_63#
+ 1bitblock$5_0/a_10363_63# 1bitblock$1$2_0/a_10906_466# 1bitblock$1$2_0/a_9609_407#
+ 1bitblock$3$2_0/a_705_407# 1bitblock$1$2_0/a_8160_n37# 1bitblock$1$2_0/a_5042_407#
+ 1bitblock$2$2_0/m2_7791_79# 1bitblock$1$2_0/m2_9431_79# 1bitblock$3$2_0/a_7410_63#
+ 1bitblock$1$2_0/a_4650_n37# 1bitblock$5_0/a_4290_63# 1bitblock$2$2_0/a_10363_63#
+ 1bitblock$2$2_0/a_3498_3# 1bitblock$5_0/a_7083_63# 1bitblock$5_0/a_705_407# 1bitblock$1$2_0/a_5243_407#
+ 1bitblock$5_0/a_7410_63# 1bitblock$5_0/a_160_63# 1bitblock$1$2_0/a_7768_n37# 1bitblock$1$2_0/a_11922_3#
+ 1bitblock$1$2_0/a_2419_63# m1_12480_n3815# 1bitblock$3$2_0/a_10906_466# m1_8729_n3942#
+ AND4$2_0/a_518_229# 1bitblock$3$2_0/a_8723_63# MUX21$2_0/a_157_63# 1bitblock$3$2_0/a_378_271#
+ 1bitblock$1$2_0/m2_7791_79# 1bitblock$2$2_0/a_5768_63# 1bitblock$1$2_0/a_10363_63#
+ 1bitblock$3$2_0/a_8361_407# m2_14516_n651# 1bitblock$5_0/a_8723_63# MUX21$2_0/m2_540_79#
+ 1bitblock$1$2_0/m2_24_342# 1bitblock$5_0/a_378_271# 1bitblock$3$2_0/a_160_63# 1bitblock$1$2_0/a_3940_63#
+ 1bitblock$1$2_0/a_3498_3# 1bitblock$3$2_0/a_3498_3# 1bitblock$3$2_0/a_1845_466#
+ m1_12486_242# 1bitblock$3$2_0/a_7083_63# 1bitblock$5_0/a_8361_407# m2_1701_n784#
+ 1bitblock$5_0/a_3498_3# 1bitblock$2$2_0/a_11922_3# 1bitblock$3$2_0/a_6721_407# 1bitblock$3$2_0/a_11480_63#
+ 1bitblock$2$2_0/a_2419_63# 1bitblock$3$2_0/m2_24_342# 1bitblock$2$2_0/a_8361_407#
+ 1bitblock$1$2_0/a_7083_63# 1bitblock$1$2_0/a_4290_63# m2_2396_n2595# 1bitblock$5_0/a_1845_466#
+ 1bitblock$3$2_0/m2_6151_79# 1bitblock$3$2_0/a_5768_63# 1bitblock$1$2_0/a_7410_63#
+ MUX21$2_0/a_1472_63# m1_13543_n1146# m1_10807_n176# 1bitblock$5_0/a_6721_407# 1bitblock$5_0/a_11480_63#
+ 1bitblock$5_0/m2_24_342# 1bitblock$5_0/a_2861_3# m1_n563_n5091# 1bitblock$5_0/a_870_n37#
+ 1bitblock$3$2_0/a_5042_n37# 1bitblock$5_0/a_10906_466# 1bitblock$2$2_0/a_10906_466#
+ 1bitblock$5_0/a_5768_63# 1bitblock$2$2_0/a_3940_63# m2_5443_n3913# m2_10721_n3315#
+ VSUBS m1_12484_n953# m1_14167_n1145# 1bitblock$3$2_0/a_9609_407#
X1bitblock$3$2_0 1bitblock$3$2_0/a_2861_3# 1bitblock$3$2_0/a_8361_407# 1bitblock$3$2_0/a_6520_n37#
+ 1bitblock$3$2_0/a_1262_n37# 1bitblock$3$2_0/a_2861_391# 1bitblock$3$2_0/a_1845_466#
+ 1bitblock$3$2_0/a_10906_n37# 1bitblock$3$2_0/a_510_63# 1bitblock$3$2_0/a_870_n37#
+ 1bitblock$3$2_0/a_6721_407# 1bitblock$3$2_0/a_9800_n37# 1bitblock$3$2_0/a_11480_63#
+ 1bitblock$3$2_0/a_6128_n37# 1bitblock$3$2_0/a_5768_63# 1bitblock$3$2_0/m2_6151_79#
+ 1bitblock$3$2_0/a_11922_391# 1bitblock$3$2_0/a_5042_n37# 1bitblock$3$2_0/a_9408_n37#
+ 1bitblock$3$2_0/a_9609_407# 1bitblock$3$2_0/a_5042_407# 1bitblock$3$2_0/a_8160_n37#
+ m2_10721_n3315# 1bitblock$3$2_0/a_11922_3# m1_8729_n3942# 1bitblock$3$2_0/a_2419_63#
+ 1bitblock$3$2_0/m2_9431_79# 1bitblock$3$2_0/a_10906_466# 1bitblock$3$2_0/a_4650_n37#
+ 1bitblock$3$2_0/a_9050_63# 1bitblock$3$2_0/a_5243_407# 1bitblock$3$2_0/a_7768_n37#
+ 1bitblock$3$2_0/a_3940_63# 1bitblock$3$2_0/m2_7791_79# 1bitblock$3$2_0/a_10363_63#
+ 1bitblock$3$2_0/a_160_63# 1bitblock$3$2_0/a_4290_63# 1bitblock$3$2_0/a_7083_63#
+ 1bitblock$3$2_0/a_705_407# m1_12480_n3815# 1bitblock$3$2_0/a_7410_63# 1bitblock$3$2_0/a_1845_n37#
+ m2_5443_n3913# VSUBS 1bitblock$3$2_0/a_3498_3# m1_13543_n1146# 1bitblock$3$2_0/a_8723_63#
+ 1bitblock$3$2_0/a_378_271# m1_n563_n5091# 1bitblock$3$2_0/m2_24_342# x1bitblock$3$2
X1bitblock$2$2_0 1bitblock$2$2_0/a_2861_3# 1bitblock$2$2_0/a_8361_407# 1bitblock$2$2_0/a_6520_n37#
+ 1bitblock$2$2_0/a_1262_n37# 1bitblock$2$2_0/a_2861_391# 1bitblock$2$2_0/a_1845_466#
+ 1bitblock$2$2_0/a_10906_n37# 1bitblock$2$2_0/a_510_63# 1bitblock$2$2_0/a_870_n37#
+ 1bitblock$2$2_0/a_6721_407# 1bitblock$2$2_0/a_9800_n37# 1bitblock$2$2_0/a_11480_63#
+ 1bitblock$2$2_0/a_6128_n37# 1bitblock$2$2_0/a_5768_63# m1_8729_n3942# 1bitblock$2$2_0/m2_6151_79#
+ 1bitblock$2$2_0/a_11922_391# 1bitblock$2$2_0/a_5042_n37# 1bitblock$2$2_0/a_9408_n37#
+ 1bitblock$2$2_0/a_9609_407# 1bitblock$2$2_0/a_5042_407# 1bitblock$2$2_0/a_8160_n37#
+ m1_12484_n953# 1bitblock$2$2_0/a_11922_3# 1bitblock$2$2_0/a_2419_63# 1bitblock$2$2_0/m2_9431_79#
+ 1bitblock$2$2_0/a_10906_466# 1bitblock$2$2_0/a_4650_n37# 1bitblock$2$2_0/a_9050_63#
+ 1bitblock$2$2_0/a_5243_407# 1bitblock$2$2_0/a_7768_n37# 1bitblock$2$2_0/a_3940_63#
+ 1bitblock$2$2_0/m2_7791_79# 1bitblock$2$2_0/a_10363_63# 1bitblock$2$2_0/a_160_63#
+ 1bitblock$2$2_0/a_4290_63# 1bitblock$2$2_0/a_7083_63# 1bitblock$2$2_0/a_705_407#
+ m2_10721_n3315# 1bitblock$2$2_0/a_7410_63# m2_5443_n3913# 1bitblock$2$2_0/a_1845_n37#
+ VSUBS m2_2396_n2595# 1bitblock$2$2_0/a_8723_63# 1bitblock$2$2_0/a_378_271# 1bitblock$2$2_0/a_3498_3#
+ m1_n563_n5091# 1bitblock$2$2_0/m2_24_342# x1bitblock$2$2
XMUX21$2_0 MUX21$2_0/a_1472_63# MUX21$2_0/a_157_63# m2_14516_n651# MUX21$2_0/a_909_n37#
+ m1_10807_n176# MUX21$2_0/a_517_n37# MUX21$2_0/a_718_407# MUX21$2_0/m2_540_79# VSUBS
+ m1_12480_n3815# m1_n563_n5091# MUX21$2
XAND4$2_0 m1_n563_n5091# m2_2396_n2595# VSUBS m1_13543_n1146# m2_14516_n651# m2_1701_n784#
+ AND4$2_0/a_704_n441# m1_14167_n1145# AND4$2_0/a_912_n441# AND4$2_0/a_518_229# AND4$2_0/a_1120_n441#
+ AND4$2
X1bitblock$5_0 1bitblock$5_0/a_2861_3# 1bitblock$5_0/a_8361_407# 1bitblock$5_0/a_6520_n37#
+ 1bitblock$5_0/a_1262_n37# 1bitblock$5_0/a_2861_391# 1bitblock$5_0/a_1845_466# 1bitblock$5_0/a_10906_n37#
+ 1bitblock$5_0/a_510_63# 1bitblock$5_0/a_870_n37# 1bitblock$5_0/a_6721_407# 1bitblock$5_0/a_9800_n37#
+ 1bitblock$5_0/a_11480_63# 1bitblock$5_0/a_6128_n37# 1bitblock$5_0/a_5768_63# 1bitblock$5_0/m2_6151_79#
+ 1bitblock$5_0/a_11922_391# 1bitblock$5_0/a_5042_n37# 1bitblock$5_0/a_9408_n37# m1_8729_n3942#
+ 1bitblock$5_0/a_9609_407# 1bitblock$5_0/a_5042_407# 1bitblock$5_0/a_8160_n37# m1_10807_n176#
+ 1bitblock$5_0/a_11922_3# 1bitblock$5_0/a_2419_63# 1bitblock$5_0/m2_9431_79# 1bitblock$5_0/a_10906_466#
+ 1bitblock$5_0/a_4650_n37# 1bitblock$5_0/a_3498_3# 1bitblock$5_0/a_9050_63# 1bitblock$5_0/a_5243_407#
+ 1bitblock$5_0/a_7768_n37# 1bitblock$5_0/a_3940_63# 1bitblock$5_0/m2_7791_79# 1bitblock$5_0/a_10363_63#
+ 1bitblock$5_0/a_160_63# 1bitblock$5_0/a_4290_63# 1bitblock$5_0/a_7083_63# 1bitblock$5_0/a_705_407#
+ m1_12486_242# 1bitblock$5_0/a_7410_63# 1bitblock$5_0/a_1845_n37# VSUBS m1_14167_n1145#
+ 1bitblock$5_0/a_8723_63# 1bitblock$5_0/a_378_271# m2_5443_n3913# m1_n563_n5091#
+ 1bitblock$5_0/m2_24_342# x1bitblock$5
X1bitblock$1$2_0 1bitblock$1$2_0/a_2861_3# 1bitblock$1$2_0/a_8361_407# 1bitblock$1$2_0/a_6520_n37#
+ 1bitblock$1$2_0/a_1262_n37# 1bitblock$1$2_0/a_2861_391# 1bitblock$1$2_0/a_1845_466#
+ 1bitblock$1$2_0/a_10906_n37# 1bitblock$1$2_0/a_510_63# 1bitblock$1$2_0/a_870_n37#
+ 1bitblock$1$2_0/a_6721_407# 1bitblock$1$2_0/a_9800_n37# 1bitblock$1$2_0/a_11480_63#
+ 1bitblock$1$2_0/a_6128_n37# 1bitblock$1$2_0/a_5768_63# 1bitblock$1$2_0/m2_6151_79#
+ 1bitblock$1$2_0/a_11922_391# 1bitblock$1$2_0/a_5042_n37# 1bitblock$1$2_0/m2_24_342#
+ 1bitblock$1$2_0/a_9408_n37# 1bitblock$1$2_0/a_9609_407# 1bitblock$1$2_0/a_5042_407#
+ 1bitblock$1$2_0/a_8160_n37# m1_12486_242# 1bitblock$1$2_0/a_11922_3# 1bitblock$1$2_0/a_2419_63#
+ 1bitblock$1$2_0/m2_9431_79# 1bitblock$1$2_0/a_10906_466# 1bitblock$1$2_0/a_4650_n37#
+ 1bitblock$1$2_0/a_9050_63# 1bitblock$1$2_0/a_5243_407# 1bitblock$1$2_0/a_7768_n37#
+ 1bitblock$1$2_0/a_160_63# 1bitblock$1$2_0/a_3940_63# m1_8729_n3942# 1bitblock$1$2_0/m2_7791_79#
+ 1bitblock$1$2_0/a_10363_63# 1bitblock$1$2_0/a_4290_63# 1bitblock$1$2_0/a_7083_63#
+ 1bitblock$1$2_0/a_3498_3# 1bitblock$1$2_0/a_705_407# m1_12484_n953# 1bitblock$1$2_0/a_7410_63#
+ m2_5443_n3913# 1bitblock$1$2_0/a_1845_n37# VSUBS m2_1701_n784# 1bitblock$1$2_0/a_8723_63#
+ 1bitblock$1$2_0/a_378_271# m1_n563_n5091# x1bitblock$1$2
C0 1bitblock$2$2_0/a_378_271# 1bitblock$1$2_0/a_705_407# 0
C1 m1_8729_n3942# m1_13543_n1146# 0.01251f
C2 AND4$2_0/a_518_229# m1_12484_n953# 0.00876f
C3 m1_13543_n1146# MUX21$2_0/a_157_63# 0
C4 m1_12480_n3815# m1_n563_n5091# 0.04173f
C5 1bitblock$3$2_0/a_10363_63# m1_8729_n3942# 0.00105f
C6 m1_13543_n1146# 1bitblock$3$2_0/a_10906_n37# 0.00152f
C7 m2_2396_n2595# 1bitblock$1$2_0/a_10906_466# 0.0111f
C8 m1_8729_n3942# 1bitblock$1$2_0/m2_7791_79# 0.02398f
C9 m1_8729_n3942# 1bitblock$1$2_0/a_9800_n37# 0.0014f
C10 m2_5443_n3913# 1bitblock$3$2_0/a_7083_63# 0.00109f
C11 m1_n563_n5091# 1bitblock$1$2_0/a_705_407# 0.00876f
C12 m1_8729_n3942# 1bitblock$3$2_0/a_9609_407# 0.00145f
C13 1bitblock$2$2_0/a_4290_63# m1_n563_n5091# 0
C14 1bitblock$3$2_0/a_378_271# m1_n563_n5091# 0
C15 1bitblock$5_0/a_7410_63# m1_14167_n1145# 0.00163f
C16 1bitblock$2$2_0/a_2419_63# 1bitblock$2$2_0/a_705_407# -0
C17 m1_13543_n1146# m1_12480_n3815# 0.07257f
C18 m2_5443_n3913# m2_10721_n3315# 0.05254f
C19 MUX21$2_0/m2_540_79# m1_10807_n176# 0.00265f
C20 m1_n563_n5091# 1bitblock$1$2_0/m2_6151_79# 0
C21 m2_5443_n3913# 1bitblock$5_0/a_6520_n37# 0.0015f
C22 m1_8729_n3942# 1bitblock$5_0/a_8160_n37# 0.00164f
C23 AND4$2_0/a_518_229# m2_2396_n2595# 0.05061f
C24 m1_8729_n3942# 1bitblock$1$2_0/a_9609_407# 0.01871f
C25 1bitblock$5_0/a_1262_n37# 1bitblock$1$2_0/a_705_407# 0
C26 m1_n563_n5091# 1bitblock$1$2_0/a_3498_3# 0.03072f
C27 1bitblock$5_0/a_705_407# 1bitblock$1$2_0/a_1262_n37# 0
C28 m1_8729_n3942# m1_12486_242# 0.05039f
C29 1bitblock$3$2_0/a_378_271# m1_13543_n1146# 0.00199f
C30 m2_5443_n3913# 1bitblock$2$2_0/a_4650_n37# 0.00119f
C31 m1_n563_n5091# 1bitblock$1$2_0/a_2419_63# 0.00292f
C32 m1_n563_n5091# 1bitblock$1$2_0/a_160_63# 0.0263f
C33 1bitblock$2$2_0/a_2419_63# 1bitblock$2$2_0/a_3498_3# -0
C34 m1_8729_n3942# 1bitblock$1$2_0/a_10363_63# 0.00192f
C35 m2_2396_n2595# 1bitblock$1$2_0/a_2861_3# 0.01004f
C36 m1_8729_n3942# 1bitblock$1$2_0/a_8361_407# 0.00891f
C37 m2_14516_n651# m1_10807_n176# 0.13342f
C38 m1_n563_n5091# 1bitblock$1$2_0/m2_9431_79# -0
C39 1bitblock$3$2_0/a_2419_63# 1bitblock$2$2_0/a_2419_63# 1.31417f
C40 AND4$2_0/a_912_n441# m2_2396_n2595# 0.0044f
C41 MUX21$2_0/m2_540_79# m1_14167_n1145# 0.01323f
C42 m1_8729_n3942# 1bitblock$1$2_0/a_7083_63# 0.05469f
C43 1bitblock$3$2_0/a_3498_3# 1bitblock$3$2_0/m2_9431_79# -0
C44 m1_13543_n1146# 1bitblock$1$2_0/a_2419_63# 0
C45 m2_2396_n2595# 1bitblock$5_0/a_2419_63# 0
C46 1bitblock$3$2_0/a_510_63# 1bitblock$2$2_0/a_705_407# 0
C47 m1_8729_n3942# m2_1701_n784# 0.03255f
C48 m1_13543_n1146# 1bitblock$2$2_0/a_1262_n37# 0
C49 m1_n563_n5091# 1bitblock$1$2_0/a_5042_407# 0
C50 MUX21$2_0/a_157_63# m2_1701_n784# 0
C51 m2_5443_n3913# m1_8729_n3942# 0.00777f
C52 m1_n563_n5091# 1bitblock$1$2_0/a_11480_63# 0
C53 1bitblock$3$2_0/a_8723_63# 1bitblock$3$2_0/m2_9431_79# -0
C54 m1_8729_n3942# 1bitblock$1$2_0/a_8723_63# 0.09524f
C55 m2_14516_n651# m1_14167_n1145# 0.09216f
C56 1bitblock$1$2_0/m2_7791_79# 1bitblock$1$2_0/m2_9431_79# -0.00474f
C57 m2_2396_n2595# 1bitblock$1$2_0/a_7410_63# 0.00161f
C58 m1_n563_n5091# 1bitblock$1$2_0/a_3940_63# 0
C59 1bitblock$3$2_0/a_510_63# 1bitblock$2$2_0/a_160_63# 0
C60 1bitblock$5_0/a_510_63# m1_14167_n1145# 0.00107f
C61 1bitblock$3$2_0/a_8723_63# 1bitblock$3$2_0/m2_7791_79# 0
C62 1bitblock$1$2_0/a_2419_63# m1_12486_242# -0.00165f
C63 1bitblock$3$2_0/m2_24_342# m2_2396_n2595# 0.00389f
C64 1bitblock$2$2_0/a_705_407# 1bitblock$1$2_0/a_378_271# 0
C65 1bitblock$3$2_0/a_3498_3# m2_2396_n2595# 0
C66 1bitblock$2$2_0/a_4290_63# m2_5443_n3913# 0.00738f
C67 m2_5443_n3913# 1bitblock$2$2_0/a_5042_n37# 0
C68 m2_1701_n784# 1bitblock$1$2_0/m2_6151_79# 0
C69 1bitblock$1$2_0/a_10906_n37# m1_12486_242# 0.00484f
C70 1bitblock$3$2_0/a_9050_63# 1bitblock$3$2_0/m2_9431_79# -0
C71 1bitblock$5_0/m2_24_342# m1_14167_n1145# 0.0031f
C72 m2_5443_n3913# 1bitblock$1$2_0/m2_6151_79# 0.01607f
C73 1bitblock$3$2_0/a_160_63# 1bitblock$2$2_0/a_510_63# 0
C74 1bitblock$3$2_0/a_705_407# 1bitblock$2$2_0/a_160_63# 0
C75 1bitblock$1$2_0/a_3498_3# m2_1701_n784# -0.0052f
C76 1bitblock$3$2_0/a_2419_63# 1bitblock$3$2_0/a_705_407# -0
C77 m2_5443_n3913# 1bitblock$1$2_0/a_3498_3# 0.05026f
C78 1bitblock$1$2_0/a_2419_63# m2_1701_n784# 0.4677f
C79 1bitblock$1$2_0/a_160_63# m2_1701_n784# 0
C80 1bitblock$5_0/a_1845_n37# m2_1701_n784# 0.00311f
C81 m1_14167_n1145# 1bitblock$1$2_0/a_1845_n37# 0
C82 1bitblock$1$2_0/a_11480_63# m1_12486_242# 0.01269f
C83 1bitblock$2$2_0/a_510_63# 1bitblock$1$2_0/a_510_63# 0.00154f
C84 m2_5443_n3913# 1bitblock$1$2_0/a_2419_63# 0.00541f
C85 1bitblock$3$2_0/a_9050_63# 1bitblock$3$2_0/m2_7791_79# -0
C86 1bitblock$3$2_0/a_11922_3# 1bitblock$2$2_0/a_2419_63# 0
C87 m2_5443_n3913# 1bitblock$1$2_0/a_6721_407# 0.01358f
C88 m1_n563_n5091# 1bitblock$5_0/m2_7791_79# -0
C89 m2_1701_n784# 1bitblock$1$2_0/m2_9431_79# 0
C90 1bitblock$2$2_0/a_510_63# 1bitblock$1$2_0/m2_24_342# 0
C91 m1_8729_n3942# 1bitblock$5_0/a_3498_3# 0.00142f
C92 1bitblock$3$2_0/a_160_63# m2_2396_n2595# 0.00103f
C93 1bitblock$3$2_0/a_3940_63# m2_2396_n2595# 0
C94 m1_8729_n3942# 1bitblock$5_0/a_2419_63# 0.00658f
C95 1bitblock$1$2_0/m2_9431_79# 1bitblock$1$2_0/a_8723_63# -0
C96 m2_1701_n784# 1bitblock$1$2_0/a_5042_407# 0.02321f
C97 m2_5443_n3913# 1bitblock$1$2_0/a_5042_407# 0.06275f
C98 MUX21$2_0/a_718_407# m2_2396_n2595# 0.00276f
C99 m1_8729_n3942# 1bitblock$5_0/m2_9431_79# 0.02012f
C100 m1_n563_n5091# m1_10807_n176# 0.00564f
C101 1bitblock$2$2_0/a_10906_466# m1_12484_n953# 0.0176f
C102 m1_8729_n3942# 1bitblock$1$2_0/a_7410_63# 0.00637f
C103 m2_2396_n2595# 1bitblock$1$2_0/m2_24_342# 0
C104 m2_1701_n784# 1bitblock$1$2_0/a_3940_63# 0.00175f
C105 m2_14516_n651# AND4$2_0/a_1120_n441# 0.00515f
C106 AND4$2_0/a_518_229# 1bitblock$1$2_0/a_2419_63# 0.00114f
C107 1bitblock$2$2_0/a_2419_63# m1_n563_n5091# 0.00232f
C108 m2_5443_n3913# 1bitblock$1$2_0/a_3940_63# 0.00421f
C109 1bitblock$3$2_0/a_2861_391# 1bitblock$3$2_0/a_705_407# -0
C110 m1_n563_n5091# 1bitblock$5_0/a_11922_3# 0
C111 1bitblock$5_0/a_705_407# 1bitblock$1$2_0/a_160_63# 0
C112 1bitblock$5_0/a_160_63# 1bitblock$1$2_0/a_705_407# 0
C113 m1_13543_n1146# m1_10807_n176# 0
C114 1bitblock$3$2_0/a_3498_3# m1_8729_n3942# 0.0014f
C115 1bitblock$3$2_0/a_705_407# 1bitblock$2$2_0/m2_24_342# 0
C116 1bitblock$2$2_0/a_9609_407# 1bitblock$2$2_0/m2_7791_79# -0
C117 m1_n563_n5091# 1bitblock$5_0/a_1845_466# 0
C118 m1_n563_n5091# m1_14167_n1145# 0.68959f
C119 1bitblock$3$2_0/a_1262_n37# m2_2396_n2595# 0
C120 1bitblock$2$2_0/a_10906_466# m2_2396_n2595# 0.01059f
C121 1bitblock$2$2_0/m2_24_342# 1bitblock$1$2_0/a_378_271# 0
C122 1bitblock$2$2_0/a_2419_63# m1_13543_n1146# 0.00534f
C123 1bitblock$3$2_0/a_2861_3# m1_13543_n1146# 0.01984f
C124 m1_8729_n3942# 1bitblock$3$2_0/a_8723_63# 0.08003f
C125 m1_n563_n5091# 1bitblock$5_0/a_8723_63# -0.0053f
C126 1bitblock$3$2_0/m2_7791_79# 1bitblock$3$2_0/m2_9431_79# -0.00447f
C127 1bitblock$5_0/a_2419_63# 1bitblock$1$2_0/a_2419_63# 1.63229f
C128 1bitblock$5_0/a_160_63# 1bitblock$1$2_0/a_160_63# 0.04611f
C129 MUX21$2_0/m2_540_79# m2_14516_n651# 0.00787f
C130 1bitblock$5_0/a_5768_63# m2_1701_n784# 0
C131 m1_10807_n176# m1_12486_242# 1.92011f
C132 1bitblock$5_0/m2_7791_79# m2_1701_n784# 0
C133 m2_2396_n2595# 1bitblock$2$2_0/m2_7791_79# 0.01632f
C134 m2_5443_n3913# 1bitblock$5_0/a_5768_63# 0.01316f
C135 1bitblock$3$2_0/a_705_407# 1bitblock$2$2_0/a_378_271# 0
C136 m1_8729_n3942# 1bitblock$3$2_0/a_8160_n37# 0.00163f
C137 m2_10721_n3315# 1bitblock$2$2_0/a_10906_466# 0
C138 m1_10807_n176# 1bitblock$1$2_0/a_11922_3# 0
C139 1bitblock$5_0/a_11922_3# m1_12486_242# 0.01844f
C140 1bitblock$2$2_0/a_378_271# 1bitblock$1$2_0/a_378_271# 0.00593f
C141 1bitblock$2$2_0/a_11922_3# m1_12484_n953# 0.03274f
C142 1bitblock$3$2_0/a_510_63# m1_13543_n1146# 0.00107f
C143 m1_8729_n3942# 1bitblock$2$2_0/a_9408_n37# 0
C144 m2_2396_n2595# 1bitblock$2$2_0/a_9609_407# 0.09632f
C145 1bitblock$3$2_0/a_9050_63# m1_8729_n3942# 0.01697f
C146 1bitblock$2$2_0/a_5768_63# m1_n563_n5091# 0
C147 1bitblock$1$2_0/a_4290_63# 1bitblock$1$2_0/a_5042_407# 0
C148 1bitblock$3$2_0/a_705_407# m1_n563_n5091# -0
C149 m1_n563_n5091# 1bitblock$2$2_0/a_9050_63# 0
C150 1bitblock$3$2_0/a_11480_63# m1_13543_n1146# 0.0097f
C151 m1_10807_n176# m2_1701_n784# 2.16295f
C152 m1_14167_n1145# m1_12486_242# 0.08947f
C153 1bitblock$2$2_0/a_510_63# m2_2396_n2595# 0.00105f
C154 m2_2396_n2595# m1_12484_n953# 0.16107f
C155 m2_5443_n3913# m1_10807_n176# 0.05217f
C156 1bitblock$3$2_0/a_11922_391# m2_10721_n3315# 0.00397f
C157 1bitblock$5_0/a_11922_3# 1bitblock$1$2_0/a_11922_3# 0.00177f
C158 1bitblock$5_0/a_2419_63# 1bitblock$1$2_0/a_3940_63# 0
C159 m1_n563_n5091# 1bitblock$1$2_0/a_378_271# 0.00489f
C160 1bitblock$5_0/a_3940_63# 1bitblock$1$2_0/a_2419_63# 0
C161 1bitblock$5_0/a_11922_391# m1_12486_242# 0.00287f
C162 m1_n563_n5091# 1bitblock$1$2_0/a_9050_63# 0
C163 1bitblock$3$2_0/a_2419_63# 1bitblock$2$2_0/a_3940_63# 0
C164 1bitblock$2$2_0/a_2419_63# m2_1701_n784# 0
C165 m2_2396_n2595# 1bitblock$2$2_0/a_8361_407# 0.03425f
C166 1bitblock$5_0/a_11922_3# m2_1701_n784# 0
C167 1bitblock$2$2_0/a_11922_3# m2_2396_n2595# 0.01144f
C168 m2_5443_n3913# 1bitblock$2$2_0/a_2419_63# 0.00972f
C169 MUX21$2_0/a_718_407# m1_12480_n3815# 0.00296f
C170 1bitblock$3$2_0/a_705_407# m1_13543_n1146# 0.00558f
C171 1bitblock$5_0/a_7083_63# m2_1701_n784# 0.02635f
C172 1bitblock$3$2_0/a_4290_63# m2_5443_n3913# 0.00473f
C173 m2_2396_n2595# 1bitblock$2$2_0/a_7083_63# 0.00471f
C174 m1_8729_n3942# 1bitblock$5_0/a_9609_407# 0.00143f
C175 m2_5443_n3913# 1bitblock$5_0/a_7083_63# 0.00107f
C176 1bitblock$2$2_0/m2_24_342# 1bitblock$2$2_0/a_3498_3# -0
C177 1bitblock$5_0/a_1845_466# 1bitblock$1$2_0/a_1845_466# 0.00192f
C178 1bitblock$5_0/a_1845_466# m2_1701_n784# 0.00247f
C179 m1_14167_n1145# 1bitblock$1$2_0/a_1845_466# 0.00183f
C180 m1_14167_n1145# m2_1701_n784# 0.36644f
C181 1bitblock$5_0/a_10906_466# m1_12486_242# 0.00953f
C182 m2_5443_n3913# m1_14167_n1145# 0.00325f
C183 1bitblock$5_0/a_8723_63# m2_1701_n784# 0
C184 1bitblock$1$2_0/a_9050_63# 1bitblock$1$2_0/m2_7791_79# -0
C185 m2_2396_n2595# 1bitblock$2$2_0/a_8723_63# 0.02885f
C186 m2_10721_n3315# m1_12484_n953# 2.41735f
C187 1bitblock$2$2_0/a_378_271# 1bitblock$2$2_0/a_705_407# -0
C188 1bitblock$2$2_0/a_2861_391# m2_2396_n2595# 0.01578f
C189 AND4$2_0/a_518_229# m1_10807_n176# 0
C190 1bitblock$5_0/a_3940_63# 1bitblock$1$2_0/a_3940_63# 0.01129f
C191 1bitblock$2$2_0/a_2861_3# 1bitblock$2$2_0/a_705_407# -0
C192 AND4$2_0/a_1120_n441# m1_13543_n1146# 0.0044f
C193 m2_10721_n3315# 1bitblock$2$2_0/a_11922_3# 0.00359f
C194 m1_8729_n3942# 1bitblock$2$2_0/m2_7791_79# 0.02388f
C195 m1_8729_n3942# 1bitblock$2$2_0/a_9800_n37# 0.0014f
C196 m1_n563_n5091# 1bitblock$2$2_0/a_705_407# 0.00817f
C197 m1_8729_n3942# 1bitblock$3$2_0/m2_9431_79# 0.02041f
C198 1bitblock$5_0/m2_7791_79# 1bitblock$5_0/m2_9431_79# -0.00444f
C199 m2_10721_n3315# m2_2396_n2595# 0.01652f
C200 m2_5443_n3913# 1bitblock$1$2_0/a_6128_n37# 0
C201 m1_8729_n3942# 1bitblock$1$2_0/a_7768_n37# 0
C202 1bitblock$3$2_0/a_7410_63# m1_13543_n1146# 0.0016f
C203 AND4$2_0/a_518_229# m1_14167_n1145# 0.01521f
C204 1bitblock$2$2_0/a_2861_3# 1bitblock$2$2_0/a_3498_3# -0
C205 m1_8729_n3942# 1bitblock$2$2_0/a_9609_407# 0.01866f
C206 MUX21$2_0/m2_540_79# m1_n563_n5091# -0.00173f
C207 m1_n563_n5091# 1bitblock$2$2_0/a_3498_3# 0.02184f
C208 1bitblock$5_0/a_2419_63# m1_10807_n176# 0.07066f
C209 m1_13543_n1146# 1bitblock$3$2_0/a_10906_466# 0.01097f
C210 m1_13543_n1146# 1bitblock$2$2_0/a_705_407# 0
C211 m1_8729_n3942# m1_12484_n953# 0.05077f
C212 1bitblock$5_0/a_705_407# m1_14167_n1145# 0.00558f
C213 m2_5443_n3913# 1bitblock$2$2_0/a_5768_63# 0.01877f
C214 m1_8729_n3942# 1bitblock$3$2_0/m2_7791_79# 0.01998f
C215 1bitblock$3$2_0/a_2419_63# 1bitblock$2$2_0/a_2861_3# 0
C216 m2_5443_n3913# 1bitblock$5_0/a_4650_n37# 0.00119f
C217 m1_n563_n5091# 1bitblock$2$2_0/a_160_63# 0.02629f
C218 1bitblock$3$2_0/a_2419_63# m1_n563_n5091# 0
C219 1bitblock$1$2_0/a_378_271# m2_1701_n784# 0.00848f
C220 1bitblock$5_0/a_2861_3# m2_1701_n784# 0.00149f
C221 m1_14167_n1145# 1bitblock$1$2_0/a_2861_3# 0.00149f
C222 1bitblock$1$2_0/a_9050_63# m2_1701_n784# 0
C223 1bitblock$2$2_0/a_7410_63# m2_2396_n2595# 0.00156f
C224 1bitblock$5_0/a_10906_n37# m1_10807_n176# 0.00266f
C225 m1_8729_n3942# 1bitblock$2$2_0/a_8361_407# 0.00891f
C226 m1_n563_n5091# 1bitblock$2$2_0/m2_9431_79# -0
C227 m1_n563_n5091# 1bitblock$2$2_0/a_11480_63# 0
C228 m2_14516_n651# m1_n563_n5091# 0.16195f
C229 1bitblock$5_0/a_1845_466# 1bitblock$5_0/a_3498_3# -0
C230 m1_13543_n1146# 1bitblock$2$2_0/a_3498_3# 0
C231 1bitblock$3$2_0/a_1845_466# 1bitblock$2$2_0/m2_24_342# 0
C232 m1_8729_n3942# 1bitblock$2$2_0/a_7083_63# 0.0547f
C233 1bitblock$5_0/a_3498_3# m1_14167_n1145# 1.79259f
C234 m1_12480_n3815# m1_12484_n953# 0
C235 m1_13543_n1146# 1bitblock$2$2_0/a_160_63# 0.00107f
C236 1bitblock$5_0/a_160_63# m1_14167_n1145# 0
C237 1bitblock$5_0/a_2419_63# m1_14167_n1145# 0.07947f
C238 1bitblock$5_0/a_11480_63# m1_10807_n176# 0
C239 m1_8729_n3942# m2_2396_n2595# 0.09192f
C240 1bitblock$3$2_0/a_2419_63# m1_13543_n1146# 0.07504f
C241 MUX21$2_0/a_157_63# m2_2396_n2595# 0
C242 m1_n563_n5091# 1bitblock$2$2_0/a_5042_407# 0
C243 m1_8729_n3942# 1bitblock$5_0/a_9050_63# 0.01686f
C244 1bitblock$5_0/a_4290_63# m2_1701_n784# 0
C245 AND4$2_0/a_1120_n441# m2_1701_n784# 0.00916f
C246 1bitblock$2$2_0/a_510_63# 1bitblock$1$2_0/a_705_407# 0
C247 m1_14167_n1145# 1bitblock$5_0/m2_9431_79# 0.02029f
C248 m2_5443_n3913# 1bitblock$5_0/a_4290_63# 0.00478f
C249 1bitblock$5_0/a_10906_n37# m1_14167_n1145# 0.00154f
C250 m1_8729_n3942# 1bitblock$2$2_0/a_8723_63# 0.09622f
C251 m2_14516_n651# m1_13543_n1146# 0.00988f
C252 1bitblock$3$2_0/a_870_n37# 1bitblock$2$2_0/a_160_63# 0.00135f
C253 1bitblock$5_0/a_7410_63# m2_1701_n784# 0
C254 m1_n563_n5091# 1bitblock$2$2_0/a_3940_63# 0
C255 1bitblock$5_0/m2_9431_79# 1bitblock$5_0/a_8723_63# -0
C256 m2_5443_n3913# 1bitblock$1$2_0/a_6520_n37# 0.00151f
C257 m1_8729_n3942# 1bitblock$1$2_0/a_8160_n37# 0.00164f
C258 1bitblock$3$2_0/a_2861_3# 1bitblock$3$2_0/a_3498_3# -0
C259 1bitblock$5_0/a_11480_63# m1_14167_n1145# 0.00995f
C260 1bitblock$3$2_0/a_7083_63# m1_8729_n3942# 0.0537f
C261 m1_n563_n5091# 1bitblock$5_0/m2_24_342# 0.01777f
C262 m1_12484_n953# 1bitblock$1$2_0/a_2419_63# 0.00245f
C263 1bitblock$2$2_0/a_705_407# m2_1701_n784# 0.00123f
C264 m2_2396_n2595# 1bitblock$1$2_0/a_705_407# 0.00123f
C265 1bitblock$5_0/a_378_271# 1bitblock$1$2_0/a_705_407# 0
C266 1bitblock$5_0/a_705_407# 1bitblock$1$2_0/a_378_271# 0
C267 1bitblock$5_0/a_2861_3# 1bitblock$5_0/a_705_407# -0
C268 1bitblock$3$2_0/a_378_271# m2_2396_n2595# 0.00248f
C269 m1_8729_n3942# m2_10721_n3315# 0.05078f
C270 m2_5443_n3913# 1bitblock$5_0/a_5042_n37# 0
C271 1bitblock$2$2_0/a_1845_466# 1bitblock$2$2_0/a_3498_3# -0
C272 m1_13543_n1146# 1bitblock$2$2_0/a_3940_63# 0
C273 m2_10721_n3315# 1bitblock$3$2_0/a_10906_n37# 0.00484f
C274 1bitblock$2$2_0/m2_24_342# m1_n563_n5091# 0.03105f
C275 m1_14167_n1145# 1bitblock$5_0/a_3940_63# 0
C276 1bitblock$3$2_0/a_1845_466# m1_n563_n5091# 0
C277 m2_14516_n651# m1_12486_242# 0.00988f
C278 m2_5443_n3913# 1bitblock$2$2_0/m2_6151_79# 0.01608f
C279 1bitblock$2$2_0/a_3498_3# m2_1701_n784# 0.0012f
C280 m2_2396_n2595# 1bitblock$1$2_0/a_3498_3# 1.69486f
C281 1bitblock$3$2_0/a_2861_391# m1_13543_n1146# 0.01584f
C282 1bitblock$5_0/a_2861_3# 1bitblock$5_0/a_3498_3# -0
C283 m2_5443_n3913# 1bitblock$2$2_0/a_3498_3# 0.05092f
C284 1bitblock$3$2_0/a_11922_3# m1_n563_n5091# 0
C285 m2_2396_n2595# 1bitblock$1$2_0/a_2419_63# 0.01135f
C286 1bitblock$5_0/a_378_271# 1bitblock$1$2_0/a_160_63# 0.00372f
C287 m1_12484_n953# 1bitblock$1$2_0/a_11480_63# 0.00279f
C288 1bitblock$5_0/a_160_63# 1bitblock$1$2_0/a_378_271# 0.00373f
C289 m2_10721_n3315# m1_12480_n3815# 0.02463f
C290 1bitblock$5_0/a_2861_391# m1_14167_n1145# 0.01608f
C291 MUX21$2_0/a_718_407# m1_10807_n176# 0
C292 m2_14516_n651# 1bitblock$1$2_0/a_11922_3# 0.00533f
C293 1bitblock$2$2_0/a_2419_63# 1bitblock$3$2_0/a_3940_63# 0
C294 1bitblock$3$2_0/a_1845_n37# m2_2396_n2595# 0.00179f
C295 m1_8729_n3942# 1bitblock$2$2_0/a_7410_63# 0.00637f
C296 1bitblock$2$2_0/m2_24_342# m1_13543_n1146# 0.00392f
C297 1bitblock$3$2_0/a_2419_63# m2_5443_n3913# 0.00867f
C298 1bitblock$5_0/a_9609_407# 1bitblock$5_0/m2_7791_79# -0
C299 1bitblock$3$2_0/a_1845_466# m1_13543_n1146# 0.01449f
C300 m2_5443_n3913# 1bitblock$2$2_0/a_6721_407# 0.01358f
C301 m2_2396_n2595# 1bitblock$1$2_0/m2_9431_79# 0.0203f
C302 m2_2396_n2595# 1bitblock$1$2_0/a_10906_n37# 0.00153f
C303 m2_14516_n651# m2_1701_n784# 0.85907f
C304 1bitblock$3$2_0/a_11922_3# m1_13543_n1146# 0.01495f
C305 1bitblock$2$2_0/a_378_271# m1_n563_n5091# 0.00489f
C306 1bitblock$5_0/a_510_63# m2_1701_n784# 0
C307 m1_14167_n1145# 1bitblock$1$2_0/a_510_63# 0
C308 m2_2396_n2595# 1bitblock$1$2_0/a_11480_63# 0.00982f
C309 m2_5443_n3913# 1bitblock$2$2_0/a_5042_407# 0.06277f
C310 m1_8729_n3942# 1bitblock$3$2_0/a_9800_n37# 0.0014f
C311 MUX21$2_0/a_718_407# m1_14167_n1145# 0
C312 1bitblock$2$2_0/a_2861_3# m1_n563_n5091# 0.00101f
C313 1bitblock$3$2_0/a_160_63# 1bitblock$2$2_0/a_870_n37# 0.00135f
C314 m1_14167_n1145# 1bitblock$1$2_0/m2_24_342# 0.00373f
C315 m1_13543_n1146# 1bitblock$3$2_0/a_8361_407# 0.03557f
C316 m2_14516_n651# 1bitblock$1$2_0/a_10906_466# 0
C317 1bitblock$2$2_0/a_378_271# m1_13543_n1146# 0.0025f
C318 m2_5443_n3913# 1bitblock$2$2_0/a_3940_63# 0.00421f
C319 1bitblock$5_0/m2_24_342# 1bitblock$1$2_0/a_1845_466# 0
C320 1bitblock$5_0/m2_24_342# m2_1701_n784# 0.01532f
C321 1bitblock$5_0/a_7410_63# 1bitblock$5_0/m2_9431_79# -0
C322 1bitblock$2$2_0/a_2861_3# m1_13543_n1146# 0.00145f
C323 1bitblock$5_0/a_9609_407# m1_14167_n1145# 0.10113f
C324 1bitblock$2$2_0/a_1845_466# 1bitblock$3$2_0/a_1845_466# 0.00184f
C325 m1_13543_n1146# m1_n563_n5091# 0.69902f
C326 1bitblock$1$2_0/a_1845_n37# m2_1701_n784# 0.00561f
C327 AND4$2_0/a_518_229# m2_14516_n651# 0.01804f
C328 m2_2396_n2595# 1bitblock$1$2_0/a_2861_391# 0.00705f
C329 1bitblock$2$2_0/m2_24_342# m2_1701_n784# 0
C330 m1_n563_n5091# 1bitblock$1$2_0/a_5768_63# 0
C331 m1_n563_n5091# 1bitblock$1$2_0/m2_7791_79# -0
C332 1bitblock$3$2_0/a_160_63# 1bitblock$3$2_0/a_705_407# 0
C333 m1_8729_n3942# 1bitblock$1$2_0/a_3498_3# 0.00389f
C334 m1_8729_n3942# 1bitblock$1$2_0/a_2419_63# 0.00237f
C335 1bitblock$3$2_0/a_10363_63# m1_13543_n1146# 0.00478f
C336 AND4$2_0/a_912_n441# m2_14516_n651# 0.00402f
C337 1bitblock$3$2_0/m2_24_342# 1bitblock$2$2_0/a_705_407# 0
C338 m1_8729_n3942# 1bitblock$1$2_0/m2_9431_79# 0.02467f
C339 m1_n563_n5091# m1_12486_242# 0.13471f
C340 1bitblock$3$2_0/a_9609_407# m1_13543_n1146# 0.10003f
C341 1bitblock$5_0/a_9050_63# 1bitblock$5_0/m2_7791_79# -0
C342 1bitblock$2$2_0/a_1845_n37# m1_13543_n1146# 0.00179f
C343 1bitblock$2$2_0/a_2419_63# m1_12484_n953# 0.03322f
C344 1bitblock$2$2_0/a_378_271# m2_1701_n784# 0
C345 m1_8729_n3942# 1bitblock$5_0/a_9408_n37# 0
C346 1bitblock$2$2_0/a_1845_466# m1_n563_n5091# 0.00109f
C347 m1_n563_n5091# 1bitblock$1$2_0/a_11922_3# 0.00267f
C348 m1_n563_n5091# 1bitblock$1$2_0/a_7083_63# 0
C349 1bitblock$3$2_0/m2_24_342# 1bitblock$2$2_0/a_160_63# 0.00419f
C350 m2_2396_n2595# m1_10807_n176# 0
C351 1bitblock$1$2_0/a_9609_407# 1bitblock$1$2_0/m2_7791_79# -0
C352 m1_n563_n5091# 1bitblock$1$2_0/a_1845_466# 0.00107f
C353 m2_14516_n651# MUX21$2_0/a_909_n37# 0
C354 1bitblock$3$2_0/a_2419_63# 1bitblock$3$2_0/a_3498_3# -0
C355 m1_n563_n5091# m2_1701_n784# 0.08054f
C356 1bitblock$5_0/m2_24_342# 1bitblock$5_0/a_3498_3# -0
C357 m2_5443_n3913# m1_n563_n5091# 0.18639f
C358 1bitblock$5_0/m2_24_342# 1bitblock$5_0/a_160_63# -0
C359 1bitblock$2$2_0/a_2419_63# m2_2396_n2595# 0.07185f
C360 1bitblock$2$2_0/a_1845_466# m1_13543_n1146# 0.00178f
C361 m1_13543_n1146# 1bitblock$1$2_0/a_11922_3# 0
C362 1bitblock$3$2_0/a_160_63# 1bitblock$2$2_0/a_705_407# 0
C363 1bitblock$3$2_0/a_2861_3# m2_2396_n2595# 0.00145f
C364 m1_n563_n5091# 1bitblock$1$2_0/a_8723_63# -0.00527f
C365 m1_14167_n1145# 1bitblock$1$2_0/a_1262_n37# 0
C366 1bitblock$5_0/a_1262_n37# m2_1701_n784# 0
C367 1bitblock$2$2_0/a_705_407# 1bitblock$1$2_0/a_510_63# 0
C368 m1_13543_n1146# m2_1701_n784# 0.0051f
C369 1bitblock$2$2_0/a_11922_391# m1_12484_n953# 0.00755f
C370 m2_2396_n2595# m1_14167_n1145# 0.00193f
C371 1bitblock$5_0/a_378_271# m1_14167_n1145# 0.00199f
C372 m2_5443_n3913# m1_13543_n1146# 0.00329f
C373 1bitblock$2$2_0/a_9050_63# 1bitblock$2$2_0/m2_7791_79# -0
C374 1bitblock$5_0/a_9050_63# m1_14167_n1145# 0.0052f
C375 m1_n563_n5091# 1bitblock$1$2_0/a_10906_466# 0.00111f
C376 1bitblock$1$2_0/a_5768_63# m2_1701_n784# 0
C377 m2_1701_n784# 1bitblock$1$2_0/m2_7791_79# 0
C378 m2_5443_n3913# 1bitblock$1$2_0/a_5768_63# 0.01876f
C379 AND4$2_0/a_704_n441# m1_14167_n1145# 0.01112f
C380 1bitblock$2$2_0/a_705_407# 1bitblock$1$2_0/m2_24_342# 0
C381 1bitblock$3$2_0/a_160_63# 1bitblock$2$2_0/a_160_63# 0.0454f
C382 1bitblock$3$2_0/a_2419_63# 1bitblock$3$2_0/a_3940_63# -0
C383 m2_5443_n3913# 1bitblock$1$2_0/a_5243_407# 0.01246f
C384 1bitblock$1$2_0/a_11922_3# m1_12486_242# 0.01722f
C385 AND4$2_0/a_518_229# m1_n563_n5091# 0.0239f
C386 1bitblock$2$2_0/a_2419_63# m2_10721_n3315# 0.04476f
C387 1bitblock$3$2_0/a_510_63# m2_2396_n2595# 0
C388 m2_1701_n784# 1bitblock$1$2_0/a_9609_407# -0
C389 1bitblock$2$2_0/a_11922_391# m2_2396_n2595# 0.00681f
C390 1bitblock$3$2_0/a_705_407# 1bitblock$2$2_0/a_510_63# 0
C391 m1_8729_n3942# 1bitblock$5_0/m2_7791_79# 0.01993f
C392 m1_8729_n3942# 1bitblock$5_0/a_9800_n37# 0.00139f
C393 1bitblock$3$2_0/a_2861_391# 1bitblock$3$2_0/a_3498_3# -0
C394 m1_n563_n5091# 1bitblock$5_0/a_705_407# -0
C395 m2_1701_n784# m1_12486_242# 0.92821f
C396 1bitblock$3$2_0/a_1262_n37# 1bitblock$2$2_0/a_705_407# 0
C397 1bitblock$2$2_0/a_510_63# 1bitblock$1$2_0/a_378_271# 0
C398 1bitblock$2$2_0/a_2861_3# 1bitblock$1$2_0/a_2861_3# 0
C399 1bitblock$3$2_0/m2_24_342# 1bitblock$2$2_0/m2_24_342# 0.14833f
C400 1bitblock$2$2_0/a_160_63# 1bitblock$1$2_0/m2_24_342# 0
C401 m2_5443_n3913# m1_12486_242# 0.0535f
C402 1bitblock$1$2_0/a_2419_63# 1bitblock$1$2_0/a_3940_63# -0
C403 m2_5443_n3913# 1bitblock$2$2_0/a_6128_n37# 0
C404 m1_n563_n5091# 1bitblock$1$2_0/a_2861_3# 0.00101f
C405 1bitblock$1$2_0/a_11922_391# m1_12486_242# 0.00397f
C406 m2_5443_n3913# 1bitblock$3$2_0/a_6520_n37# 0.00151f
C407 m1_8729_n3942# 1bitblock$2$2_0/a_7768_n37# 0
C408 AND4$2_0/a_518_229# m1_13543_n1146# 0.05606f
C409 1bitblock$3$2_0/a_3498_3# 1bitblock$3$2_0/a_1845_466# -0
C410 m2_1701_n784# 1bitblock$1$2_0/a_8361_407# -0
C411 1bitblock$2$2_0/a_1845_466# m2_1701_n784# 0.0015f
C412 1bitblock$2$2_0/a_1845_466# 1bitblock$1$2_0/a_1845_466# 0.00145f
C413 1bitblock$1$2_0/a_11922_3# m2_1701_n784# 0
C414 1bitblock$5_0/a_1262_n37# 1bitblock$5_0/a_705_407# 0
C415 m1_n563_n5091# 1bitblock$5_0/a_3498_3# -0.00886f
C416 m2_1701_n784# 1bitblock$1$2_0/a_7083_63# 0.03418f
C417 1bitblock$3$2_0/a_705_407# m2_2396_n2595# 0
C418 m1_8729_n3942# m1_10807_n176# 0.0504f
C419 1bitblock$2$2_0/a_9050_63# m2_2396_n2595# 0.00483f
C420 MUX21$2_0/a_157_63# m1_10807_n176# 0.00177f
C421 m2_5443_n3913# 1bitblock$1$2_0/a_7083_63# 0.00187f
C422 m1_n563_n5091# 1bitblock$5_0/a_160_63# 0.02528f
C423 m1_n563_n5091# 1bitblock$5_0/a_2419_63# 0
C424 1bitblock$1$2_0/a_1845_466# m2_1701_n784# 0.01233f
C425 1bitblock$3$2_0/a_7410_63# 1bitblock$3$2_0/m2_9431_79# -0
C426 1bitblock$3$2_0/a_3940_63# 1bitblock$2$2_0/a_3940_63# 0.01104f
C427 1bitblock$1$2_0/a_10906_466# m1_12486_242# 0.0161f
C428 m2_2396_n2595# 1bitblock$1$2_0/a_378_271# 0
C429 m2_5443_n3913# m2_1701_n784# 0.03676f
C430 m1_8729_n3942# 1bitblock$5_0/a_10363_63# 0.00105f
C431 m2_2396_n2595# 1bitblock$1$2_0/a_9050_63# 0.00507f
C432 m1_n563_n5091# 1bitblock$1$2_0/a_4290_63# 0
C433 1bitblock$2$2_0/a_2419_63# m1_8729_n3942# 0.00665f
C434 m1_8729_n3942# 1bitblock$5_0/a_8361_407# 0
C435 m1_n563_n5091# 1bitblock$5_0/m2_9431_79# -0.00109f
C436 m2_1701_n784# 1bitblock$1$2_0/a_8723_63# -0
C437 m1_8729_n3942# 1bitblock$5_0/a_7083_63# 0.05365f
C438 1bitblock$3$2_0/a_11480_63# m2_10721_n3315# 0.01269f
C439 MUX21$2_0/a_517_n37# m1_14167_n1145# 0
C440 m1_12480_n3815# m1_10807_n176# 0.00167f
C441 m1_n563_n5091# 1bitblock$1$2_0/a_7410_63# 0
C442 1bitblock$3$2_0/a_160_63# 1bitblock$2$2_0/m2_24_342# 0.00437f
C443 m1_8729_n3942# m1_14167_n1145# 0.01252f
C444 MUX21$2_0/a_157_63# m1_14167_n1145# 0.0056f
C445 1bitblock$5_0/m2_24_342# 1bitblock$1$2_0/m2_24_342# 0.16333f
C446 1bitblock$1$2_0/a_10906_466# m2_1701_n784# 0
C447 AND4$2_0/a_1120_n441# m2_2396_n2595# 0
C448 1bitblock$2$2_0/m2_24_342# 1bitblock$1$2_0/a_510_63# 0
C449 1bitblock$3$2_0/m2_24_342# m1_n563_n5091# 0.01803f
C450 m1_8729_n3942# 1bitblock$5_0/a_8723_63# 0.07922f
C451 AND4$2_0/a_518_229# 1bitblock$1$2_0/a_11922_3# 0.0046f
C452 1bitblock$3$2_0/a_3498_3# m1_n563_n5091# -0.0086f
C453 1bitblock$2$2_0/m2_7791_79# 1bitblock$2$2_0/m2_9431_79# -0.00474f
C454 1bitblock$2$2_0/m2_24_342# 1bitblock$1$2_0/m2_24_342# 0.0286f
C455 m1_12480_n3815# m1_14167_n1145# 0
C456 m2_5443_n3913# 1bitblock$2$2_0/a_6520_n37# 0.00151f
C457 AND4$2_0/a_518_229# m2_1701_n784# 0.02153f
C458 m1_8729_n3942# 1bitblock$2$2_0/a_8160_n37# 0.00164f
C459 1bitblock$3$2_0/a_8723_63# m1_n563_n5091# -0.00531f
C460 m1_10807_n176# 1bitblock$1$2_0/a_2419_63# 0.01284f
C461 1bitblock$5_0/a_2419_63# m1_12486_242# 0.05407f
C462 1bitblock$3$2_0/m2_24_342# m1_13543_n1146# 0.0031f
C463 m1_14167_n1145# 1bitblock$1$2_0/a_705_407# 0
C464 1bitblock$5_0/a_705_407# m2_1701_n784# 0
C465 1bitblock$3$2_0/a_7768_n37# m1_8729_n3942# 0
C466 1bitblock$2$2_0/a_705_407# m2_2396_n2595# 0.00549f
C467 1bitblock$3$2_0/a_2419_63# m1_12484_n953# 0.04408f
C468 m2_5443_n3913# 1bitblock$1$2_0/a_4650_n37# 0.00119f
C469 1bitblock$3$2_0/a_3498_3# m1_13543_n1146# 1.66674f
C470 1bitblock$3$2_0/a_160_63# 1bitblock$2$2_0/a_378_271# 0.00362f
C471 1bitblock$2$2_0/a_2419_63# 1bitblock$1$2_0/a_3498_3# 0
C472 1bitblock$1$2_0/a_2861_3# m2_1701_n784# 0
C473 1bitblock$2$2_0/a_2419_63# 1bitblock$1$2_0/a_2419_63# 0.00365f
C474 1bitblock$5_0/m2_6151_79# m2_1701_n784# 0
C475 1bitblock$5_0/a_10906_n37# m1_12486_242# 0.00168f
C476 1bitblock$2$2_0/a_10906_n37# m1_12484_n953# 0.00483f
C477 1bitblock$2$2_0/a_378_271# 1bitblock$1$2_0/a_510_63# 0
C478 1bitblock$2$2_0/a_11480_63# m1_12484_n953# 0.0167f
C479 1bitblock$5_0/a_2419_63# 1bitblock$1$2_0/a_11922_3# 0
C480 m2_14516_n651# m1_12484_n953# 0.10897f
C481 1bitblock$2$2_0/a_2861_391# 1bitblock$2$2_0/a_705_407# -0
C482 m2_5443_n3913# 1bitblock$5_0/m2_6151_79# 0.01043f
C483 AND4$2_0/a_912_n441# m2_1701_n784# 0.01194f
C484 m2_5443_n3913# 1bitblock$3$2_0/a_6128_n37# 0
C485 1bitblock$3$2_0/a_8723_63# m1_13543_n1146# 0.02911f
C486 m1_14167_n1145# 1bitblock$1$2_0/a_3498_3# 0
C487 1bitblock$5_0/a_3498_3# m2_1701_n784# 0
C488 1bitblock$3$2_0/a_160_63# m1_n563_n5091# 0.0255f
C489 1bitblock$2$2_0/a_3498_3# m2_2396_n2595# 1.47227f
C490 m1_8729_n3942# 1bitblock$2$2_0/a_9050_63# 0.02224f
C491 1bitblock$3$2_0/a_3940_63# m1_n563_n5091# 0
C492 m2_5443_n3913# 1bitblock$5_0/a_3498_3# 0
C493 1bitblock$5_0/a_2419_63# m2_1701_n784# 0.36366f
C494 m1_14167_n1145# 1bitblock$1$2_0/a_2419_63# 0.004f
C495 m1_14167_n1145# 1bitblock$1$2_0/a_160_63# 0.00107f
C496 1bitblock$5_0/a_160_63# m2_1701_n784# 0.00109f
C497 1bitblock$2$2_0/a_160_63# m2_2396_n2595# 0
C498 1bitblock$5_0/a_1845_n37# m1_14167_n1145# 0
C499 1bitblock$5_0/a_11480_63# m1_12486_242# 0.00896f
C500 1bitblock$2$2_0/a_378_271# 1bitblock$1$2_0/m2_24_342# 0
C501 m2_5443_n3913# 1bitblock$5_0/a_2419_63# 0.00862f
C502 1bitblock$3$2_0/a_2419_63# m2_2396_n2595# 0.00529f
C503 m1_n563_n5091# 1bitblock$1$2_0/a_510_63# 0
C504 m1_8729_n3942# 1bitblock$1$2_0/a_9050_63# 0.02224f
C505 MUX21$2_0/a_718_407# m1_n563_n5091# 0.0018f
C506 1bitblock$1$2_0/a_4290_63# m2_1701_n784# 0
C507 1bitblock$5_0/m2_9431_79# m2_1701_n784# 0
C508 m2_2396_n2595# 1bitblock$2$2_0/m2_9431_79# 0.01952f
C509 m2_5443_n3913# 1bitblock$1$2_0/a_4290_63# 0.00738f
C510 1bitblock$2$2_0/a_10906_n37# m2_2396_n2595# 0.00148f
C511 1bitblock$3$2_0/a_10906_466# m2_10721_n3315# 0.0161f
C512 1bitblock$2$2_0/a_11480_63# m2_2396_n2595# 0.00938f
C513 m2_14516_n651# m2_2396_n2595# 0.00583f
C514 1bitblock$3$2_0/a_160_63# m1_13543_n1146# 0
C515 1bitblock$3$2_0/a_3940_63# m1_13543_n1146# 0
C516 1bitblock$5_0/a_3940_63# m1_12486_242# 0
C517 m1_n563_n5091# 1bitblock$1$2_0/m2_24_342# 0.03103f
C518 1bitblock$1$2_0/a_7410_63# m2_1701_n784# 0
C519 1bitblock$2$2_0/m2_9431_79# 1bitblock$2$2_0/a_8723_63# -0
C520 1bitblock$5_0/a_5042_407# m2_1701_n784# 0.01787f
C521 m2_14516_n651# AND4$2_0/a_704_n441# 0.00119f
C522 m2_5443_n3913# 1bitblock$5_0/a_5042_407# 0.05822f
C523 1bitblock$3$2_0/a_9050_63# m1_13543_n1146# 0.00508f
C524 m1_n563_n5091# 1bitblock$2$2_0/a_10906_466# 0.00105f
C525 m1_8729_n3942# 1bitblock$5_0/a_7410_63# 0.00465f
C526 m2_5443_n3913# 1bitblock$3$2_0/a_4650_n37# 0.00118f
C527 m2_5443_n3913# 1bitblock$1$2_0/a_5042_n37# 0
C528 m2_5443_n3913# 1bitblock$3$2_0/a_3498_3# 0
C529 1bitblock$3$2_0/a_2419_63# m2_10721_n3315# 0.02948f
C530 m1_8729_n3942# 1bitblock$3$2_0/a_7410_63# 0.00461f
C531 1bitblock$5_0/a_3940_63# m2_1701_n784# 0.00164f
C532 m1_14167_n1145# 1bitblock$1$2_0/a_3940_63# 0
C533 m2_2396_n2595# 1bitblock$2$2_0/a_3940_63# 0
C534 m2_5443_n3913# 1bitblock$5_0/a_3940_63# 0.00286f
C535 1bitblock$5_0/a_2419_63# 1bitblock$5_0/a_705_407# -0
C536 1bitblock$3$2_0/a_11922_3# m1_12484_n953# 0
C537 m2_14516_n651# m2_10721_n3315# 0.00204f
C538 1bitblock$3$2_0/a_705_407# 1bitblock$2$2_0/a_1262_n37# 0
C539 1bitblock$3$2_0/m2_6151_79# m1_n563_n5091# 0
C540 1bitblock$3$2_0/a_1262_n37# m1_13543_n1146# -0
C541 1bitblock$5_0/a_2861_3# 1bitblock$1$2_0/a_2419_63# 0
C542 1bitblock$5_0/a_2419_63# 1bitblock$1$2_0/a_2861_3# 0
C543 1bitblock$2$2_0/m2_24_342# m2_2396_n2595# 0.00302f
C544 m1_n563_n5091# 1bitblock$2$2_0/m2_7791_79# -0
C545 1bitblock$3$2_0/a_1845_466# m2_2396_n2595# 0.00179f
C546 1bitblock$3$2_0/a_11922_3# 1bitblock$2$2_0/a_11922_3# 0.0017f
C547 MUX21$2_0/m2_540_79# MUX21$2_0/a_157_63# 0
C548 1bitblock$5_0/a_2419_63# 1bitblock$5_0/a_3498_3# -0
C549 m1_8729_n3942# 1bitblock$2$2_0/a_3498_3# 0.00389f
C550 1bitblock$1$2_0/a_9050_63# 1bitblock$1$2_0/m2_9431_79# -0
C551 1bitblock$3$2_0/m2_9431_79# m1_n563_n5091# -0.00106f
C552 1bitblock$3$2_0/a_11922_391# m1_13543_n1146# 0.00701f
C553 m2_5443_n3913# 1bitblock$3$2_0/a_3940_63# 0.00284f
C554 1bitblock$3$2_0/a_2419_63# m1_8729_n3942# 0.00663f
C555 m2_10721_n3315# 1bitblock$2$2_0/a_3940_63# 0
C556 1bitblock$5_0/a_3498_3# 1bitblock$5_0/m2_9431_79# -0
C557 1bitblock$1$2_0/a_510_63# m2_1701_n784# 0.00173f
C558 1bitblock$2$2_0/a_705_407# 1bitblock$1$2_0/a_705_407# 0.04927f
C559 m2_14516_n651# MUX21$2_0/a_517_n37# 0
C560 MUX21$2_0/a_718_407# m2_1701_n784# 0
C561 m1_14167_n1145# 1bitblock$5_0/m2_7791_79# 0.01686f
C562 m2_5443_n3913# 1bitblock$3$2_0/a_5042_n37# 0
C563 1bitblock$3$2_0/a_378_271# 1bitblock$2$2_0/a_705_407# 0
C564 m1_8729_n3942# 1bitblock$2$2_0/m2_9431_79# 0.02467f
C565 1bitblock$2$2_0/a_510_63# m1_n563_n5091# 0
C566 m1_n563_n5091# m1_12484_n953# 0.32612f
C567 1bitblock$3$2_0/m2_7791_79# m1_n563_n5091# -0
C568 m2_14516_n651# MUX21$2_0/a_157_63# 0.01122f
C569 1bitblock$3$2_0/m2_9431_79# m1_13543_n1146# 0.0201f
C570 1bitblock$1$2_0/m2_24_342# m2_1701_n784# 0.02455f
C571 1bitblock$2$2_0/a_378_271# m2_2396_n2595# 0.00194f
C572 1bitblock$5_0/a_11922_3# m1_10807_n176# 0
C573 1bitblock$2$2_0/a_10363_63# m2_2396_n2595# 0.00459f
C574 m1_n563_n5091# 1bitblock$2$2_0/a_11922_3# 0.00103f
C575 1bitblock$2$2_0/a_705_407# 1bitblock$1$2_0/a_160_63# 0
C576 1bitblock$2$2_0/a_160_63# 1bitblock$1$2_0/a_705_407# 0
C577 m1_n563_n5091# 1bitblock$2$2_0/a_7083_63# 0
C578 1bitblock$2$2_0/a_2861_3# m2_2396_n2595# 0.01973f
C579 m1_13543_n1146# m1_12484_n953# 0.08498f
C580 m1_14167_n1145# m1_10807_n176# 0.08342f
C581 1bitblock$2$2_0/a_510_63# m1_13543_n1146# 0
C582 1bitblock$3$2_0/a_5042_407# m1_n563_n5091# 0
C583 1bitblock$5_0/a_2861_391# 1bitblock$5_0/a_705_407# -0
C584 1bitblock$3$2_0/m2_7791_79# m1_13543_n1146# 0.01676f
C585 1bitblock$3$2_0/a_378_271# 1bitblock$2$2_0/a_160_63# 0.00364f
C586 1bitblock$3$2_0/a_2861_3# 1bitblock$2$2_0/a_2419_63# 0
C587 m2_14516_n651# m1_12480_n3815# 0
C588 1bitblock$3$2_0/a_11922_3# m2_10721_n3315# 0.01722f
C589 m1_n563_n5091# m2_2396_n2595# 1.58588f
C590 1bitblock$5_0/a_10363_63# m1_14167_n1145# 0.00489f
C591 1bitblock$2$2_0/a_3498_3# 1bitblock$1$2_0/a_3498_3# 0.01312f
C592 m1_14167_n1145# 1bitblock$5_0/a_8361_407# 0.03596f
C593 1bitblock$3$2_0/m2_7791_79# 1bitblock$3$2_0/a_9609_407# -0
C594 m1_13543_n1146# 1bitblock$2$2_0/a_11922_3# 0
C595 1bitblock$5_0/a_11922_3# m1_14167_n1145# 0.01214f
C596 1bitblock$2$2_0/a_3498_3# 1bitblock$1$2_0/a_2419_63# 0
C597 m1_n563_n5091# 1bitblock$2$2_0/a_8723_63# -0.0053f
C598 m1_14167_n1145# 1bitblock$5_0/a_7083_63# 0.00482f
C599 AND4$2_0/a_518_229# MUX21$2_0/a_718_407# 0
C600 1bitblock$1$2_0/a_870_n37# m2_1701_n784# 0
C601 1bitblock$5_0/a_2861_391# 1bitblock$5_0/a_3498_3# -0
C602 1bitblock$2$2_0/a_160_63# 1bitblock$1$2_0/a_160_63# 0.00196f
C603 1bitblock$5_0/a_510_63# 1bitblock$1$2_0/a_705_407# 0
C604 1bitblock$5_0/a_705_407# 1bitblock$1$2_0/a_510_63# 0
C605 m1_13543_n1146# m2_2396_n2595# 0.33711f
C606 1bitblock$5_0/a_1845_466# m1_14167_n1145# 0.01466f
C607 1bitblock$5_0/a_10906_466# m1_10807_n176# 0.00242f
C608 m2_5443_n3913# 1bitblock$3$2_0/m2_6151_79# 0.01067f
C609 1bitblock$2$2_0/a_10906_466# 1bitblock$1$2_0/a_10906_466# 0.00145f
C610 m1_12484_n953# m1_12486_242# 0.0157f
C611 m2_2396_n2595# 1bitblock$1$2_0/m2_7791_79# 0.0169f
C612 1bitblock$5_0/a_11922_391# m1_14167_n1145# 0.00712f
C613 1bitblock$3$2_0/m2_24_342# 1bitblock$3$2_0/a_3498_3# -0
C614 1bitblock$5_0/a_705_407# 1bitblock$1$2_0/m2_24_342# 0
C615 m2_14516_n651# 1bitblock$1$2_0/a_2419_63# 0.00162f
C616 m1_14167_n1145# 1bitblock$5_0/a_8723_63# 0.0292f
C617 m2_5443_n3913# 1bitblock$3$2_0/a_5768_63# 0.01326f
C618 m2_10721_n3315# m1_n563_n5091# 0.0925f
C619 m2_5443_n3913# 1bitblock$2$2_0/a_5243_407# 0.01246f
C620 1bitblock$5_0/m2_24_342# 1bitblock$1$2_0/a_705_407# 0
C621 1bitblock$5_0/a_510_63# 1bitblock$1$2_0/a_160_63# 0
C622 m1_12484_n953# 1bitblock$1$2_0/a_11922_3# 0.01185f
C623 1bitblock$5_0/a_160_63# 1bitblock$1$2_0/a_510_63# 0
C624 1bitblock$3$2_0/a_7083_63# m1_13543_n1146# 0.0048f
C625 m1_8729_n3942# 1bitblock$1$2_0/a_9408_n37# 0
C626 1bitblock$5_0/a_10906_466# m1_14167_n1145# 0.01125f
C627 m2_2396_n2595# 1bitblock$1$2_0/a_9609_407# 0.1012f
C628 m2_2396_n2595# m1_12486_242# 0.0866f
C629 m1_12484_n953# m2_1701_n784# 0.00165f
C630 1bitblock$5_0/a_160_63# 1bitblock$1$2_0/m2_24_342# 0.00432f
C631 1bitblock$2$2_0/m2_24_342# 1bitblock$1$2_0/a_705_407# 0
C632 m2_5443_n3913# m1_12484_n953# 0.05387f
C633 m1_8729_n3942# 1bitblock$3$2_0/a_8361_407# 0
C634 m1_13543_n1146# m2_10721_n3315# 0.17094f
C635 1bitblock$2$2_0/a_11480_63# 1bitblock$1$2_0/a_11480_63# 0.00182f
C636 1bitblock$2$2_0/a_11922_3# 1bitblock$1$2_0/a_11922_3# 0
C637 m2_14516_n651# 1bitblock$1$2_0/a_11480_63# 0
C638 m1_8729_n3942# 1bitblock$3$2_0/a_9408_n37# 0
C639 m2_5443_n3913# 1bitblock$5_0/a_6128_n37# 0
C640 1bitblock$3$2_0/a_2861_3# 1bitblock$3$2_0/a_705_407# -0
C641 1bitblock$3$2_0/a_11922_3# m1_12480_n3815# 0.00447f
C642 m1_8729_n3942# 1bitblock$5_0/a_7768_n37# 0
C643 1bitblock$2$2_0/a_7410_63# m1_n563_n5091# 0
C644 m1_12484_n953# 1bitblock$1$2_0/a_11922_391# 0.00359f
C645 m2_2396_n2595# 1bitblock$1$2_0/a_10363_63# 0.00482f
C646 m1_8729_n3942# 1bitblock$2$2_0/a_10363_63# 0.00192f
C647 1bitblock$5_0/m2_24_342# 1bitblock$1$2_0/a_160_63# 0.00441f
C648 m2_2396_n2595# 1bitblock$1$2_0/a_8361_407# 0.03598f
C649 1bitblock$5_0/a_7410_63# 1bitblock$5_0/m2_7791_79# 0
C650 1bitblock$2$2_0/a_1845_466# m2_2396_n2595# 0.01396f
C651 m2_2396_n2595# 1bitblock$1$2_0/a_11922_3# 0.01205f
C652 m2_2396_n2595# 1bitblock$1$2_0/a_7083_63# 0.00482f
C653 m2_5443_n3913# 1bitblock$2$2_0/a_7083_63# 0.00187f
C654 1bitblock$1$2_0/a_1262_n37# m2_1701_n784# 0
C655 m1_8729_n3942# m1_n563_n5091# 0.27477f
C656 m2_2396_n2595# 1bitblock$1$2_0/a_1845_466# 0.0015f
C657 1bitblock$3$2_0/a_5042_407# m2_5443_n3913# 0.05824f
C658 m1_n563_n5091# MUX21$2_0/a_157_63# 0.00149f
C659 m2_2396_n2595# m2_1701_n784# 1.22078f
C660 m1_12484_n953# 1bitblock$1$2_0/a_10906_466# 0
C661 m1_14167_n1145# 1bitblock$1$2_0/a_378_271# 0.00256f
C662 1bitblock$5_0/a_378_271# m2_1701_n784# 0.00257f
C663 1bitblock$2$2_0/m2_24_342# 1bitblock$1$2_0/a_160_63# 0
C664 1bitblock$5_0/a_2861_3# m1_14167_n1145# 0.0205f
C665 m2_5443_n3913# m2_2396_n2595# 0.06231f
C666 1bitblock$5_0/a_9050_63# m2_1701_n784# 0
C667 m2_2396_n2595# 1bitblock$1$2_0/a_11922_391# 0.00705f
C668 AND4$2_0/a_704_n441# m2_1701_n784# 0.01591f
C669 1bitblock$5_0/a_870_n37# 1bitblock$1$2_0/a_160_63# 0.00138f
C670 m2_2396_n2595# 1bitblock$1$2_0/a_8723_63# 0.02997f
C671 1bitblock$5_0/a_160_63# 1bitblock$1$2_0/a_870_n37# 0.00138f
C672 m1_12486_242# VSUBS 3.27675f
C673 1bitblock$1$2_0/a_7083_63# VSUBS 0.85222f
C674 1bitblock$1$2_0/a_8723_63# VSUBS 0.40722f
C675 1bitblock$1$2_0/m2_9431_79# VSUBS 0.62597f
C676 1bitblock$1$2_0/m2_7791_79# VSUBS 0.61991f
C677 1bitblock$1$2_0/a_9609_407# VSUBS 0.11896f
C678 1bitblock$1$2_0/a_8361_407# VSUBS 0.05045f
C679 1bitblock$1$2_0/m2_6151_79# VSUBS 0.6012f
C680 1bitblock$1$2_0/a_6721_407# VSUBS 0.01523f
C681 1bitblock$1$2_0/a_5042_407# VSUBS 0.79698f
C682 1bitblock$1$2_0/a_3940_63# VSUBS 0.46873f
C683 m2_1701_n784# VSUBS 7.90146f
C684 1bitblock$1$2_0/a_160_63# VSUBS 0.60582f
C685 1bitblock$1$2_0/a_5243_407# VSUBS 0.01459f
C686 1bitblock$1$2_0/a_705_407# VSUBS 0.14113f
C687 1bitblock$1$2_0/a_3498_3# VSUBS 1.27913f
C688 1bitblock$1$2_0/a_10906_n37# VSUBS 0.02232f
C689 1bitblock$1$2_0/a_9800_n37# VSUBS 0.01742f
C690 1bitblock$1$2_0/a_9408_n37# VSUBS 0.01326f
C691 1bitblock$1$2_0/a_8160_n37# VSUBS 0.01743f
C692 1bitblock$1$2_0/a_7768_n37# VSUBS 0.01327f
C693 1bitblock$1$2_0/a_6520_n37# VSUBS 0.01743f
C694 1bitblock$1$2_0/a_6128_n37# VSUBS 0.01327f
C695 1bitblock$1$2_0/a_5042_n37# VSUBS 0.01422f
C696 1bitblock$1$2_0/a_4650_n37# VSUBS 0.01569f
C697 1bitblock$1$2_0/a_11922_3# VSUBS 0.64605f
C698 1bitblock$1$2_0/a_11922_391# VSUBS 0.00119f
C699 1bitblock$1$2_0/a_10906_466# VSUBS 0.59827f
C700 1bitblock$1$2_0/a_11480_63# VSUBS 0.42359f
C701 1bitblock$1$2_0/a_10363_63# VSUBS 0.13924f
C702 1bitblock$1$2_0/a_9050_63# VSUBS 0.55145f
C703 1bitblock$1$2_0/a_7410_63# VSUBS 0.55612f
C704 1bitblock$1$2_0/a_5768_63# VSUBS 0.55881f
C705 1bitblock$1$2_0/a_1845_n37# VSUBS 0.01974f
C706 1bitblock$1$2_0/a_1262_n37# VSUBS 0.0127f
C707 1bitblock$1$2_0/a_870_n37# VSUBS 0.01586f
C708 1bitblock$1$2_0/a_4290_63# VSUBS 0.59067f
C709 1bitblock$1$2_0/a_2861_3# VSUBS 0.62907f
C710 1bitblock$1$2_0/a_1845_466# VSUBS 0.59871f
C711 1bitblock$1$2_0/a_2419_63# VSUBS 6.60418f
C712 1bitblock$1$2_0/a_510_63# VSUBS 0.58168f
C713 1bitblock$1$2_0/a_378_271# VSUBS 1.38973f
C714 1bitblock$1$2_0/m2_24_342# VSUBS 1.99971f
C715 m1_10807_n176# VSUBS 5.13684f
C716 1bitblock$5_0/a_7083_63# VSUBS 0.85222f
C717 1bitblock$5_0/a_8723_63# VSUBS 0.40569f
C718 1bitblock$5_0/m2_9431_79# VSUBS 0.62597f
C719 1bitblock$5_0/m2_7791_79# VSUBS 0.61991f
C720 1bitblock$5_0/a_8361_407# VSUBS 0.05045f
C721 1bitblock$5_0/m2_6151_79# VSUBS 0.6012f
C722 1bitblock$5_0/a_6721_407# VSUBS 0.01523f
C723 1bitblock$5_0/a_5042_407# VSUBS 0.79698f
C724 1bitblock$5_0/a_3940_63# VSUBS 0.46873f
C725 m1_14167_n1145# VSUBS 3.95284f
C726 1bitblock$5_0/a_160_63# VSUBS 0.59457f
C727 1bitblock$5_0/a_5243_407# VSUBS 0.01459f
C728 1bitblock$5_0/a_705_407# VSUBS 0.13654f
C729 1bitblock$5_0/a_3498_3# VSUBS 1.27913f
C730 1bitblock$5_0/a_10906_n37# VSUBS 0.02232f
C731 1bitblock$5_0/a_9800_n37# VSUBS 0.01742f
C732 1bitblock$5_0/a_9408_n37# VSUBS 0.01326f
C733 1bitblock$5_0/a_8160_n37# VSUBS 0.01743f
C734 1bitblock$5_0/a_7768_n37# VSUBS 0.01327f
C735 1bitblock$5_0/a_6520_n37# VSUBS 0.01743f
C736 1bitblock$5_0/a_6128_n37# VSUBS 0.01327f
C737 1bitblock$5_0/a_5042_n37# VSUBS 0.01422f
C738 1bitblock$5_0/a_4650_n37# VSUBS 0.01569f
C739 1bitblock$5_0/a_11922_3# VSUBS 0.64588f
C740 1bitblock$5_0/a_11922_391# VSUBS 0.00119f
C741 1bitblock$5_0/a_10906_466# VSUBS 0.59827f
C742 1bitblock$5_0/a_11480_63# VSUBS 0.42359f
C743 1bitblock$5_0/a_10363_63# VSUBS 0.13924f
C744 1bitblock$5_0/a_9050_63# VSUBS 0.55145f
C745 1bitblock$5_0/a_7410_63# VSUBS 0.55612f
C746 1bitblock$5_0/a_5768_63# VSUBS 0.55881f
C747 1bitblock$5_0/a_1845_n37# VSUBS 0.01974f
C748 1bitblock$5_0/a_1262_n37# VSUBS 0.0127f
C749 1bitblock$5_0/a_870_n37# VSUBS 0.01517f
C750 1bitblock$5_0/a_4290_63# VSUBS 0.59067f
C751 1bitblock$5_0/a_2861_3# VSUBS 0.62907f
C752 1bitblock$5_0/a_1845_466# VSUBS 0.5987f
C753 1bitblock$5_0/a_2419_63# VSUBS 6.63957f
C754 1bitblock$5_0/a_510_63# VSUBS 0.58009f
C755 1bitblock$5_0/a_378_271# VSUBS 1.3862f
C756 1bitblock$5_0/m2_24_342# VSUBS 1.9762f
C757 1bitblock$5_0/a_9609_407# VSUBS 0.11896f
C758 AND4$2_0/a_1120_n441# VSUBS 0.02626f
C759 AND4$2_0/a_912_n441# VSUBS 0.02949f
C760 AND4$2_0/a_704_n441# VSUBS 0.03642f
C761 m2_14516_n651# VSUBS 2.96302f
C762 AND4$2_0/a_518_229# VSUBS 0.81913f
C763 MUX21$2_0/m2_540_79# VSUBS 0.81982f
C764 MUX21$2_0/a_718_407# VSUBS 0.15145f
C765 MUX21$2_0/a_909_n37# VSUBS 0.01743f
C766 MUX21$2_0/a_517_n37# VSUBS 0.01327f
C767 MUX21$2_0/a_1472_63# VSUBS 0.17252f
C768 MUX21$2_0/a_157_63# VSUBS 0.65278f
C769 m1_12484_n953# VSUBS 3.35772f
C770 1bitblock$2$2_0/a_7083_63# VSUBS 0.85965f
C771 1bitblock$2$2_0/a_8723_63# VSUBS 0.40727f
C772 1bitblock$2$2_0/m2_9431_79# VSUBS 0.62602f
C773 1bitblock$2$2_0/m2_7791_79# VSUBS 0.61996f
C774 1bitblock$2$2_0/a_9609_407# VSUBS 0.11896f
C775 1bitblock$2$2_0/a_8361_407# VSUBS 0.05045f
C776 1bitblock$2$2_0/m2_6151_79# VSUBS 0.60126f
C777 1bitblock$2$2_0/a_6721_407# VSUBS 0.01523f
C778 1bitblock$2$2_0/a_5042_407# VSUBS 0.80196f
C779 1bitblock$2$2_0/a_3940_63# VSUBS 0.46875f
C780 m2_2396_n2595# VSUBS 3.96636f
C781 1bitblock$2$2_0/a_160_63# VSUBS 0.60571f
C782 1bitblock$2$2_0/a_5243_407# VSUBS 0.01459f
C783 1bitblock$2$2_0/a_705_407# VSUBS 0.14113f
C784 1bitblock$2$2_0/a_3498_3# VSUBS 1.27919f
C785 1bitblock$2$2_0/a_10906_n37# VSUBS 0.02232f
C786 1bitblock$2$2_0/a_9800_n37# VSUBS 0.01742f
C787 1bitblock$2$2_0/a_9408_n37# VSUBS 0.01326f
C788 1bitblock$2$2_0/a_8160_n37# VSUBS 0.01743f
C789 1bitblock$2$2_0/a_7768_n37# VSUBS 0.01327f
C790 1bitblock$2$2_0/a_6520_n37# VSUBS 0.01743f
C791 1bitblock$2$2_0/a_6128_n37# VSUBS 0.01327f
C792 1bitblock$2$2_0/a_5042_n37# VSUBS 0.01422f
C793 1bitblock$2$2_0/a_4650_n37# VSUBS 0.01569f
C794 1bitblock$2$2_0/a_11922_3# VSUBS 0.64587f
C795 1bitblock$2$2_0/a_11922_391# VSUBS 0.00119f
C796 1bitblock$2$2_0/a_10906_466# VSUBS 0.59833f
C797 1bitblock$2$2_0/a_11480_63# VSUBS 0.42359f
C798 1bitblock$2$2_0/a_10363_63# VSUBS 0.13924f
C799 1bitblock$2$2_0/a_9050_63# VSUBS 0.55151f
C800 1bitblock$2$2_0/a_7410_63# VSUBS 0.55618f
C801 1bitblock$2$2_0/a_5768_63# VSUBS 0.55887f
C802 1bitblock$2$2_0/a_1845_n37# VSUBS 0.01974f
C803 1bitblock$2$2_0/a_1262_n37# VSUBS 0.0127f
C804 1bitblock$2$2_0/a_870_n37# VSUBS 0.01586f
C805 1bitblock$2$2_0/a_4290_63# VSUBS 0.59072f
C806 1bitblock$2$2_0/a_2861_3# VSUBS 0.62907f
C807 1bitblock$2$2_0/a_1845_466# VSUBS 0.59875f
C808 1bitblock$2$2_0/a_2419_63# VSUBS 6.72858f
C809 1bitblock$2$2_0/a_510_63# VSUBS 0.58168f
C810 1bitblock$2$2_0/a_378_271# VSUBS 1.38936f
C811 1bitblock$2$2_0/m2_24_342# VSUBS 2.00127f
C812 m2_10721_n3315# VSUBS 3.33193f
C813 1bitblock$3$2_0/a_7083_63# VSUBS 0.85964f
C814 1bitblock$3$2_0/a_8723_63# VSUBS 0.40583f
C815 1bitblock$3$2_0/m2_9431_79# VSUBS 0.62602f
C816 1bitblock$3$2_0/m2_7791_79# VSUBS 0.61996f
C817 1bitblock$3$2_0/a_9609_407# VSUBS 0.11896f
C818 1bitblock$3$2_0/a_8361_407# VSUBS 0.05045f
C819 1bitblock$3$2_0/m2_6151_79# VSUBS 0.60126f
C820 1bitblock$3$2_0/a_6721_407# VSUBS 0.01523f
C821 1bitblock$3$2_0/a_5042_407# VSUBS 0.80196f
C822 1bitblock$3$2_0/a_3940_63# VSUBS 0.46874f
C823 m1_13543_n1146# VSUBS 3.96884f
C824 1bitblock$3$2_0/a_160_63# VSUBS 0.60578f
C825 1bitblock$3$2_0/a_5243_407# VSUBS 0.01459f
C826 1bitblock$3$2_0/a_705_407# VSUBS 0.14117f
C827 1bitblock$3$2_0/a_3498_3# VSUBS 1.27919f
C828 1bitblock$3$2_0/a_10906_n37# VSUBS 0.02232f
C829 1bitblock$3$2_0/a_9800_n37# VSUBS 0.01742f
C830 1bitblock$3$2_0/a_9408_n37# VSUBS 0.01326f
C831 1bitblock$3$2_0/a_8160_n37# VSUBS 0.01743f
C832 1bitblock$3$2_0/a_7768_n37# VSUBS 0.01327f
C833 1bitblock$3$2_0/a_6520_n37# VSUBS 0.01743f
C834 1bitblock$3$2_0/a_6128_n37# VSUBS 0.01327f
C835 1bitblock$3$2_0/a_5042_n37# VSUBS 0.01422f
C836 1bitblock$3$2_0/a_4650_n37# VSUBS 0.01569f
C837 m1_12480_n3815# VSUBS 2.27952f
C838 1bitblock$3$2_0/a_11922_3# VSUBS 0.64588f
C839 1bitblock$3$2_0/a_11922_391# VSUBS 0.00119f
C840 1bitblock$3$2_0/a_10906_466# VSUBS 0.59833f
C841 1bitblock$3$2_0/a_11480_63# VSUBS 0.42359f
C842 1bitblock$3$2_0/a_10363_63# VSUBS 0.13924f
C843 1bitblock$3$2_0/a_9050_63# VSUBS 0.55151f
C844 m1_8729_n3942# VSUBS 2.90486f
C845 1bitblock$3$2_0/a_7410_63# VSUBS 0.55618f
C846 1bitblock$3$2_0/a_5768_63# VSUBS 0.55887f
C847 1bitblock$3$2_0/a_1845_n37# VSUBS 0.01974f
C848 1bitblock$3$2_0/a_1262_n37# VSUBS 0.0127f
C849 1bitblock$3$2_0/a_870_n37# VSUBS 0.01586f
C850 1bitblock$3$2_0/a_4290_63# VSUBS 0.59072f
C851 1bitblock$3$2_0/a_2861_3# VSUBS 0.62907f
C852 1bitblock$3$2_0/a_1845_466# VSUBS 0.59877f
C853 1bitblock$3$2_0/a_2419_63# VSUBS 6.72858f
C854 1bitblock$3$2_0/a_510_63# VSUBS 0.58169f
C855 1bitblock$3$2_0/a_378_271# VSUBS 1.3894f
C856 m1_n563_n5091# VSUBS 0.11812p
C857 m2_5443_n3913# VSUBS 5.24763f
C858 1bitblock$3$2_0/m2_24_342# VSUBS 2.00163f
.ends

.subckt AND4$4 a_992_79# a_372_n441# a_1200_79# a_1686_n317# w_n205_91# a_784_79#
+ a_704_n441# a_576_79# a_912_n441# a_518_229# a_1120_n441#
X0 w_n205_91# a_992_79# a_518_229# w_n205_91# pfet_03v3 ad=0.38p pd=1.76u as=0.38p ps=1.76u w=1u l=0.28u
X1 a_518_229# a_784_79# w_n205_91# w_n205_91# pfet_03v3 ad=0.38p pd=1.76u as=0.38p ps=1.76u w=1u l=0.28u
X2 a_1686_n317# a_518_229# w_n205_91# w_n205_91# pfet_03v3 ad=0.65p pd=3.3u as=0.65p ps=3.3u w=1u l=0.28u
X3 a_912_n441# a_784_79# a_704_n441# a_372_n441# nfet_03v3 ad=0.76p pd=2.76u as=0.76p ps=2.76u w=2u l=0.28u
X4 w_n205_91# a_576_79# a_518_229# w_n205_91# pfet_03v3 ad=0.38p pd=1.76u as=0.65p ps=3.3u w=1u l=0.28u
X5 a_704_n441# a_576_79# a_372_n441# a_372_n441# nfet_03v3 ad=0.76p pd=2.76u as=1.34p ps=5.34u w=2u l=0.28u
X6 a_518_229# a_1200_79# a_1120_n441# a_372_n441# nfet_03v3 ad=1.14p pd=5.14u as=0.76p ps=2.76u w=2u l=0.28u
X7 a_1686_n317# a_518_229# a_372_n441# a_372_n441# nfet_03v3 ad=0.315p pd=2.26u as=0.295p ps=2.18u w=0.5u l=0.28u
X8 a_518_229# a_1200_79# w_n205_91# w_n205_91# pfet_03v3 ad=0.55p pd=3.1u as=0.38p ps=1.76u w=1u l=0.28u
X9 a_1120_n441# a_992_79# a_912_n441# a_372_n441# nfet_03v3 ad=0.76p pd=2.76u as=0.76p ps=2.76u w=2u l=0.28u
C0 a_1686_n317# a_518_229# 0.12995f
C1 a_704_n441# a_518_229# 0.01032f
C2 w_n205_91# a_1686_n317# 0.15164f
C3 a_704_n441# a_784_79# 0.00663f
C4 a_576_79# a_518_229# 0.11544f
C5 a_912_n441# a_518_229# 0.01471f
C6 a_784_79# a_576_79# 0.06396f
C7 w_n205_91# a_576_79# 0.17338f
C8 a_1200_79# a_518_229# 0.20239f
C9 a_912_n441# a_992_79# 0.00663f
C10 a_1200_79# w_n205_91# 0.15834f
C11 a_784_79# a_518_229# 0.11673f
C12 w_n205_91# a_518_229# 1.12991f
C13 a_1200_79# a_992_79# 0.06396f
C14 w_n205_91# a_784_79# 0.14862f
C15 a_1120_n441# a_1200_79# 0.00663f
C16 a_518_229# a_992_79# 0.12168f
C17 a_784_79# a_992_79# 0.06396f
C18 a_1120_n441# a_518_229# 0.02253f
C19 w_n205_91# a_992_79# 0.14838f
C20 a_1120_n441# a_372_n441# 0.02626f
C21 a_912_n441# a_372_n441# 0.02949f
C22 a_704_n441# a_372_n441# 0.03642f
C23 a_1686_n317# a_372_n441# 0.21601f
C24 a_518_229# a_372_n441# 0.81497f
C25 a_1200_79# a_372_n441# 0.23192f
C26 a_992_79# a_372_n441# 0.22411f
C27 a_784_79# a_372_n441# 0.22655f
C28 a_576_79# a_372_n441# 0.27133f
C29 w_n205_91# a_372_n441# 3.35188f
.ends

.subckt x1bitblock$3$4 a_2861_3# a_8361_407# a_6520_n37# a_1262_n37# a_2861_391# a_1845_466#
+ a_10906_n37# a_510_63# a_870_n37# a_6721_407# a_9800_n37# a_11480_63# a_6128_n37#
+ a_5768_63# m2_6151_79# a_11922_391# a_5042_n37# a_9408_n37# a_9609_407# a_8160_n37#
+ a_4158_271# a_11922_3# a_8918_358# a_2419_63# m2_9431_79# a_10906_466# a_4650_n37#
+ a_5243_407# a_3498_3# a_9050_63# a_7768_n37# a_5042_407# a_3940_63# m2_7791_79#
+ a_10363_63# a_160_63# a_4290_63# a_7083_63# a_705_407# a_12559_3# a_7410_63# a_1845_n37#
+ via_dev$5$3$4_9/VSUBS m2_1295_79# a_8723_63# a_378_271# m2_5700_324# w_n310_281#
+ m2_24_342#
X0 a_2419_63# a_1845_466# via_dev$5$3$4_9/VSUBS via_dev$5$3$4_9/VSUBS nfet_03v3 ad=0.315p pd=2.26u as=0.2425p ps=1.97u w=0.5u l=0.28u
X1 a_1845_466# m2_24_342# a_1845_n37# via_dev$5$3$4_9/VSUBS nfet_03v3 ad=0.65p pd=3.3u as=0.42p ps=1.84u w=1u l=0.28u
X2 a_3940_63# m2_1295_79# w_n310_281# w_n310_281# pfet_03v3 ad=0.63p pd=3.26u as=0.65p ps=3.3u w=1u l=0.28u
X3 via_dev$5$3$4_9/VSUBS a_510_63# a_1262_n37# via_dev$5$3$4_9/VSUBS nfet_03v3 ad=0.65p pd=3.3u as=0.3625p ps=1.725u w=1u l=0.28u
X4 a_5243_407# a_4290_63# a_5042_407# w_n310_281# pfet_03v3 ad=1.3p pd=5.3u as=0.725p ps=2.725u w=2u l=0.28u
X5 a_6721_407# a_2419_63# m2_6151_79# w_n310_281# pfet_03v3 ad=0.675p pd=2.675u as=0.725p ps=2.725u w=2u l=0.28u
X6 a_10906_466# a_4158_271# w_n310_281# w_n310_281# pfet_03v3 ad=0.42p pd=1.84u as=0.65p ps=3.3u w=1u l=0.28u
X7 a_4290_63# a_4158_271# via_dev$5$3$4_9/VSUBS via_dev$5$3$4_9/VSUBS nfet_03v3 ad=0.315p pd=2.26u as=0.28p ps=2.12u w=0.5u l=0.28u
X8 w_n310_281# a_378_271# a_705_407# w_n310_281# pfet_03v3 ad=0.725p pd=2.725u as=1.09p ps=5.09u w=2u l=0.28u
X9 a_2861_3# m2_1295_79# via_dev$5$3$4_9/VSUBS via_dev$5$3$4_9/VSUBS nfet_03v3 ad=0.18125p pd=1.225u as=0.325p ps=2.3u w=0.5u l=0.28u
X10 via_dev$5$3$4_9/VSUBS a_2419_63# a_2861_3# via_dev$5$3$4_9/VSUBS nfet_03v3 ad=0.315p pd=2.26u as=0.18125p ps=1.225u w=0.5u l=0.28u
X11 m2_7791_79# m2_1295_79# a_7768_n37# via_dev$5$3$4_9/VSUBS nfet_03v3 ad=0.3375p pd=1.675u as=0.3625p ps=1.725u w=1u l=0.28u
X12 a_10906_n37# a_4158_271# via_dev$5$3$4_9/VSUBS via_dev$5$3$4_9/VSUBS nfet_03v3 ad=0.42p pd=1.84u as=0.63p ps=3.26u w=1u l=0.28u
X13 a_9050_63# a_8918_358# via_dev$5$3$4_9/VSUBS via_dev$5$3$4_9/VSUBS nfet_03v3 ad=0.31p pd=2.24u as=0.24p ps=1.96u w=0.5u l=0.28u
X14 a_11922_3# a_11480_63# via_dev$5$3$4_9/VSUBS via_dev$5$3$4_9/VSUBS nfet_03v3 ad=0.18125p pd=1.225u as=0.325p ps=2.3u w=0.5u l=0.28u
X15 via_dev$5$3$4_9/VSUBS a_2419_63# a_11922_3# via_dev$5$3$4_9/VSUBS nfet_03v3 ad=0.315p pd=2.26u as=0.18125p ps=1.225u w=0.5u l=0.28u
X16 a_705_407# a_510_63# m2_1295_79# w_n310_281# pfet_03v3 ad=1.3p pd=5.3u as=0.725p ps=2.725u w=2u l=0.28u
X17 a_4650_n37# a_4158_271# via_dev$5$3$4_9/VSUBS via_dev$5$3$4_9/VSUBS nfet_03v3 ad=0.3625p pd=1.725u as=0.54p ps=3.08u w=1u l=0.28u
X18 a_2861_3# a_2419_63# a_2861_391# w_n310_281# pfet_03v3 ad=1.3p pd=5.3u as=0.725p ps=2.725u w=2u l=0.28u
X19 a_5768_63# m2_5700_324# via_dev$5$3$4_9/VSUBS via_dev$5$3$4_9/VSUBS nfet_03v3 ad=0.315p pd=2.26u as=0.3175p ps=2.27u w=0.5u l=0.28u
X20 via_dev$5$3$4_9/VSUBS a_9050_63# a_9800_n37# via_dev$5$3$4_9/VSUBS nfet_03v3 ad=0.65p pd=3.3u as=0.3625p ps=1.725u w=1u l=0.28u
X21 a_8361_407# m2_1295_79# m2_7791_79# w_n310_281# pfet_03v3 ad=0.675p pd=2.675u as=0.725p ps=2.725u w=2u l=0.28u
X22 a_9408_n37# a_8918_358# via_dev$5$3$4_9/VSUBS via_dev$5$3$4_9/VSUBS nfet_03v3 ad=0.3625p pd=1.725u as=0.54p ps=3.08u w=1u l=0.28u
X23 a_3498_3# a_2861_3# w_n310_281# w_n310_281# pfet_03v3 ad=0.65p pd=3.3u as=0.675p ps=3.35u w=1u l=0.28u
X24 a_7410_63# m2_5700_324# via_dev$5$3$4_9/VSUBS via_dev$5$3$4_9/VSUBS nfet_03v3 ad=0.31p pd=2.24u as=0.24p ps=1.96u w=0.5u l=0.28u
X25 via_dev$5$3$4_9/VSUBS a_7410_63# a_8160_n37# via_dev$5$3$4_9/VSUBS nfet_03v3 ad=0.65p pd=3.3u as=0.3625p ps=1.725u w=1u l=0.28u
X26 a_8723_63# m2_7791_79# via_dev$5$3$4_9/VSUBS via_dev$5$3$4_9/VSUBS nfet_03v3 ad=0.2625p pd=2.05u as=0.265p ps=2.06u w=0.5u l=0.28u
X27 w_n310_281# a_4158_271# a_5243_407# w_n310_281# pfet_03v3 ad=0.725p pd=2.725u as=1.09p ps=5.09u w=2u l=0.28u
X28 a_5768_63# m2_5700_324# w_n310_281# w_n310_281# pfet_03v3 ad=0.65p pd=3.3u as=0.635p ps=3.27u w=1u l=0.28u
X29 a_9050_63# a_8918_358# w_n310_281# w_n310_281# pfet_03v3 ad=0.64p pd=3.28u as=0.48p ps=2.96u w=1u l=0.28u
X30 a_11922_391# a_11480_63# w_n310_281# w_n310_281# pfet_03v3 ad=0.725p pd=2.725u as=1.3p ps=5.3u w=2u l=0.28u
X31 a_160_63# m2_24_342# via_dev$5$3$4_9/VSUBS via_dev$5$3$4_9/VSUBS nfet_03v3 ad=0.315p pd=2.26u as=0.325p ps=2.3u w=0.5u l=0.28u
X32 a_9609_407# a_9050_63# w_n310_281# w_n310_281# pfet_03v3 ad=1.3p pd=5.3u as=0.725p ps=2.725u w=2u l=0.28u
X33 a_6128_n37# m2_5700_324# via_dev$5$3$4_9/VSUBS via_dev$5$3$4_9/VSUBS nfet_03v3 ad=0.3625p pd=1.725u as=0.54p ps=3.08u w=1u l=0.28u
X34 via_dev$5$3$4_9/VSUBS a_5768_63# a_6520_n37# via_dev$5$3$4_9/VSUBS nfet_03v3 ad=0.65p pd=3.3u as=0.3625p ps=1.725u w=1u l=0.28u
X35 a_7410_63# m2_5700_324# w_n310_281# w_n310_281# pfet_03v3 ad=0.64p pd=3.28u as=0.48p ps=2.96u w=1u l=0.28u
X36 m2_9431_79# a_8918_358# a_9609_407# w_n310_281# pfet_03v3 ad=0.725p pd=2.725u as=1.09p ps=5.09u w=2u l=0.28u
X37 a_11480_63# a_10906_466# via_dev$5$3$4_9/VSUBS via_dev$5$3$4_9/VSUBS nfet_03v3 ad=0.315p pd=2.26u as=0.2425p ps=1.97u w=0.5u l=0.28u
X38 a_1845_466# a_378_271# w_n310_281# w_n310_281# pfet_03v3 ad=0.42p pd=1.84u as=0.65p ps=3.3u w=1u l=0.28u
X39 a_8361_407# a_7410_63# w_n310_281# w_n310_281# pfet_03v3 ad=1.3p pd=5.3u as=0.725p ps=2.725u w=2u l=0.28u
X40 w_n310_281# m2_1295_79# a_10906_466# w_n310_281# pfet_03v3 ad=0.735p pd=2.47u as=0.42p ps=1.84u w=1u l=0.28u
X41 a_7083_63# m2_6151_79# via_dev$5$3$4_9/VSUBS via_dev$5$3$4_9/VSUBS nfet_03v3 ad=0.2625p pd=2.05u as=0.265p ps=2.06u w=0.5u l=0.28u
X42 a_510_63# a_378_271# w_n310_281# w_n310_281# pfet_03v3 ad=0.65p pd=3.3u as=0.56p ps=3.12u w=1u l=0.28u
X43 a_10363_63# m2_9431_79# w_n310_281# w_n310_281# pfet_03v3 ad=0.715p pd=3.43u as=0.53p ps=3.06u w=1u l=0.28u
X44 a_510_63# a_378_271# via_dev$5$3$4_9/VSUBS via_dev$5$3$4_9/VSUBS nfet_03v3 ad=0.315p pd=2.26u as=0.28p ps=2.12u w=0.5u l=0.28u
X45 a_1262_n37# a_160_63# m2_1295_79# via_dev$5$3$4_9/VSUBS nfet_03v3 ad=0.3625p pd=1.725u as=0.3375p ps=1.675u w=1u l=0.28u
X46 a_1845_n37# a_378_271# via_dev$5$3$4_9/VSUBS via_dev$5$3$4_9/VSUBS nfet_03v3 ad=0.42p pd=1.84u as=0.63p ps=3.26u w=1u l=0.28u
X47 m2_6151_79# m2_5700_324# a_6721_407# w_n310_281# pfet_03v3 ad=0.725p pd=2.725u as=1.09p ps=5.09u w=2u l=0.28u
X48 a_6721_407# a_5768_63# w_n310_281# w_n310_281# pfet_03v3 ad=1.3p pd=5.3u as=0.725p ps=2.725u w=2u l=0.28u
X49 a_10363_63# m2_9431_79# via_dev$5$3$4_9/VSUBS via_dev$5$3$4_9/VSUBS nfet_03v3 ad=0.3575p pd=2.43u as=0.265p ps=2.06u w=0.5u l=0.28u
X50 a_10906_466# m2_1295_79# a_10906_n37# via_dev$5$3$4_9/VSUBS nfet_03v3 ad=0.65p pd=3.3u as=0.42p ps=1.84u w=1u l=0.28u
X51 a_8723_63# m2_7791_79# w_n310_281# w_n310_281# pfet_03v3 ad=0.545p pd=3.09u as=0.53p ps=3.06u w=1u l=0.28u
X52 a_11480_63# a_10906_466# w_n310_281# w_n310_281# pfet_03v3 ad=0.65p pd=3.3u as=0.735p ps=2.47u w=1u l=0.28u
X53 a_12559_3# a_11922_3# via_dev$5$3$4_9/VSUBS via_dev$5$3$4_9/VSUBS nfet_03v3 ad=0.315p pd=2.26u as=0.325p ps=2.3u w=0.5u l=0.28u
X54 a_7083_63# m2_6151_79# w_n310_281# w_n310_281# pfet_03v3 ad=0.545p pd=3.09u as=0.53p ps=3.06u w=1u l=0.28u
X55 a_7768_n37# m2_5700_324# via_dev$5$3$4_9/VSUBS via_dev$5$3$4_9/VSUBS nfet_03v3 ad=0.3625p pd=1.725u as=0.54p ps=3.08u w=1u l=0.28u
X56 a_160_63# m2_24_342# w_n310_281# w_n310_281# pfet_03v3 ad=0.63p pd=3.26u as=0.65p ps=3.3u w=1u l=0.28u
X57 m2_1295_79# a_160_63# a_705_407# w_n310_281# pfet_03v3 ad=0.725p pd=2.725u as=0.675p ps=2.675u w=2u l=0.28u
X58 a_5042_n37# a_3940_63# a_5042_407# via_dev$5$3$4_9/VSUBS nfet_03v3 ad=0.3625p pd=1.725u as=0.3375p ps=1.675u w=1u l=0.28u
X59 m2_1295_79# m2_24_342# a_870_n37# via_dev$5$3$4_9/VSUBS nfet_03v3 ad=0.3375p pd=1.675u as=0.3625p ps=1.725u w=1u l=0.28u
X60 a_11922_3# a_2419_63# a_11922_391# w_n310_281# pfet_03v3 ad=1.3p pd=5.3u as=0.725p ps=2.725u w=2u l=0.28u
X61 a_9800_n37# a_7083_63# m2_9431_79# via_dev$5$3$4_9/VSUBS nfet_03v3 ad=0.3625p pd=1.725u as=0.3375p ps=1.675u w=1u l=0.28u
X62 m2_7791_79# m2_5700_324# a_8361_407# w_n310_281# pfet_03v3 ad=0.725p pd=2.725u as=1.09p ps=5.09u w=2u l=0.28u
X63 a_5042_407# a_3940_63# a_5243_407# w_n310_281# pfet_03v3 ad=0.725p pd=2.725u as=0.675p ps=2.675u w=2u l=0.28u
X64 a_3940_63# m2_1295_79# via_dev$5$3$4_9/VSUBS via_dev$5$3$4_9/VSUBS nfet_03v3 ad=0.315p pd=2.26u as=0.325p ps=2.3u w=0.5u l=0.28u
X65 a_8160_n37# a_3498_3# m2_7791_79# via_dev$5$3$4_9/VSUBS nfet_03v3 ad=0.3625p pd=1.725u as=0.3375p ps=1.675u w=1u l=0.28u
X66 a_705_407# m2_24_342# w_n310_281# w_n310_281# pfet_03v3 ad=0.675p pd=2.675u as=0.725p ps=2.725u w=2u l=0.28u
X67 a_5042_407# m2_1295_79# a_4650_n37# via_dev$5$3$4_9/VSUBS nfet_03v3 ad=0.3375p pd=1.675u as=0.3625p ps=1.725u w=1u l=0.28u
X68 a_6520_n37# a_5042_407# m2_6151_79# via_dev$5$3$4_9/VSUBS nfet_03v3 ad=0.3625p pd=1.725u as=0.3375p ps=1.675u w=1u l=0.28u
X69 w_n310_281# a_7083_63# a_9609_407# w_n310_281# pfet_03v3 ad=0.725p pd=2.725u as=0.675p ps=2.675u w=2u l=0.28u
X70 a_2419_63# a_1845_466# w_n310_281# w_n310_281# pfet_03v3 ad=0.65p pd=3.3u as=0.735p ps=2.47u w=1u l=0.28u
X71 m2_9431_79# a_8723_63# a_9408_n37# via_dev$5$3$4_9/VSUBS nfet_03v3 ad=0.3375p pd=1.675u as=0.3625p ps=1.725u w=1u l=0.28u
X72 w_n310_281# a_3498_3# a_8361_407# w_n310_281# pfet_03v3 ad=0.725p pd=2.725u as=0.675p ps=2.675u w=2u l=0.28u
X73 a_2861_391# m2_1295_79# w_n310_281# w_n310_281# pfet_03v3 ad=0.725p pd=2.725u as=1.3p ps=5.3u w=2u l=0.28u
X74 a_4290_63# a_4158_271# w_n310_281# w_n310_281# pfet_03v3 ad=0.65p pd=3.3u as=0.56p ps=3.12u w=1u l=0.28u
X75 a_5243_407# m2_1295_79# w_n310_281# w_n310_281# pfet_03v3 ad=0.675p pd=2.675u as=0.725p ps=2.725u w=2u l=0.28u
X76 w_n310_281# a_5042_407# a_6721_407# w_n310_281# pfet_03v3 ad=0.725p pd=2.725u as=0.675p ps=2.675u w=2u l=0.28u
X77 a_3498_3# a_2861_3# via_dev$5$3$4_9/VSUBS via_dev$5$3$4_9/VSUBS nfet_03v3 ad=0.315p pd=2.26u as=0.325p ps=2.3u w=0.5u l=0.28u
X78 a_9609_407# a_8723_63# m2_9431_79# w_n310_281# pfet_03v3 ad=0.675p pd=2.675u as=0.725p ps=2.725u w=2u l=0.28u
X79 via_dev$5$3$4_9/VSUBS a_4290_63# a_5042_n37# via_dev$5$3$4_9/VSUBS nfet_03v3 ad=0.65p pd=3.3u as=0.3625p ps=1.725u w=1u l=0.28u
X80 m2_6151_79# a_2419_63# a_6128_n37# via_dev$5$3$4_9/VSUBS nfet_03v3 ad=0.3375p pd=1.675u as=0.3625p ps=1.725u w=1u l=0.28u
X81 w_n310_281# m2_24_342# a_1845_466# w_n310_281# pfet_03v3 ad=0.735p pd=2.47u as=0.42p ps=1.84u w=1u l=0.28u
X82 a_870_n37# a_378_271# via_dev$5$3$4_9/VSUBS via_dev$5$3$4_9/VSUBS nfet_03v3 ad=0.3625p pd=1.725u as=0.54p ps=3.08u w=1u l=0.28u
X83 a_12559_3# a_11922_3# w_n310_281# w_n310_281# pfet_03v3 ad=0.65p pd=3.3u as=0.675p ps=3.35u w=1u l=0.28u
C0 m2_1295_79# a_6721_407# 0.00452f
C1 a_5042_407# a_3940_63# 0.0941f
C2 a_7410_63# a_3498_3# 0.11774f
C3 m2_5700_324# a_3498_3# 0.55174f
C4 a_705_407# a_160_63# 0.06737f
C5 a_5768_63# a_7083_63# 0.01494f
C6 a_5042_407# a_6128_n37# 0.00376f
C7 m2_24_342# m2_1295_79# 0.04399f
C8 a_7768_n37# a_8361_407# 0
C9 a_6520_n37# a_4158_271# 0.00406f
C10 a_11480_63# a_10906_466# 0.1131f
C11 w_n310_281# a_2861_391# 0.03535f
C12 m2_1295_79# a_8361_407# 0.02509f
C13 a_2419_63# a_4158_271# 0.14782f
C14 a_9050_63# a_9609_407# 0.1261f
C15 a_1845_466# a_3940_63# 0
C16 a_5768_63# a_3498_3# 0
C17 a_8160_n37# m2_7791_79# 0.01048f
C18 a_10906_466# a_11922_3# 0
C19 a_5042_n37# a_5243_407# 0
C20 w_n310_281# a_9609_407# 0.7653f
C21 a_7083_63# a_8918_358# 0.01057f
C22 m2_24_342# a_510_63# 0.13025f
C23 a_5042_n37# a_4290_63# 0.00898f
C24 m2_6151_79# a_7410_63# 0
C25 m2_5700_324# m2_6151_79# 0.14941f
C26 w_n310_281# a_3940_63# 0.30087f
C27 a_11480_63# m2_1295_79# 0.00126f
C28 a_7410_63# m2_7791_79# 0.36168f
C29 m2_5700_324# m2_7791_79# 0.05245f
C30 m2_1295_79# a_5243_407# 0.10989f
C31 a_8723_63# a_9609_407# 0.0593f
C32 m2_5700_324# a_6721_407# 0.50857f
C33 m2_1295_79# a_4290_63# 0.13519f
C34 m2_9431_79# a_10906_466# 0.00167f
C35 m2_1295_79# a_11922_3# 0
C36 a_1845_466# a_160_63# 0
C37 a_5768_63# m2_6151_79# 0.35511f
C38 a_705_407# m2_1295_79# 0.30816f
C39 a_5768_63# m2_7791_79# 0
C40 m2_9431_79# a_7768_n37# 0
C41 a_5768_63# a_6721_407# 0.14017f
C42 w_n310_281# a_160_63# 0.30515f
C43 a_4158_271# a_4650_n37# 0.00383f
C44 a_5042_407# a_5042_n37# 0.01726f
C45 a_2861_3# a_3498_3# 0.09846f
C46 a_7410_63# a_8361_407# 0.1423f
C47 a_6520_n37# a_7083_63# 0.00272f
C48 m2_5700_324# a_8361_407# 0.05956f
C49 m2_9431_79# m2_1295_79# 0.0078f
C50 a_2419_63# a_7083_63# 0.01345f
C51 a_510_63# a_705_407# 0.13828f
C52 a_5042_407# m2_1295_79# 0.03487f
C53 m2_7791_79# a_8918_358# 0.02764f
C54 a_11480_63# a_10363_63# 0
C55 w_n310_281# a_10906_n37# 0
C56 a_2419_63# a_3498_3# 0.01177f
C57 m2_5700_324# a_5243_407# 0.01927f
C58 w_n310_281# a_10906_466# 0.44509f
C59 m2_5700_324# a_4290_63# 0.01531f
C60 a_9408_n37# a_7083_63# 0.00336f
C61 a_705_407# a_1262_n37# 0
C62 a_11922_391# a_2419_63# 0.00754f
C63 a_4158_271# a_7083_63# 1.09132f
C64 m2_9431_79# a_8160_n37# 0
C65 a_1845_466# m2_1295_79# 0.09644f
C66 a_9050_63# m2_1295_79# 0.00716f
C67 a_12559_3# a_10906_466# 0
C68 a_5768_63# a_5243_407# 0.00722f
C69 a_8361_407# a_8918_358# 0
C70 a_4158_271# a_3498_3# 0.00829f
C71 m2_6151_79# a_6520_n37# 0.00766f
C72 a_5768_63# a_4290_63# 0.01093f
C73 m2_9431_79# a_10363_63# 0.07766f
C74 w_n310_281# m2_1295_79# 2.35222f
C75 a_7410_63# m2_9431_79# 0.00105f
C76 a_2419_63# m2_6151_79# 0.05852f
C77 a_4158_271# a_9800_n37# 0.00497f
C78 a_510_63# a_1845_466# 0.01433f
C79 a_2419_63# m2_7791_79# 0.00843f
C80 a_7410_63# a_5042_407# 0
C81 m2_5700_324# a_5042_407# 0.06917f
C82 a_2419_63# a_6721_407# 0.01825f
C83 m2_1295_79# a_8723_63# 0.00796f
C84 w_n310_281# a_510_63# 0.28255f
C85 a_1845_466# a_1262_n37# 0
C86 m2_6151_79# a_4158_271# 0.04334f
C87 m2_24_342# a_2419_63# 0.00234f
C88 a_10906_466# a_9609_407# 0
C89 a_5768_63# a_5042_407# 0.22596f
C90 a_9408_n37# m2_7791_79# 0
C91 a_4158_271# m2_7791_79# 0
C92 a_2419_63# a_8361_407# 0
C93 a_2861_3# a_5243_407# 0
C94 a_9050_63# a_10363_63# 0.01385f
C95 a_2861_391# m2_1295_79# 0.00841f
C96 a_2861_3# a_4290_63# 0
C97 m2_9431_79# a_8918_358# 0.03217f
C98 w_n310_281# a_10363_63# 0.15741f
C99 m2_24_342# a_378_271# 0.56715f
C100 w_n310_281# a_7410_63# 0.31086f
C101 m2_5700_324# w_n310_281# 1.65678f
C102 a_3498_3# a_7083_63# 0.01356f
C103 m2_1295_79# a_9609_407# 0.0093f
C104 a_2861_3# a_705_407# 0
C105 a_9800_n37# a_7083_63# 0.00527f
C106 a_2419_63# a_11480_63# 0.0769f
C107 a_2419_63# a_5243_407# 0
C108 m2_1295_79# a_3940_63# 0.46061f
C109 a_10363_63# a_8723_63# 0
C110 a_7410_63# a_8723_63# 0.01398f
C111 m2_5700_324# a_8723_63# 0
C112 a_2419_63# a_4290_63# 0.00652f
C113 a_1845_n37# a_1845_466# 0.01333f
C114 a_2419_63# a_11922_3# 0.16984f
C115 a_5768_63# w_n310_281# 0.31314f
C116 a_2419_63# a_705_407# 0
C117 a_2861_3# a_5042_407# 0
C118 w_n310_281# a_1845_n37# 0
C119 m2_6151_79# a_7083_63# 0.08089f
C120 a_11480_63# a_4158_271# 0.00295f
C121 a_9050_63# a_8918_358# 0.09973f
C122 a_4158_271# a_5243_407# 0.02964f
C123 a_7083_63# m2_7791_79# 0.14708f
C124 a_2419_63# m2_9431_79# 0.00832f
C125 a_10906_466# a_10906_n37# 0.01333f
C126 a_4158_271# a_4290_63# 0.11363f
C127 m2_1295_79# a_160_63# 0.09339f
C128 a_6721_407# a_7083_63# 0.01268f
C129 a_4158_271# a_11922_3# 0.0013f
C130 w_n310_281# a_8918_358# 0.49498f
C131 a_5042_407# a_6520_n37# 0.00483f
C132 m2_6151_79# a_3498_3# 0
C133 a_705_407# a_378_271# 0.02817f
C134 a_2861_3# a_1845_466# 0
C135 a_2419_63# a_5042_407# 0.08051f
C136 a_10363_63# a_9609_407# 0.01306f
C137 a_3498_3# m2_7791_79# 0.0296f
C138 a_3498_3# a_6721_407# 0
C139 a_8723_63# a_8918_358# 0.12497f
C140 m2_5700_324# a_3940_63# 0.00132f
C141 a_4290_63# a_4650_n37# 0.01502f
C142 m2_9431_79# a_9408_n37# 0.01733f
C143 a_510_63# a_160_63# 0.28903f
C144 m2_9431_79# a_4158_271# 0.05572f
C145 a_2861_3# w_n310_281# 0.4655f
C146 a_8361_407# a_7083_63# 0.01453f
C147 a_10906_466# m2_1295_79# 0.0692f
C148 m2_24_342# a_3498_3# 0
C149 a_2419_63# a_1845_466# 0.10509f
C150 a_5042_407# a_4158_271# 0.63867f
C151 a_9050_63# a_2419_63# 0.00801f
C152 a_5768_63# a_3940_63# 0
C153 a_3498_3# a_8361_407# 0.12093f
C154 m2_6151_79# m2_7791_79# 0.00114f
C155 w_n310_281# a_2419_63# 0.75125f
C156 m2_6151_79# a_6721_407# 0.4935f
C157 a_5768_63# a_6128_n37# 0.00935f
C158 a_1845_466# a_378_271# 0.01278f
C159 a_5042_407# a_4650_n37# 0.00712f
C160 a_8918_358# a_9609_407# 0.02942f
C161 a_2419_63# a_12559_3# 0
C162 a_2419_63# a_8723_63# 0.00649f
C163 a_9050_63# a_9408_n37# 0.00935f
C164 a_9050_63# a_4158_271# 0.00717f
C165 a_3498_3# a_5243_407# 0.16427f
C166 w_n310_281# a_378_271# 0.63374f
C167 a_2861_3# a_2861_391# 0.01616f
C168 a_11922_391# a_11480_63# 0.00152f
C169 a_3498_3# a_4290_63# 0.00876f
C170 a_10363_63# a_10906_n37# 0
C171 w_n310_281# a_4158_271# 0.66883f
C172 a_510_63# m2_1295_79# 0.39896f
C173 m2_9431_79# a_7083_63# 0.19293f
C174 a_10906_466# a_10363_63# 0.02047f
C175 a_8361_407# m2_7791_79# 0.49779f
C176 a_11922_391# a_11922_3# 0.01891f
C177 a_2861_3# a_3940_63# 0
C178 a_4158_271# a_8723_63# 0
C179 a_5042_407# a_7083_63# 0.02611f
C180 a_2419_63# a_2861_391# 0.0163f
C181 a_7410_63# a_7768_n37# 0.00935f
C182 m2_9431_79# a_3498_3# 0
C183 m2_1295_79# a_1262_n37# 0.01607f
C184 m2_6151_79# a_4290_63# 0
C185 m2_9431_79# a_9800_n37# 0.0074f
C186 a_2419_63# a_9609_407# 0
C187 a_10363_63# m2_1295_79# 0.00179f
C188 a_7410_63# m2_1295_79# 0.07614f
C189 m2_5700_324# m2_1295_79# 0.07849f
C190 a_5042_407# a_3498_3# 0.02015f
C191 a_2419_63# a_3940_63# 0.00879f
C192 a_510_63# a_1262_n37# 0.00898f
C193 a_9050_63# a_7083_63# 0.21474f
C194 a_5768_63# m2_1295_79# 0.00766f
C195 a_9408_n37# a_9609_407# 0
C196 w_n310_281# a_7083_63# 0.31663f
C197 a_4158_271# a_9609_407# 0
C198 a_1845_466# a_3498_3# 0.00105f
C199 m2_9431_79# m2_7791_79# 0.01571f
C200 a_870_n37# a_1845_466# 0
C201 a_4158_271# a_3940_63# 0.16366f
C202 a_1845_n37# m2_1295_79# 0.00942f
C203 a_7410_63# a_8160_n37# 0.01329f
C204 m2_6151_79# a_5042_407# 0.20459f
C205 m2_24_342# a_705_407# 0.10607f
C206 a_8723_63# a_7083_63# 0.15796f
C207 a_9050_63# a_9800_n37# 0.01329f
C208 w_n310_281# a_3498_3# 1.03377f
C209 a_5042_407# m2_7791_79# 0.00555f
C210 a_5042_407# a_6721_407# 0.03265f
C211 m2_1295_79# a_8918_358# 0.01371f
C212 a_11922_391# w_n310_281# 0.03535f
C213 m2_5700_324# a_7410_63# 0.14432f
C214 a_3940_63# a_4650_n37# 0.00441f
C215 a_510_63# a_1845_n37# 0.0011f
C216 a_3498_3# a_8723_63# 0.00575f
C217 a_11480_63# a_11922_3# 0.04054f
C218 a_378_271# a_160_63# 0.09182f
C219 m2_9431_79# a_8361_407# 0
C220 a_4290_63# a_5243_407# 0.14023f
C221 a_2419_63# a_10906_466# 0.00833f
C222 a_2861_3# m2_1295_79# 0.15381f
C223 a_9050_63# m2_7791_79# 0.00127f
C224 w_n310_281# m2_6151_79# 0.44301f
C225 m2_5700_324# a_5768_63# 0.16447f
C226 w_n310_281# m2_7791_79# 0.45142f
C227 a_11480_63# m2_9431_79# 0
C228 a_7083_63# a_9609_407# 0.0285f
C229 w_n310_281# a_6721_407# 0.72579f
C230 m2_24_342# a_1845_466# 0.06999f
C231 a_2861_391# a_3498_3# 0.00454f
C232 a_4158_271# a_10906_n37# 0.00824f
C233 a_2419_63# m2_1295_79# 0.3246f
C234 a_10906_466# a_4158_271# 0.03873f
C235 a_8723_63# m2_7791_79# 0.08381f
C236 a_5042_407# a_5243_407# 0.29512f
C237 a_10363_63# a_8918_358# 0
C238 a_7410_63# a_8918_358# 0
C239 m2_5700_324# a_8918_358# 0
C240 m2_24_342# w_n310_281# 0.66878f
C241 a_5042_407# a_4290_63# 0.38112f
C242 a_4158_271# a_5042_n37# 0
C243 a_9050_63# a_8361_407# 0
C244 a_3498_3# a_3940_63# 0.04602f
C245 w_n310_281# a_8361_407# 0.75753f
C246 a_378_271# m2_1295_79# 0.02669f
C247 a_4158_271# m2_1295_79# 0.16058f
C248 a_8361_407# a_8723_63# 0.01268f
C249 w_n310_281# a_11480_63# 0.37298f
C250 w_n310_281# a_5243_407# 0.78984f
C251 a_705_407# a_1845_466# 0.0126f
C252 m2_7791_79# a_9609_407# 0
C253 a_510_63# a_378_271# 0.14298f
C254 w_n310_281# a_4290_63# 0.2819f
C255 w_n310_281# a_11922_3# 0.46598f
C256 a_870_n37# a_160_63# 0.00441f
C257 a_2419_63# a_10363_63# 0.00126f
C258 a_2419_63# a_7410_63# 0.00801f
C259 m2_5700_324# a_2419_63# 0.074f
C260 m2_6151_79# a_6128_n37# 0.01733f
C261 a_10906_466# a_7083_63# 0
C262 w_n310_281# a_705_407# 0.79414f
C263 a_9050_63# m2_9431_79# 0.328f
C264 a_12559_3# a_11922_3# 0.0899f
C265 a_6128_n37# a_6721_407# 0
C266 a_5768_63# a_6520_n37# 0.01329f
C267 w_n310_281# m2_9431_79# 0.46253f
C268 a_7768_n37# a_7083_63# 0.0028f
C269 a_5768_63# a_2419_63# 0.07749f
C270 a_8361_407# a_9609_407# 0.00466f
C271 a_10363_63# a_4158_271# 0.02222f
C272 a_7410_63# a_4158_271# 0
C273 m2_5700_324# a_4158_271# 0.00861f
C274 w_n310_281# a_5042_407# 0.29911f
C275 m2_1295_79# a_7083_63# 0.01071f
C276 m2_9431_79# a_8723_63# 0.13485f
C277 a_11480_63# a_9609_407# 0
C278 a_2419_63# a_8918_358# 0.01449f
C279 a_5768_63# a_4158_271# 0.00573f
C280 m2_1295_79# a_3498_3# 0.3391f
C281 m2_24_342# a_160_63# 0.42316f
C282 a_2861_391# a_705_407# 0
C283 a_870_n37# m2_1295_79# 0.00639f
C284 w_n310_281# a_1845_466# 0.44517f
C285 a_5243_407# a_3940_63# 0.06737f
C286 a_4290_63# a_3940_63# 0.28903f
C287 a_9050_63# w_n310_281# 0.28931f
C288 m2_6151_79# a_5042_n37# 0
C289 a_8160_n37# a_7083_63# 0.00507f
C290 a_2861_3# a_2419_63# 0.21478f
C291 a_4158_271# a_8918_358# 0.00101f
C292 m2_9431_79# a_9609_407# 0.49779f
C293 a_870_n37# a_510_63# 0.01502f
C294 a_7768_n37# m2_7791_79# 0.01733f
C295 a_9050_63# a_8723_63# 0.52788f
C296 m2_6151_79# m2_1295_79# 0.00667f
C297 a_10363_63# a_7083_63# 0.00582f
C298 a_7410_63# a_7083_63# 0.07718f
C299 m2_5700_324# a_7083_63# 0.12051f
C300 w_n310_281# a_12559_3# 0.08598f
C301 w_n310_281# a_8723_63# 0.33519f
C302 m2_1295_79# m2_7791_79# 0.05731f
C303 a_4158_271# via_dev$5$3$4_9/VSUBS 2.63856f
C304 a_7083_63# via_dev$5$3$4_9/VSUBS 0.86585f
C305 a_8723_63# via_dev$5$3$4_9/VSUBS 0.40977f
C306 m2_9431_79# via_dev$5$3$4_9/VSUBS 0.75255f
C307 m2_7791_79# via_dev$5$3$4_9/VSUBS 0.74612f
C308 a_9609_407# via_dev$5$3$4_9/VSUBS 0.11967f
C309 a_8361_407# via_dev$5$3$4_9/VSUBS 0.05216f
C310 m2_6151_79# via_dev$5$3$4_9/VSUBS 0.72815f
C311 a_6721_407# via_dev$5$3$4_9/VSUBS 0.01698f
C312 a_5042_407# via_dev$5$3$4_9/VSUBS 0.88916f
C313 a_3940_63# via_dev$5$3$4_9/VSUBS 0.46864f
C314 m2_1295_79# via_dev$5$3$4_9/VSUBS 3.34703f
C315 a_160_63# via_dev$5$3$4_9/VSUBS 0.5921f
C316 a_5243_407# via_dev$5$3$4_9/VSUBS 0.01661f
C317 a_705_407# via_dev$5$3$4_9/VSUBS 0.13677f
C318 a_3498_3# via_dev$5$3$4_9/VSUBS 1.27724f
C319 a_10906_n37# via_dev$5$3$4_9/VSUBS 0.02232f
C320 a_9800_n37# via_dev$5$3$4_9/VSUBS 0.01742f
C321 a_9408_n37# via_dev$5$3$4_9/VSUBS 0.007f
C322 a_8160_n37# via_dev$5$3$4_9/VSUBS 0.01743f
C323 a_7768_n37# via_dev$5$3$4_9/VSUBS 0.007f
C324 a_6520_n37# via_dev$5$3$4_9/VSUBS 0.01743f
C325 a_6128_n37# via_dev$5$3$4_9/VSUBS 0.007f
C326 a_5042_n37# via_dev$5$3$4_9/VSUBS 0.00833f
C327 a_4650_n37# via_dev$5$3$4_9/VSUBS 0.01565f
C328 a_12559_3# via_dev$5$3$4_9/VSUBS 0.19481f
C329 a_11922_3# via_dev$5$3$4_9/VSUBS 0.64569f
C330 a_11922_391# via_dev$5$3$4_9/VSUBS 0.00119f
C331 a_10906_466# via_dev$5$3$4_9/VSUBS 0.59796f
C332 a_11480_63# via_dev$5$3$4_9/VSUBS 0.42359f
C333 a_10363_63# via_dev$5$3$4_9/VSUBS 0.13924f
C334 a_9050_63# via_dev$5$3$4_9/VSUBS 0.53264f
C335 a_8918_358# via_dev$5$3$4_9/VSUBS 0.5203f
C336 a_7410_63# via_dev$5$3$4_9/VSUBS 0.53731f
C337 a_5768_63# via_dev$5$3$4_9/VSUBS 0.54f
C338 a_1845_n37# via_dev$5$3$4_9/VSUBS 0.01974f
C339 a_1262_n37# via_dev$5$3$4_9/VSUBS 0.0069f
C340 a_870_n37# via_dev$5$3$4_9/VSUBS 0.01517f
C341 a_4290_63# via_dev$5$3$4_9/VSUBS 0.57048f
C342 a_2861_3# via_dev$5$3$4_9/VSUBS 0.62907f
C343 a_1845_466# via_dev$5$3$4_9/VSUBS 0.59853f
C344 a_2419_63# via_dev$5$3$4_9/VSUBS 6.64114f
C345 a_510_63# via_dev$5$3$4_9/VSUBS 0.55998f
C346 a_378_271# via_dev$5$3$4_9/VSUBS 1.37769f
C347 w_n310_281# via_dev$5$3$4_9/VSUBS 27.06676f
C348 m2_5700_324# via_dev$5$3$4_9/VSUBS 1.14834f
C349 m2_24_342# via_dev$5$3$4_9/VSUBS 1.98211f
.ends

.subckt x1bitblock$2$4 a_2861_3# a_8361_407# a_6520_n37# a_1262_n37# a_2861_391# a_1845_466#
+ a_10906_n37# a_510_63# a_870_n37# a_6721_407# a_9800_n37# a_11480_63# a_6128_n37#
+ a_5768_63# a_8919_367# m2_6151_79# a_11922_391# a_5042_n37# a_9408_n37# a_9609_407#
+ a_5042_407# a_8160_n37# a_4158_271# a_11922_3# a_2419_63# m2_9431_79# a_10906_466#
+ a_4650_n37# a_9050_63# a_5243_407# a_7768_n37# a_3940_63# m2_7791_79# a_10363_63#
+ a_160_63# a_4290_63# a_7083_63# a_705_407# a_12559_3# a_7410_63# a_1845_n37# via_dev$5$2$4_9/VSUBS
+ m2_5700_324# m2_1295_79# a_8723_63# a_378_271# a_3498_3# w_n310_281# m2_24_342#
X0 a_2419_63# a_1845_466# via_dev$5$2$4_9/VSUBS via_dev$5$2$4_9/VSUBS nfet_03v3 ad=0.315p pd=2.26u as=0.2425p ps=1.97u w=0.5u l=0.28u
X1 a_1845_466# m2_24_342# a_1845_n37# via_dev$5$2$4_9/VSUBS nfet_03v3 ad=0.65p pd=3.3u as=0.42p ps=1.84u w=1u l=0.28u
X2 a_3940_63# m2_1295_79# w_n310_281# w_n310_281# pfet_03v3 ad=0.63p pd=3.26u as=0.65p ps=3.3u w=1u l=0.28u
X3 via_dev$5$2$4_9/VSUBS a_510_63# a_1262_n37# via_dev$5$2$4_9/VSUBS nfet_03v3 ad=0.65p pd=3.3u as=0.3625p ps=1.725u w=1u l=0.28u
X4 a_5243_407# a_4290_63# a_5042_407# w_n310_281# pfet_03v3 ad=1.3p pd=5.3u as=0.725p ps=2.725u w=2u l=0.28u
X5 a_6721_407# a_2419_63# m2_6151_79# w_n310_281# pfet_03v3 ad=0.675p pd=2.675u as=0.725p ps=2.725u w=2u l=0.28u
X6 a_10906_466# a_4158_271# w_n310_281# w_n310_281# pfet_03v3 ad=0.42p pd=1.84u as=0.65p ps=3.3u w=1u l=0.28u
X7 a_4290_63# a_4158_271# via_dev$5$2$4_9/VSUBS via_dev$5$2$4_9/VSUBS nfet_03v3 ad=0.315p pd=2.26u as=0.28p ps=2.12u w=0.5u l=0.28u
X8 w_n310_281# a_378_271# a_705_407# w_n310_281# pfet_03v3 ad=0.725p pd=2.725u as=1.09p ps=5.09u w=2u l=0.28u
X9 a_2861_3# m2_1295_79# via_dev$5$2$4_9/VSUBS via_dev$5$2$4_9/VSUBS nfet_03v3 ad=0.18125p pd=1.225u as=0.325p ps=2.3u w=0.5u l=0.28u
X10 via_dev$5$2$4_9/VSUBS a_2419_63# a_2861_3# via_dev$5$2$4_9/VSUBS nfet_03v3 ad=0.315p pd=2.26u as=0.18125p ps=1.225u w=0.5u l=0.28u
X11 m2_7791_79# m2_1295_79# a_7768_n37# via_dev$5$2$4_9/VSUBS nfet_03v3 ad=0.3375p pd=1.675u as=0.3625p ps=1.725u w=1u l=0.28u
X12 a_10906_n37# a_4158_271# via_dev$5$2$4_9/VSUBS via_dev$5$2$4_9/VSUBS nfet_03v3 ad=0.42p pd=1.84u as=0.63p ps=3.26u w=1u l=0.28u
X13 a_9050_63# a_8919_367# via_dev$5$2$4_9/VSUBS via_dev$5$2$4_9/VSUBS nfet_03v3 ad=0.31p pd=2.24u as=0.24p ps=1.96u w=0.5u l=0.28u
X14 a_11922_3# a_11480_63# via_dev$5$2$4_9/VSUBS via_dev$5$2$4_9/VSUBS nfet_03v3 ad=0.18125p pd=1.225u as=0.325p ps=2.3u w=0.5u l=0.28u
X15 via_dev$5$2$4_9/VSUBS a_2419_63# a_11922_3# via_dev$5$2$4_9/VSUBS nfet_03v3 ad=0.315p pd=2.26u as=0.18125p ps=1.225u w=0.5u l=0.28u
X16 a_705_407# a_510_63# m2_1295_79# w_n310_281# pfet_03v3 ad=1.3p pd=5.3u as=0.725p ps=2.725u w=2u l=0.28u
X17 a_4650_n37# a_4158_271# via_dev$5$2$4_9/VSUBS via_dev$5$2$4_9/VSUBS nfet_03v3 ad=0.3625p pd=1.725u as=0.54p ps=3.08u w=1u l=0.28u
X18 a_2861_3# a_2419_63# a_2861_391# w_n310_281# pfet_03v3 ad=1.3p pd=5.3u as=0.725p ps=2.725u w=2u l=0.28u
X19 a_5768_63# m2_5700_324# via_dev$5$2$4_9/VSUBS via_dev$5$2$4_9/VSUBS nfet_03v3 ad=0.315p pd=2.26u as=0.3175p ps=2.27u w=0.5u l=0.28u
X20 via_dev$5$2$4_9/VSUBS a_9050_63# a_9800_n37# via_dev$5$2$4_9/VSUBS nfet_03v3 ad=0.65p pd=3.3u as=0.3625p ps=1.725u w=1u l=0.28u
X21 a_8361_407# m2_1295_79# m2_7791_79# w_n310_281# pfet_03v3 ad=0.675p pd=2.675u as=0.725p ps=2.725u w=2u l=0.28u
X22 a_9408_n37# a_8919_367# via_dev$5$2$4_9/VSUBS via_dev$5$2$4_9/VSUBS nfet_03v3 ad=0.3625p pd=1.725u as=0.54p ps=3.08u w=1u l=0.28u
X23 a_3498_3# a_2861_3# w_n310_281# w_n310_281# pfet_03v3 ad=0.65p pd=3.3u as=0.675p ps=3.35u w=1u l=0.28u
X24 a_7410_63# m2_5700_324# via_dev$5$2$4_9/VSUBS via_dev$5$2$4_9/VSUBS nfet_03v3 ad=0.31p pd=2.24u as=0.24p ps=1.96u w=0.5u l=0.28u
X25 via_dev$5$2$4_9/VSUBS a_7410_63# a_8160_n37# via_dev$5$2$4_9/VSUBS nfet_03v3 ad=0.65p pd=3.3u as=0.3625p ps=1.725u w=1u l=0.28u
X26 a_8723_63# m2_7791_79# via_dev$5$2$4_9/VSUBS via_dev$5$2$4_9/VSUBS nfet_03v3 ad=0.2625p pd=2.05u as=0.265p ps=2.06u w=0.5u l=0.28u
X27 w_n310_281# a_4158_271# a_5243_407# w_n310_281# pfet_03v3 ad=0.725p pd=2.725u as=1.09p ps=5.09u w=2u l=0.28u
X28 a_5768_63# m2_5700_324# w_n310_281# w_n310_281# pfet_03v3 ad=0.65p pd=3.3u as=0.635p ps=3.27u w=1u l=0.28u
X29 a_9050_63# a_8919_367# w_n310_281# w_n310_281# pfet_03v3 ad=0.64p pd=3.28u as=0.48p ps=2.96u w=1u l=0.28u
X30 a_11922_391# a_11480_63# w_n310_281# w_n310_281# pfet_03v3 ad=0.725p pd=2.725u as=1.3p ps=5.3u w=2u l=0.28u
X31 a_160_63# m2_24_342# via_dev$5$2$4_9/VSUBS via_dev$5$2$4_9/VSUBS nfet_03v3 ad=0.315p pd=2.26u as=0.325p ps=2.3u w=0.5u l=0.28u
X32 a_9609_407# a_9050_63# w_n310_281# w_n310_281# pfet_03v3 ad=1.3p pd=5.3u as=0.725p ps=2.725u w=2u l=0.28u
X33 a_6128_n37# m2_5700_324# via_dev$5$2$4_9/VSUBS via_dev$5$2$4_9/VSUBS nfet_03v3 ad=0.3625p pd=1.725u as=0.54p ps=3.08u w=1u l=0.28u
X34 via_dev$5$2$4_9/VSUBS a_5768_63# a_6520_n37# via_dev$5$2$4_9/VSUBS nfet_03v3 ad=0.65p pd=3.3u as=0.3625p ps=1.725u w=1u l=0.28u
X35 a_7410_63# m2_5700_324# w_n310_281# w_n310_281# pfet_03v3 ad=0.64p pd=3.28u as=0.48p ps=2.96u w=1u l=0.28u
X36 m2_9431_79# a_8919_367# a_9609_407# w_n310_281# pfet_03v3 ad=0.725p pd=2.725u as=1.09p ps=5.09u w=2u l=0.28u
X37 a_11480_63# a_10906_466# via_dev$5$2$4_9/VSUBS via_dev$5$2$4_9/VSUBS nfet_03v3 ad=0.315p pd=2.26u as=0.2425p ps=1.97u w=0.5u l=0.28u
X38 a_1845_466# a_378_271# w_n310_281# w_n310_281# pfet_03v3 ad=0.42p pd=1.84u as=0.65p ps=3.3u w=1u l=0.28u
X39 a_8361_407# a_7410_63# w_n310_281# w_n310_281# pfet_03v3 ad=1.3p pd=5.3u as=0.725p ps=2.725u w=2u l=0.28u
X40 w_n310_281# m2_1295_79# a_10906_466# w_n310_281# pfet_03v3 ad=0.735p pd=2.47u as=0.42p ps=1.84u w=1u l=0.28u
X41 a_7083_63# m2_6151_79# via_dev$5$2$4_9/VSUBS via_dev$5$2$4_9/VSUBS nfet_03v3 ad=0.2625p pd=2.05u as=0.265p ps=2.06u w=0.5u l=0.28u
X42 a_510_63# a_378_271# w_n310_281# w_n310_281# pfet_03v3 ad=0.65p pd=3.3u as=0.56p ps=3.12u w=1u l=0.28u
X43 a_10363_63# m2_9431_79# w_n310_281# w_n310_281# pfet_03v3 ad=0.715p pd=3.43u as=0.53p ps=3.06u w=1u l=0.28u
X44 a_510_63# a_378_271# via_dev$5$2$4_9/VSUBS via_dev$5$2$4_9/VSUBS nfet_03v3 ad=0.315p pd=2.26u as=0.28p ps=2.12u w=0.5u l=0.28u
X45 a_1262_n37# a_160_63# m2_1295_79# via_dev$5$2$4_9/VSUBS nfet_03v3 ad=0.3625p pd=1.725u as=0.3375p ps=1.675u w=1u l=0.28u
X46 a_1845_n37# a_378_271# via_dev$5$2$4_9/VSUBS via_dev$5$2$4_9/VSUBS nfet_03v3 ad=0.42p pd=1.84u as=0.63p ps=3.26u w=1u l=0.28u
X47 m2_6151_79# m2_5700_324# a_6721_407# w_n310_281# pfet_03v3 ad=0.725p pd=2.725u as=1.09p ps=5.09u w=2u l=0.28u
X48 a_6721_407# a_5768_63# w_n310_281# w_n310_281# pfet_03v3 ad=1.3p pd=5.3u as=0.725p ps=2.725u w=2u l=0.28u
X49 a_10363_63# m2_9431_79# via_dev$5$2$4_9/VSUBS via_dev$5$2$4_9/VSUBS nfet_03v3 ad=0.3575p pd=2.43u as=0.265p ps=2.06u w=0.5u l=0.28u
X50 a_10906_466# m2_1295_79# a_10906_n37# via_dev$5$2$4_9/VSUBS nfet_03v3 ad=0.65p pd=3.3u as=0.42p ps=1.84u w=1u l=0.28u
X51 a_8723_63# m2_7791_79# w_n310_281# w_n310_281# pfet_03v3 ad=0.545p pd=3.09u as=0.53p ps=3.06u w=1u l=0.28u
X52 a_11480_63# a_10906_466# w_n310_281# w_n310_281# pfet_03v3 ad=0.65p pd=3.3u as=0.735p ps=2.47u w=1u l=0.28u
X53 a_12559_3# a_11922_3# via_dev$5$2$4_9/VSUBS via_dev$5$2$4_9/VSUBS nfet_03v3 ad=0.315p pd=2.26u as=0.325p ps=2.3u w=0.5u l=0.28u
X54 a_7083_63# m2_6151_79# w_n310_281# w_n310_281# pfet_03v3 ad=0.545p pd=3.09u as=0.53p ps=3.06u w=1u l=0.28u
X55 a_7768_n37# m2_5700_324# via_dev$5$2$4_9/VSUBS via_dev$5$2$4_9/VSUBS nfet_03v3 ad=0.3625p pd=1.725u as=0.54p ps=3.08u w=1u l=0.28u
X56 a_160_63# m2_24_342# w_n310_281# w_n310_281# pfet_03v3 ad=0.63p pd=3.26u as=0.65p ps=3.3u w=1u l=0.28u
X57 m2_1295_79# a_160_63# a_705_407# w_n310_281# pfet_03v3 ad=0.725p pd=2.725u as=0.675p ps=2.675u w=2u l=0.28u
X58 a_5042_n37# a_3940_63# a_5042_407# via_dev$5$2$4_9/VSUBS nfet_03v3 ad=0.3625p pd=1.725u as=0.3375p ps=1.675u w=1u l=0.28u
X59 m2_1295_79# m2_24_342# a_870_n37# via_dev$5$2$4_9/VSUBS nfet_03v3 ad=0.3375p pd=1.675u as=0.3625p ps=1.725u w=1u l=0.28u
X60 a_11922_3# a_2419_63# a_11922_391# w_n310_281# pfet_03v3 ad=1.3p pd=5.3u as=0.725p ps=2.725u w=2u l=0.28u
X61 a_9800_n37# a_7083_63# m2_9431_79# via_dev$5$2$4_9/VSUBS nfet_03v3 ad=0.3625p pd=1.725u as=0.3375p ps=1.675u w=1u l=0.28u
X62 m2_7791_79# m2_5700_324# a_8361_407# w_n310_281# pfet_03v3 ad=0.725p pd=2.725u as=1.09p ps=5.09u w=2u l=0.28u
X63 a_5042_407# a_3940_63# a_5243_407# w_n310_281# pfet_03v3 ad=0.725p pd=2.725u as=0.675p ps=2.675u w=2u l=0.28u
X64 a_3940_63# m2_1295_79# via_dev$5$2$4_9/VSUBS via_dev$5$2$4_9/VSUBS nfet_03v3 ad=0.315p pd=2.26u as=0.325p ps=2.3u w=0.5u l=0.28u
X65 a_8160_n37# a_3498_3# m2_7791_79# via_dev$5$2$4_9/VSUBS nfet_03v3 ad=0.3625p pd=1.725u as=0.3375p ps=1.675u w=1u l=0.28u
X66 a_705_407# m2_24_342# w_n310_281# w_n310_281# pfet_03v3 ad=0.675p pd=2.675u as=0.725p ps=2.725u w=2u l=0.28u
X67 a_5042_407# m2_1295_79# a_4650_n37# via_dev$5$2$4_9/VSUBS nfet_03v3 ad=0.3375p pd=1.675u as=0.3625p ps=1.725u w=1u l=0.28u
X68 a_6520_n37# a_5042_407# m2_6151_79# via_dev$5$2$4_9/VSUBS nfet_03v3 ad=0.3625p pd=1.725u as=0.3375p ps=1.675u w=1u l=0.28u
X69 w_n310_281# a_7083_63# a_9609_407# w_n310_281# pfet_03v3 ad=0.725p pd=2.725u as=0.675p ps=2.675u w=2u l=0.28u
X70 a_2419_63# a_1845_466# w_n310_281# w_n310_281# pfet_03v3 ad=0.65p pd=3.3u as=0.735p ps=2.47u w=1u l=0.28u
X71 m2_9431_79# a_8723_63# a_9408_n37# via_dev$5$2$4_9/VSUBS nfet_03v3 ad=0.3375p pd=1.675u as=0.3625p ps=1.725u w=1u l=0.28u
X72 w_n310_281# a_3498_3# a_8361_407# w_n310_281# pfet_03v3 ad=0.725p pd=2.725u as=0.675p ps=2.675u w=2u l=0.28u
X73 a_2861_391# m2_1295_79# w_n310_281# w_n310_281# pfet_03v3 ad=0.725p pd=2.725u as=1.3p ps=5.3u w=2u l=0.28u
X74 a_4290_63# a_4158_271# w_n310_281# w_n310_281# pfet_03v3 ad=0.65p pd=3.3u as=0.56p ps=3.12u w=1u l=0.28u
X75 a_5243_407# m2_1295_79# w_n310_281# w_n310_281# pfet_03v3 ad=0.675p pd=2.675u as=0.725p ps=2.725u w=2u l=0.28u
X76 w_n310_281# a_5042_407# a_6721_407# w_n310_281# pfet_03v3 ad=0.725p pd=2.725u as=0.675p ps=2.675u w=2u l=0.28u
X77 a_3498_3# a_2861_3# via_dev$5$2$4_9/VSUBS via_dev$5$2$4_9/VSUBS nfet_03v3 ad=0.315p pd=2.26u as=0.325p ps=2.3u w=0.5u l=0.28u
X78 a_9609_407# a_8723_63# m2_9431_79# w_n310_281# pfet_03v3 ad=0.675p pd=2.675u as=0.725p ps=2.725u w=2u l=0.28u
X79 via_dev$5$2$4_9/VSUBS a_4290_63# a_5042_n37# via_dev$5$2$4_9/VSUBS nfet_03v3 ad=0.65p pd=3.3u as=0.3625p ps=1.725u w=1u l=0.28u
X80 m2_6151_79# a_2419_63# a_6128_n37# via_dev$5$2$4_9/VSUBS nfet_03v3 ad=0.3375p pd=1.675u as=0.3625p ps=1.725u w=1u l=0.28u
X81 w_n310_281# m2_24_342# a_1845_466# w_n310_281# pfet_03v3 ad=0.735p pd=2.47u as=0.42p ps=1.84u w=1u l=0.28u
X82 a_870_n37# a_378_271# via_dev$5$2$4_9/VSUBS via_dev$5$2$4_9/VSUBS nfet_03v3 ad=0.3625p pd=1.725u as=0.54p ps=3.08u w=1u l=0.28u
X83 a_12559_3# a_11922_3# w_n310_281# w_n310_281# pfet_03v3 ad=0.65p pd=3.3u as=0.675p ps=3.35u w=1u l=0.28u
C0 a_11480_63# a_11922_391# 0.00152f
C1 a_4290_63# a_5042_407# 0.38112f
C2 w_n310_281# a_160_63# 0.30515f
C3 a_4158_271# a_3498_3# 0.00829f
C4 a_7410_63# m2_5700_324# 0.14432f
C5 a_2419_63# m2_7791_79# 0.00843f
C6 w_n310_281# m2_1295_79# 2.3522f
C7 a_7083_63# m2_7791_79# 0.14708f
C8 a_705_407# a_2861_391# 0
C9 a_4158_271# a_9800_n37# 0.00497f
C10 a_2861_3# a_5243_407# 0
C11 a_2419_63# a_1845_466# 0.10509f
C12 a_8361_407# a_8723_63# 0.01268f
C13 a_9609_407# a_8361_407# 0.00466f
C14 m2_1295_79# a_3498_3# 0.3391f
C15 w_n310_281# m2_6151_79# 0.44301f
C16 a_705_407# a_1845_466# 0.0126f
C17 a_7410_63# a_4158_271# 0
C18 a_5768_63# a_3940_63# 0
C19 m2_5700_324# a_5243_407# 0.01927f
C20 a_2419_63# a_5042_407# 0.08051f
C21 a_7083_63# a_5042_407# 0.02611f
C22 a_10906_n37# a_4158_271# 0.00824f
C23 a_1262_n37# a_1845_466# 0
C24 m2_6151_79# a_3498_3# 0
C25 m2_5700_324# a_8919_367# 0
C26 a_510_63# a_1845_n37# 0.0011f
C27 a_9050_63# m2_9431_79# 0.328f
C28 a_510_63# a_1845_466# 0.01433f
C29 a_2861_3# a_3940_63# 0
C30 a_9050_63# a_8919_367# 0.10006f
C31 w_n310_281# a_11922_391# 0.03535f
C32 a_7410_63# m2_1295_79# 0.07614f
C33 a_705_407# a_378_271# 0.02817f
C34 a_4158_271# a_10906_466# 0.03873f
C35 a_4158_271# a_5243_407# 0.02964f
C36 a_5768_63# a_4290_63# 0.01093f
C37 w_n310_281# a_3498_3# 1.03377f
C38 a_11480_63# a_10906_466# 0.1131f
C39 a_7083_63# a_7768_n37# 0.0028f
C40 m2_5700_324# a_3940_63# 0.00132f
C41 a_4158_271# m2_9431_79# 0.05572f
C42 a_378_271# a_510_63# 0.14298f
C43 a_4158_271# a_11922_3# 0.0013f
C44 a_8919_367# a_4158_271# 0.001f
C45 a_7410_63# m2_6151_79# 0
C46 a_2419_63# a_8361_407# 0
C47 m2_1295_79# a_10906_466# 0.0692f
C48 a_4158_271# a_4650_n37# 0.00383f
C49 a_11480_63# m2_9431_79# 0
C50 a_7083_63# a_8361_407# 0.01453f
C51 a_9050_63# a_9408_n37# 0.00935f
C52 a_2861_3# a_4290_63# 0
C53 m2_5700_324# a_8723_63# 0
C54 a_11480_63# a_11922_3# 0.04054f
C55 m2_1295_79# a_5243_407# 0.10989f
C56 a_9050_63# a_8723_63# 0.53121f
C57 a_5042_n37# a_5243_407# 0
C58 a_9050_63# a_9609_407# 0.1261f
C59 m2_1295_79# m2_9431_79# 0.0078f
C60 a_7410_63# w_n310_281# 0.31086f
C61 m2_1295_79# a_11922_3# 0
C62 a_8919_367# m2_1295_79# 0.01372f
C63 a_4158_271# a_3940_63# 0.16366f
C64 a_2419_63# a_5768_63# 0.07749f
C65 m2_5700_324# a_4290_63# 0.01531f
C66 w_n310_281# a_10906_n37# 0
C67 a_5768_63# a_7083_63# 0.01494f
C68 a_4158_271# a_8723_63# 0
C69 a_7410_63# a_3498_3# 0.11774f
C70 m2_24_342# a_160_63# 0.42316f
C71 a_9609_407# a_4158_271# 0
C72 m2_24_342# m2_1295_79# 0.04399f
C73 w_n310_281# a_10906_466# 0.44509f
C74 a_1845_466# a_1845_n37# 0.01333f
C75 a_6721_407# a_5042_407# 0.03265f
C76 a_2419_63# a_2861_3# 0.21478f
C77 m2_1295_79# a_3940_63# 0.46061f
C78 a_9609_407# a_11480_63# 0
C79 w_n310_281# a_5243_407# 0.78984f
C80 a_4290_63# a_4158_271# 0.11363f
C81 a_5042_407# m2_7791_79# 0.00555f
C82 m2_1295_79# a_8723_63# 0.00803f
C83 w_n310_281# m2_9431_79# 0.46254f
C84 a_9609_407# m2_1295_79# 0.0093f
C85 a_705_407# a_2861_3# 0
C86 w_n310_281# a_11922_3# 0.46598f
C87 w_n310_281# a_8919_367# 0.49838f
C88 a_2419_63# m2_5700_324# 0.074f
C89 a_6721_407# a_6128_n37# 0
C90 a_378_271# a_1845_466# 0.01278f
C91 a_5243_407# a_3498_3# 0.16427f
C92 a_11922_3# a_11922_391# 0.01891f
C93 m2_5700_324# a_7083_63# 0.12051f
C94 a_9050_63# a_2419_63# 0.00801f
C95 a_9050_63# a_7083_63# 0.21474f
C96 m2_9431_79# a_3498_3# 0
C97 a_4290_63# m2_1295_79# 0.13519f
C98 a_510_63# a_870_n37# 0.01502f
C99 a_7083_63# a_6520_n37# 0.00272f
C100 w_n310_281# m2_24_342# 0.66878f
C101 a_7768_n37# m2_7791_79# 0.01733f
C102 a_4290_63# a_5042_n37# 0.00898f
C103 w_n310_281# a_3940_63# 0.30087f
C104 m2_9431_79# a_9800_n37# 0.0074f
C105 a_9050_63# a_10363_63# 0.01385f
C106 a_2419_63# a_4158_271# 0.14782f
C107 a_8361_407# m2_7791_79# 0.49779f
C108 a_7410_63# a_8160_n37# 0.01329f
C109 w_n310_281# a_8723_63# 0.33584f
C110 m2_24_342# a_3498_3# 0
C111 a_7083_63# a_4158_271# 1.09132f
C112 m2_6151_79# a_4290_63# 0
C113 w_n310_281# a_9609_407# 0.7653f
C114 a_2419_63# a_11480_63# 0.0769f
C115 a_10906_n37# a_10906_466# 0.01333f
C116 a_3940_63# a_3498_3# 0.04602f
C117 a_7410_63# m2_9431_79# 0.00105f
C118 a_5768_63# a_6721_407# 0.14017f
C119 a_7410_63# a_8919_367# 0
C120 a_6128_n37# a_5042_407# 0.00376f
C121 a_8723_63# a_3498_3# 0.00575f
C122 a_2419_63# m2_1295_79# 0.32461f
C123 a_4158_271# a_10363_63# 0.02222f
C124 w_n310_281# a_4290_63# 0.2819f
C125 a_5768_63# m2_7791_79# 0
C126 a_7083_63# m2_1295_79# 0.01071f
C127 a_11480_63# a_10363_63# 0
C128 a_705_407# a_160_63# 0.06737f
C129 a_2861_391# a_2861_3# 0.01616f
C130 a_10906_466# m2_9431_79# 0.00167f
C131 a_705_407# m2_1295_79# 0.30816f
C132 a_10906_466# a_11922_3# 0
C133 a_4290_63# a_3498_3# 0.00876f
C134 m2_9431_79# a_8160_n37# 0
C135 m2_1295_79# a_10363_63# 0.00179f
C136 a_2419_63# m2_6151_79# 0.05852f
C137 m2_6151_79# a_7083_63# 0.08089f
C138 a_1262_n37# m2_1295_79# 0.01607f
C139 a_7410_63# a_8723_63# 0.01398f
C140 m2_5700_324# a_6721_407# 0.50857f
C141 a_510_63# a_160_63# 0.28903f
C142 a_1845_466# a_870_n37# 0
C143 a_8919_367# m2_9431_79# 0.03216f
C144 a_510_63# m2_1295_79# 0.39896f
C145 a_1845_466# a_2861_3# 0
C146 a_8361_407# a_7768_n37# 0
C147 a_5768_63# a_5042_407# 0.22596f
C148 a_2419_63# w_n310_281# 0.75129f
C149 m2_5700_324# m2_7791_79# 0.05245f
C150 w_n310_281# a_7083_63# 0.31663f
C151 a_2419_63# a_11922_391# 0.00754f
C152 a_9050_63# m2_7791_79# 0.00127f
C153 a_3940_63# a_5243_407# 0.06737f
C154 a_705_407# w_n310_281# 0.79414f
C155 a_2861_3# a_5042_407# 0
C156 a_9609_407# a_10906_466# 0
C157 a_2419_63# a_3498_3# 0.01177f
C158 a_5768_63# a_6128_n37# 0.00935f
C159 w_n310_281# a_10363_63# 0.15741f
C160 a_7083_63# a_3498_3# 0.01356f
C161 m2_9431_79# a_9408_n37# 0.01733f
C162 a_3940_63# a_4650_n37# 0.00441f
C163 m2_9431_79# a_8723_63# 0.13485f
C164 a_4158_271# m2_7791_79# 0
C165 a_9609_407# m2_9431_79# 0.49779f
C166 a_7083_63# a_9800_n37# 0.00527f
C167 a_8919_367# a_8723_63# 0.12587f
C168 w_n310_281# a_510_63# 0.28255f
C169 m2_5700_324# a_5042_407# 0.06917f
C170 a_8919_367# a_9609_407# 0.02942f
C171 w_n310_281# a_12559_3# 0.08598f
C172 a_4290_63# a_5243_407# 0.14023f
C173 m2_1295_79# a_6721_407# 0.00452f
C174 a_2861_391# m2_1295_79# 0.00841f
C175 a_6520_n37# a_5042_407# 0.00483f
C176 a_7410_63# a_2419_63# 0.00801f
C177 m2_1295_79# m2_7791_79# 0.05731f
C178 a_7410_63# a_7083_63# 0.07718f
C179 a_4290_63# a_4650_n37# 0.01502f
C180 m2_1295_79# a_1845_n37# 0.00942f
C181 a_1845_466# a_160_63# 0
C182 a_1845_466# m2_1295_79# 0.09644f
C183 m2_6151_79# a_6721_407# 0.4935f
C184 a_4158_271# a_5042_407# 0.63867f
C185 a_9609_407# a_9408_n37# 0
C186 a_2419_63# a_10906_466# 0.00833f
C187 a_9609_407# a_8723_63# 0.0593f
C188 m2_5700_324# a_8361_407# 0.05956f
C189 m2_6151_79# m2_7791_79# 0.00114f
C190 a_4290_63# a_3940_63# 0.28903f
C191 a_7083_63# a_10906_466# 0
C192 a_2419_63# a_5243_407# 0
C193 a_9050_63# a_8361_407# 0
C194 a_10906_n37# a_10363_63# 0
C195 w_n310_281# a_6721_407# 0.72579f
C196 a_7083_63# a_8160_n37# 0.00507f
C197 w_n310_281# a_2861_391# 0.03535f
C198 a_378_271# a_160_63# 0.09182f
C199 a_378_271# m2_1295_79# 0.02669f
C200 m2_1295_79# a_5042_407# 0.03487f
C201 a_2419_63# m2_9431_79# 0.00832f
C202 a_2419_63# a_11922_3# 0.16984f
C203 a_2419_63# a_8919_367# 0.01445f
C204 a_7083_63# m2_9431_79# 0.19293f
C205 w_n310_281# m2_7791_79# 0.45139f
C206 a_5042_n37# a_5042_407# 0.01726f
C207 a_10906_466# a_10363_63# 0.02047f
C208 a_8919_367# a_7083_63# 0.01057f
C209 a_6721_407# a_3498_3# 0
C210 m2_5700_324# a_5768_63# 0.16447f
C211 w_n310_281# a_1845_n37# 0
C212 a_2861_391# a_3498_3# 0.00454f
C213 w_n310_281# a_1845_466# 0.44517f
C214 a_5768_63# a_6520_n37# 0.01329f
C215 a_2419_63# m2_24_342# 0.00234f
C216 a_12559_3# a_10906_466# 0
C217 m2_6151_79# a_5042_407# 0.20459f
C218 m2_9431_79# a_10363_63# 0.07766f
C219 a_3498_3# m2_7791_79# 0.0296f
C220 a_8919_367# a_10363_63# 0
C221 a_2419_63# a_3940_63# 0.00879f
C222 a_1845_466# a_3498_3# 0.00105f
C223 a_705_407# m2_24_342# 0.10607f
C224 m2_1295_79# a_8361_407# 0.02509f
C225 a_7083_63# a_9408_n37# 0.00336f
C226 a_2419_63# a_8723_63# 0.00661f
C227 a_378_271# w_n310_281# 0.6337f
C228 w_n310_281# a_5042_407# 0.29911f
C229 a_5768_63# a_4158_271# 0.00573f
C230 a_12559_3# a_11922_3# 0.0899f
C231 a_2419_63# a_9609_407# 0
C232 a_7083_63# a_8723_63# 0.15796f
C233 m2_6151_79# a_6128_n37# 0.01733f
C234 a_9609_407# a_7083_63# 0.0285f
C235 a_7410_63# m2_7791_79# 0.36168f
C236 a_510_63# m2_24_342# 0.13025f
C237 a_5042_407# a_3498_3# 0.02015f
C238 a_2419_63# a_4290_63# 0.00652f
C239 a_8723_63# a_10363_63# 0
C240 a_5768_63# m2_1295_79# 0.00766f
C241 a_9609_407# a_10363_63# 0.01306f
C242 a_870_n37# a_160_63# 0.00441f
C243 w_n310_281# a_8361_407# 0.75753f
C244 m2_1295_79# a_870_n37# 0.00639f
C245 m2_5700_324# a_4158_271# 0.00861f
C246 a_2861_3# m2_1295_79# 0.15381f
C247 a_8160_n37# m2_7791_79# 0.01048f
C248 a_9050_63# a_4158_271# 0.00717f
C249 a_5768_63# m2_6151_79# 0.35511f
C250 a_7410_63# a_5042_407# 0
C251 a_6520_n37# a_4158_271# 0.00406f
C252 m2_9431_79# m2_7791_79# 0.01571f
C253 a_8361_407# a_3498_3# 0.12093f
C254 a_8919_367# m2_7791_79# 0.02774f
C255 m2_5700_324# m2_1295_79# 0.07849f
C256 a_2419_63# a_7083_63# 0.01345f
C257 w_n310_281# a_5768_63# 0.31314f
C258 a_9050_63# m2_1295_79# 0.00716f
C259 a_7410_63# a_7768_n37# 0.00935f
C260 a_705_407# a_2419_63# 0
C261 a_11480_63# a_4158_271# 0.00295f
C262 a_5243_407# a_5042_407# 0.29512f
C263 a_2419_63# a_10363_63# 0.00126f
C264 a_5768_63# a_3498_3# 0
C265 w_n310_281# a_2861_3# 0.4655f
C266 a_7083_63# a_10363_63# 0.00582f
C267 m2_5700_324# m2_6151_79# 0.14941f
C268 a_9408_n37# m2_7791_79# 0
C269 a_7410_63# a_8361_407# 0.1423f
C270 a_1845_466# m2_24_342# 0.06999f
C271 m2_1295_79# a_4158_271# 0.16058f
C272 a_8723_63# m2_7791_79# 0.08396f
C273 a_1845_466# a_3940_63# 0
C274 m2_6151_79# a_6520_n37# 0.00766f
C275 a_4650_n37# a_5042_407# 0.00712f
C276 a_9609_407# m2_7791_79# 0
C277 a_2419_63# a_12559_3# 0
C278 a_4158_271# a_5042_n37# 0
C279 a_11480_63# m2_1295_79# 0.00126f
C280 a_2861_3# a_3498_3# 0.09846f
C281 a_705_407# a_1262_n37# 0
C282 m2_5700_324# w_n310_281# 1.65678f
C283 a_9050_63# w_n310_281# 0.28931f
C284 a_705_407# a_510_63# 0.13828f
C285 a_378_271# m2_24_342# 0.56715f
C286 m2_1295_79# a_160_63# 0.09339f
C287 m2_9431_79# a_7768_n37# 0
C288 m2_6151_79# a_4158_271# 0.04334f
C289 a_3940_63# a_5042_407# 0.0941f
C290 m2_5700_324# a_3498_3# 0.55174f
C291 a_1262_n37# a_510_63# 0.00898f
C292 m2_9431_79# a_8361_407# 0
C293 a_8919_367# a_8361_407# 0
C294 w_n310_281# a_4158_271# 0.66883f
C295 m2_6151_79# m2_1295_79# 0.00667f
C296 a_9050_63# a_9800_n37# 0.01329f
C297 w_n310_281# a_11480_63# 0.37298f
C298 a_2419_63# a_6721_407# 0.01825f
C299 m2_6151_79# a_5042_n37# 0
C300 a_2419_63# a_2861_391# 0.0163f
C301 a_5768_63# a_5243_407# 0.00722f
C302 a_7083_63# a_6721_407# 0.01268f
C303 a_4158_271# via_dev$5$2$4_9/VSUBS 2.63898f
C304 a_7083_63# via_dev$5$2$4_9/VSUBS 0.86585f
C305 a_8723_63# via_dev$5$2$4_9/VSUBS 0.41121f
C306 m2_9431_79# via_dev$5$2$4_9/VSUBS 0.75255f
C307 m2_7791_79# via_dev$5$2$4_9/VSUBS 0.74612f
C308 a_9609_407# via_dev$5$2$4_9/VSUBS 0.11967f
C309 a_8361_407# via_dev$5$2$4_9/VSUBS 0.05216f
C310 m2_6151_79# via_dev$5$2$4_9/VSUBS 0.72815f
C311 a_6721_407# via_dev$5$2$4_9/VSUBS 0.01698f
C312 a_5042_407# via_dev$5$2$4_9/VSUBS 0.88916f
C313 a_3940_63# via_dev$5$2$4_9/VSUBS 0.46864f
C314 m2_1295_79# via_dev$5$2$4_9/VSUBS 3.37184f
C315 a_160_63# via_dev$5$2$4_9/VSUBS 0.5921f
C316 a_5243_407# via_dev$5$2$4_9/VSUBS 0.01661f
C317 a_705_407# via_dev$5$2$4_9/VSUBS 0.13677f
C318 a_3498_3# via_dev$5$2$4_9/VSUBS 1.27724f
C319 a_10906_n37# via_dev$5$2$4_9/VSUBS 0.02232f
C320 a_9800_n37# via_dev$5$2$4_9/VSUBS 0.01742f
C321 a_9408_n37# via_dev$5$2$4_9/VSUBS 0.007f
C322 a_8160_n37# via_dev$5$2$4_9/VSUBS 0.01743f
C323 a_7768_n37# via_dev$5$2$4_9/VSUBS 0.007f
C324 a_6520_n37# via_dev$5$2$4_9/VSUBS 0.01743f
C325 a_6128_n37# via_dev$5$2$4_9/VSUBS 0.007f
C326 a_5042_n37# via_dev$5$2$4_9/VSUBS 0.00833f
C327 a_4650_n37# via_dev$5$2$4_9/VSUBS 0.01565f
C328 a_12559_3# via_dev$5$2$4_9/VSUBS 0.19481f
C329 a_11922_3# via_dev$5$2$4_9/VSUBS 0.64569f
C330 a_11922_391# via_dev$5$2$4_9/VSUBS 0.00119f
C331 a_10906_466# via_dev$5$2$4_9/VSUBS 0.59796f
C332 a_11480_63# via_dev$5$2$4_9/VSUBS 0.42359f
C333 a_10363_63# via_dev$5$2$4_9/VSUBS 0.13924f
C334 a_9050_63# via_dev$5$2$4_9/VSUBS 0.53264f
C335 a_8919_367# via_dev$5$2$4_9/VSUBS 0.51866f
C336 a_7410_63# via_dev$5$2$4_9/VSUBS 0.53731f
C337 a_5768_63# via_dev$5$2$4_9/VSUBS 0.54f
C338 a_1845_n37# via_dev$5$2$4_9/VSUBS 0.01974f
C339 a_1262_n37# via_dev$5$2$4_9/VSUBS 0.0069f
C340 a_870_n37# via_dev$5$2$4_9/VSUBS 0.01517f
C341 a_4290_63# via_dev$5$2$4_9/VSUBS 0.57048f
C342 a_2861_3# via_dev$5$2$4_9/VSUBS 0.62907f
C343 a_1845_466# via_dev$5$2$4_9/VSUBS 0.59853f
C344 a_2419_63# via_dev$5$2$4_9/VSUBS 6.64114f
C345 a_510_63# via_dev$5$2$4_9/VSUBS 0.55998f
C346 a_378_271# via_dev$5$2$4_9/VSUBS 1.37769f
C347 w_n310_281# via_dev$5$2$4_9/VSUBS 27.01716f
C348 m2_24_342# via_dev$5$2$4_9/VSUBS 1.98211f
C349 m2_5700_324# via_dev$5$2$4_9/VSUBS 1.14834f
.ends

.subckt MUX21$4 a_1472_63# a_157_63# a_25_271# a_909_n37# a_650_n277# a_517_n37# a_718_407#
+ m2_540_79# via_dev$11$4_4/VSUBS a_846_955# w_n310_281#
X0 a_1472_63# m2_540_79# via_dev$11$4_4/VSUBS via_dev$11$4_4/VSUBS nfet_03v3 ad=0.2625p pd=2.05u as=0.265p ps=2.06u w=0.5u l=0.28u
X1 a_157_63# a_25_271# w_n310_281# w_n310_281# pfet_03v3 ad=0.65p pd=3.3u as=0.635p ps=3.27u w=1u l=0.28u
X2 a_718_407# a_650_n277# m2_540_79# w_n310_281# pfet_03v3 ad=0.675p pd=2.675u as=0.725p ps=2.725u w=2u l=0.28u
X3 a_517_n37# a_25_271# via_dev$11$4_4/VSUBS via_dev$11$4_4/VSUBS nfet_03v3 ad=0.3625p pd=1.725u as=0.54p ps=3.08u w=1u l=0.28u
X4 via_dev$11$4_4/VSUBS a_157_63# a_909_n37# via_dev$11$4_4/VSUBS nfet_03v3 ad=0.65p pd=3.3u as=0.3625p ps=1.725u w=1u l=0.28u
X5 m2_540_79# a_25_271# a_718_407# w_n310_281# pfet_03v3 ad=0.725p pd=2.725u as=1.09p ps=5.09u w=2u l=0.28u
X6 a_157_63# a_25_271# via_dev$11$4_4/VSUBS via_dev$11$4_4/VSUBS nfet_03v3 ad=0.315p pd=2.26u as=0.3175p ps=2.27u w=0.5u l=0.28u
X7 a_718_407# a_157_63# w_n310_281# w_n310_281# pfet_03v3 ad=1.3p pd=5.3u as=0.725p ps=2.725u w=2u l=0.28u
X8 a_909_n37# a_846_955# m2_540_79# via_dev$11$4_4/VSUBS nfet_03v3 ad=0.3625p pd=1.725u as=0.3375p ps=1.675u w=1u l=0.28u
X9 w_n310_281# a_846_955# a_718_407# w_n310_281# pfet_03v3 ad=0.725p pd=2.725u as=0.675p ps=2.675u w=2u l=0.28u
X10 a_1472_63# m2_540_79# w_n310_281# w_n310_281# pfet_03v3 ad=0.545p pd=3.09u as=0.53p ps=3.06u w=1u l=0.28u
X11 m2_540_79# a_650_n277# a_517_n37# via_dev$11$4_4/VSUBS nfet_03v3 ad=0.3375p pd=1.675u as=0.3625p ps=1.725u w=1u l=0.28u
C0 w_n310_281# a_25_271# 0.47695f
C1 m2_540_79# a_25_271# 0.03352f
C2 a_25_271# a_157_63# 0.11031f
C3 a_1472_63# a_25_271# 0
C4 m2_540_79# w_n310_281# 0.45246f
C5 a_718_407# a_25_271# 0.03028f
C6 w_n310_281# a_157_63# 0.32903f
C7 a_846_955# w_n310_281# 0.19275f
C8 m2_540_79# a_909_n37# 0.01048f
C9 m2_540_79# a_157_63# 0.36591f
C10 a_846_955# m2_540_79# 0.017f
C11 a_1472_63# w_n310_281# 0.10269f
C12 a_909_n37# a_157_63# 0.01329f
C13 m2_540_79# a_1472_63# 0.0785f
C14 a_846_955# a_157_63# 0.07151f
C15 a_1472_63# a_157_63# 0.0156f
C16 a_846_955# a_1472_63# 0
C17 a_718_407# w_n310_281# 0.7633f
C18 m2_540_79# a_718_407# 0.49779f
C19 a_650_n277# a_25_271# 0.03814f
C20 a_718_407# a_157_63# 0.14486f
C21 a_846_955# a_718_407# 0.01845f
C22 a_718_407# a_1472_63# 0.01268f
C23 a_650_n277# w_n310_281# 0.11257f
C24 m2_540_79# a_650_n277# 0.03687f
C25 a_517_n37# m2_540_79# 0.01733f
C26 a_650_n277# a_157_63# 0.02096f
C27 a_846_955# a_650_n277# 0.04128f
C28 a_517_n37# a_157_63# 0.00935f
C29 a_650_n277# a_1472_63# 0
C30 a_718_407# a_650_n277# 0.01687f
C31 a_517_n37# a_718_407# 0
C32 m2_540_79# via_dev$11$4_4/VSUBS 0.94619f
C33 a_718_407# via_dev$11$4_4/VSUBS 0.15332f
C34 a_909_n37# via_dev$11$4_4/VSUBS 0.01743f
C35 a_517_n37# via_dev$11$4_4/VSUBS 0.007f
C36 a_1472_63# via_dev$11$4_4/VSUBS 0.17252f
C37 a_157_63# via_dev$11$4_4/VSUBS 0.63396f
C38 a_650_n277# via_dev$11$4_4/VSUBS 0.37069f
C39 a_25_271# via_dev$11$4_4/VSUBS 0.66513f
C40 a_846_955# via_dev$11$4_4/VSUBS 0.36058f
C41 w_n310_281# via_dev$11$4_4/VSUBS 4.23822f
.ends

.subckt x1bitblock$7 a_2861_3# a_8361_407# a_6520_n37# a_1262_n37# a_2861_391# a_1845_466#
+ a_10906_n37# a_510_63# a_870_n37# a_6721_407# a_9800_n37# a_11480_63# a_6128_n37#
+ a_5768_63# m2_6151_79# a_3498_3# a_11922_391# a_5042_n37# a_9408_n37# a_8918_357#
+ a_9609_407# a_5042_407# a_8160_n37# a_4158_271# a_11922_3# a_2419_63# m2_9431_79#
+ a_10906_466# a_4650_n37# a_9050_63# a_5243_407# a_7768_n37# a_3940_63# m2_7791_79#
+ a_10363_63# a_160_63# a_4290_63# a_7083_63# a_705_407# a_12559_3# a_7410_63# m2_5700_324#
+ a_1845_n37# via_dev$5$7_9/VSUBS m2_1295_79# a_8723_63# a_378_271# w_n310_281# m2_24_342#
X0 a_2419_63# a_1845_466# via_dev$5$7_9/VSUBS via_dev$5$7_9/VSUBS nfet_03v3 ad=0.315p pd=2.26u as=0.2425p ps=1.97u w=0.5u l=0.28u
X1 a_1845_466# m2_24_342# a_1845_n37# via_dev$5$7_9/VSUBS nfet_03v3 ad=0.65p pd=3.3u as=0.42p ps=1.84u w=1u l=0.28u
X2 a_3940_63# m2_1295_79# w_n310_281# w_n310_281# pfet_03v3 ad=0.63p pd=3.26u as=0.65p ps=3.3u w=1u l=0.28u
X3 via_dev$5$7_9/VSUBS a_510_63# a_1262_n37# via_dev$5$7_9/VSUBS nfet_03v3 ad=0.65p pd=3.3u as=0.3625p ps=1.725u w=1u l=0.28u
X4 a_5243_407# a_4290_63# a_5042_407# w_n310_281# pfet_03v3 ad=1.3p pd=5.3u as=0.725p ps=2.725u w=2u l=0.28u
X5 a_6721_407# a_2419_63# m2_6151_79# w_n310_281# pfet_03v3 ad=0.675p pd=2.675u as=0.725p ps=2.725u w=2u l=0.28u
X6 a_10906_466# a_4158_271# w_n310_281# w_n310_281# pfet_03v3 ad=0.42p pd=1.84u as=0.65p ps=3.3u w=1u l=0.28u
X7 a_4290_63# a_4158_271# via_dev$5$7_9/VSUBS via_dev$5$7_9/VSUBS nfet_03v3 ad=0.315p pd=2.26u as=0.28p ps=2.12u w=0.5u l=0.28u
X8 w_n310_281# a_378_271# a_705_407# w_n310_281# pfet_03v3 ad=0.725p pd=2.725u as=1.09p ps=5.09u w=2u l=0.28u
X9 a_2861_3# m2_1295_79# via_dev$5$7_9/VSUBS via_dev$5$7_9/VSUBS nfet_03v3 ad=0.18125p pd=1.225u as=0.325p ps=2.3u w=0.5u l=0.28u
X10 via_dev$5$7_9/VSUBS a_2419_63# a_2861_3# via_dev$5$7_9/VSUBS nfet_03v3 ad=0.315p pd=2.26u as=0.18125p ps=1.225u w=0.5u l=0.28u
X11 m2_7791_79# m2_1295_79# a_7768_n37# via_dev$5$7_9/VSUBS nfet_03v3 ad=0.3375p pd=1.675u as=0.3625p ps=1.725u w=1u l=0.28u
X12 a_10906_n37# a_4158_271# via_dev$5$7_9/VSUBS via_dev$5$7_9/VSUBS nfet_03v3 ad=0.42p pd=1.84u as=0.63p ps=3.26u w=1u l=0.28u
X13 a_9050_63# a_8918_357# via_dev$5$7_9/VSUBS via_dev$5$7_9/VSUBS nfet_03v3 ad=0.31p pd=2.24u as=0.24p ps=1.96u w=0.5u l=0.28u
X14 a_11922_3# a_11480_63# via_dev$5$7_9/VSUBS via_dev$5$7_9/VSUBS nfet_03v3 ad=0.18125p pd=1.225u as=0.325p ps=2.3u w=0.5u l=0.28u
X15 via_dev$5$7_9/VSUBS a_2419_63# a_11922_3# via_dev$5$7_9/VSUBS nfet_03v3 ad=0.315p pd=2.26u as=0.18125p ps=1.225u w=0.5u l=0.28u
X16 a_705_407# a_510_63# m2_1295_79# w_n310_281# pfet_03v3 ad=1.3p pd=5.3u as=0.725p ps=2.725u w=2u l=0.28u
X17 a_4650_n37# a_4158_271# via_dev$5$7_9/VSUBS via_dev$5$7_9/VSUBS nfet_03v3 ad=0.3625p pd=1.725u as=0.54p ps=3.08u w=1u l=0.28u
X18 a_2861_3# a_2419_63# a_2861_391# w_n310_281# pfet_03v3 ad=1.3p pd=5.3u as=0.725p ps=2.725u w=2u l=0.28u
X19 a_5768_63# m2_5700_324# via_dev$5$7_9/VSUBS via_dev$5$7_9/VSUBS nfet_03v3 ad=0.315p pd=2.26u as=0.3175p ps=2.27u w=0.5u l=0.28u
X20 via_dev$5$7_9/VSUBS a_9050_63# a_9800_n37# via_dev$5$7_9/VSUBS nfet_03v3 ad=0.65p pd=3.3u as=0.3625p ps=1.725u w=1u l=0.28u
X21 a_8361_407# m2_1295_79# m2_7791_79# w_n310_281# pfet_03v3 ad=0.675p pd=2.675u as=0.725p ps=2.725u w=2u l=0.28u
X22 a_9408_n37# a_8918_357# via_dev$5$7_9/VSUBS via_dev$5$7_9/VSUBS nfet_03v3 ad=0.3625p pd=1.725u as=0.54p ps=3.08u w=1u l=0.28u
X23 a_3498_3# a_2861_3# w_n310_281# w_n310_281# pfet_03v3 ad=0.65p pd=3.3u as=0.675p ps=3.35u w=1u l=0.28u
X24 a_7410_63# m2_5700_324# via_dev$5$7_9/VSUBS via_dev$5$7_9/VSUBS nfet_03v3 ad=0.31p pd=2.24u as=0.24p ps=1.96u w=0.5u l=0.28u
X25 via_dev$5$7_9/VSUBS a_7410_63# a_8160_n37# via_dev$5$7_9/VSUBS nfet_03v3 ad=0.65p pd=3.3u as=0.3625p ps=1.725u w=1u l=0.28u
X26 a_8723_63# m2_7791_79# via_dev$5$7_9/VSUBS via_dev$5$7_9/VSUBS nfet_03v3 ad=0.2625p pd=2.05u as=0.265p ps=2.06u w=0.5u l=0.28u
X27 w_n310_281# a_4158_271# a_5243_407# w_n310_281# pfet_03v3 ad=0.725p pd=2.725u as=1.09p ps=5.09u w=2u l=0.28u
X28 a_5768_63# m2_5700_324# w_n310_281# w_n310_281# pfet_03v3 ad=0.65p pd=3.3u as=0.635p ps=3.27u w=1u l=0.28u
X29 a_9050_63# a_8918_357# w_n310_281# w_n310_281# pfet_03v3 ad=0.64p pd=3.28u as=0.48p ps=2.96u w=1u l=0.28u
X30 a_11922_391# a_11480_63# w_n310_281# w_n310_281# pfet_03v3 ad=0.725p pd=2.725u as=1.3p ps=5.3u w=2u l=0.28u
X31 a_160_63# m2_24_342# via_dev$5$7_9/VSUBS via_dev$5$7_9/VSUBS nfet_03v3 ad=0.315p pd=2.26u as=0.325p ps=2.3u w=0.5u l=0.28u
X32 a_9609_407# a_9050_63# w_n310_281# w_n310_281# pfet_03v3 ad=1.3p pd=5.3u as=0.725p ps=2.725u w=2u l=0.28u
X33 a_6128_n37# m2_5700_324# via_dev$5$7_9/VSUBS via_dev$5$7_9/VSUBS nfet_03v3 ad=0.3625p pd=1.725u as=0.54p ps=3.08u w=1u l=0.28u
X34 via_dev$5$7_9/VSUBS a_5768_63# a_6520_n37# via_dev$5$7_9/VSUBS nfet_03v3 ad=0.65p pd=3.3u as=0.3625p ps=1.725u w=1u l=0.28u
X35 a_7410_63# m2_5700_324# w_n310_281# w_n310_281# pfet_03v3 ad=0.64p pd=3.28u as=0.48p ps=2.96u w=1u l=0.28u
X36 m2_9431_79# a_8918_357# a_9609_407# w_n310_281# pfet_03v3 ad=0.725p pd=2.725u as=1.09p ps=5.09u w=2u l=0.28u
X37 a_11480_63# a_10906_466# via_dev$5$7_9/VSUBS via_dev$5$7_9/VSUBS nfet_03v3 ad=0.315p pd=2.26u as=0.2425p ps=1.97u w=0.5u l=0.28u
X38 a_1845_466# a_378_271# w_n310_281# w_n310_281# pfet_03v3 ad=0.42p pd=1.84u as=0.65p ps=3.3u w=1u l=0.28u
X39 a_8361_407# a_7410_63# w_n310_281# w_n310_281# pfet_03v3 ad=1.3p pd=5.3u as=0.725p ps=2.725u w=2u l=0.28u
X40 w_n310_281# m2_1295_79# a_10906_466# w_n310_281# pfet_03v3 ad=0.735p pd=2.47u as=0.42p ps=1.84u w=1u l=0.28u
X41 a_7083_63# m2_6151_79# via_dev$5$7_9/VSUBS via_dev$5$7_9/VSUBS nfet_03v3 ad=0.2625p pd=2.05u as=0.265p ps=2.06u w=0.5u l=0.28u
X42 a_510_63# a_378_271# w_n310_281# w_n310_281# pfet_03v3 ad=0.65p pd=3.3u as=0.56p ps=3.12u w=1u l=0.28u
X43 a_10363_63# m2_9431_79# w_n310_281# w_n310_281# pfet_03v3 ad=0.715p pd=3.43u as=0.53p ps=3.06u w=1u l=0.28u
X44 a_510_63# a_378_271# via_dev$5$7_9/VSUBS via_dev$5$7_9/VSUBS nfet_03v3 ad=0.315p pd=2.26u as=0.28p ps=2.12u w=0.5u l=0.28u
X45 a_1262_n37# a_160_63# m2_1295_79# via_dev$5$7_9/VSUBS nfet_03v3 ad=0.3625p pd=1.725u as=0.3375p ps=1.675u w=1u l=0.28u
X46 a_1845_n37# a_378_271# via_dev$5$7_9/VSUBS via_dev$5$7_9/VSUBS nfet_03v3 ad=0.42p pd=1.84u as=0.63p ps=3.26u w=1u l=0.28u
X47 m2_6151_79# m2_5700_324# a_6721_407# w_n310_281# pfet_03v3 ad=0.725p pd=2.725u as=1.09p ps=5.09u w=2u l=0.28u
X48 a_6721_407# a_5768_63# w_n310_281# w_n310_281# pfet_03v3 ad=1.3p pd=5.3u as=0.725p ps=2.725u w=2u l=0.28u
X49 a_10363_63# m2_9431_79# via_dev$5$7_9/VSUBS via_dev$5$7_9/VSUBS nfet_03v3 ad=0.3575p pd=2.43u as=0.265p ps=2.06u w=0.5u l=0.28u
X50 a_10906_466# m2_1295_79# a_10906_n37# via_dev$5$7_9/VSUBS nfet_03v3 ad=0.65p pd=3.3u as=0.42p ps=1.84u w=1u l=0.28u
X51 a_8723_63# m2_7791_79# w_n310_281# w_n310_281# pfet_03v3 ad=0.545p pd=3.09u as=0.53p ps=3.06u w=1u l=0.28u
X52 a_11480_63# a_10906_466# w_n310_281# w_n310_281# pfet_03v3 ad=0.65p pd=3.3u as=0.735p ps=2.47u w=1u l=0.28u
X53 a_12559_3# a_11922_3# via_dev$5$7_9/VSUBS via_dev$5$7_9/VSUBS nfet_03v3 ad=0.315p pd=2.26u as=0.325p ps=2.3u w=0.5u l=0.28u
X54 a_7083_63# m2_6151_79# w_n310_281# w_n310_281# pfet_03v3 ad=0.545p pd=3.09u as=0.53p ps=3.06u w=1u l=0.28u
X55 a_7768_n37# m2_5700_324# via_dev$5$7_9/VSUBS via_dev$5$7_9/VSUBS nfet_03v3 ad=0.3625p pd=1.725u as=0.54p ps=3.08u w=1u l=0.28u
X56 a_160_63# m2_24_342# w_n310_281# w_n310_281# pfet_03v3 ad=0.63p pd=3.26u as=0.65p ps=3.3u w=1u l=0.28u
X57 m2_1295_79# a_160_63# a_705_407# w_n310_281# pfet_03v3 ad=0.725p pd=2.725u as=0.675p ps=2.675u w=2u l=0.28u
X58 a_5042_n37# a_3940_63# a_5042_407# via_dev$5$7_9/VSUBS nfet_03v3 ad=0.3625p pd=1.725u as=0.3375p ps=1.675u w=1u l=0.28u
X59 m2_1295_79# m2_24_342# a_870_n37# via_dev$5$7_9/VSUBS nfet_03v3 ad=0.3375p pd=1.675u as=0.3625p ps=1.725u w=1u l=0.28u
X60 a_11922_3# a_2419_63# a_11922_391# w_n310_281# pfet_03v3 ad=1.3p pd=5.3u as=0.725p ps=2.725u w=2u l=0.28u
X61 a_9800_n37# a_7083_63# m2_9431_79# via_dev$5$7_9/VSUBS nfet_03v3 ad=0.3625p pd=1.725u as=0.3375p ps=1.675u w=1u l=0.28u
X62 m2_7791_79# m2_5700_324# a_8361_407# w_n310_281# pfet_03v3 ad=0.725p pd=2.725u as=1.09p ps=5.09u w=2u l=0.28u
X63 a_5042_407# a_3940_63# a_5243_407# w_n310_281# pfet_03v3 ad=0.725p pd=2.725u as=0.675p ps=2.675u w=2u l=0.28u
X64 a_3940_63# m2_1295_79# via_dev$5$7_9/VSUBS via_dev$5$7_9/VSUBS nfet_03v3 ad=0.315p pd=2.26u as=0.325p ps=2.3u w=0.5u l=0.28u
X65 a_8160_n37# a_3498_3# m2_7791_79# via_dev$5$7_9/VSUBS nfet_03v3 ad=0.3625p pd=1.725u as=0.3375p ps=1.675u w=1u l=0.28u
X66 a_705_407# m2_24_342# w_n310_281# w_n310_281# pfet_03v3 ad=0.675p pd=2.675u as=0.725p ps=2.725u w=2u l=0.28u
X67 a_5042_407# m2_1295_79# a_4650_n37# via_dev$5$7_9/VSUBS nfet_03v3 ad=0.3375p pd=1.675u as=0.3625p ps=1.725u w=1u l=0.28u
X68 a_6520_n37# a_5042_407# m2_6151_79# via_dev$5$7_9/VSUBS nfet_03v3 ad=0.3625p pd=1.725u as=0.3375p ps=1.675u w=1u l=0.28u
X69 w_n310_281# a_7083_63# a_9609_407# w_n310_281# pfet_03v3 ad=0.725p pd=2.725u as=0.675p ps=2.675u w=2u l=0.28u
X70 a_2419_63# a_1845_466# w_n310_281# w_n310_281# pfet_03v3 ad=0.65p pd=3.3u as=0.735p ps=2.47u w=1u l=0.28u
X71 m2_9431_79# a_8723_63# a_9408_n37# via_dev$5$7_9/VSUBS nfet_03v3 ad=0.3375p pd=1.675u as=0.3625p ps=1.725u w=1u l=0.28u
X72 w_n310_281# a_3498_3# a_8361_407# w_n310_281# pfet_03v3 ad=0.725p pd=2.725u as=0.675p ps=2.675u w=2u l=0.28u
X73 a_2861_391# m2_1295_79# w_n310_281# w_n310_281# pfet_03v3 ad=0.725p pd=2.725u as=1.3p ps=5.3u w=2u l=0.28u
X74 a_4290_63# a_4158_271# w_n310_281# w_n310_281# pfet_03v3 ad=0.65p pd=3.3u as=0.56p ps=3.12u w=1u l=0.28u
X75 a_5243_407# m2_1295_79# w_n310_281# w_n310_281# pfet_03v3 ad=0.675p pd=2.675u as=0.725p ps=2.725u w=2u l=0.28u
X76 w_n310_281# a_5042_407# a_6721_407# w_n310_281# pfet_03v3 ad=0.725p pd=2.725u as=0.675p ps=2.675u w=2u l=0.28u
X77 a_3498_3# a_2861_3# via_dev$5$7_9/VSUBS via_dev$5$7_9/VSUBS nfet_03v3 ad=0.315p pd=2.26u as=0.325p ps=2.3u w=0.5u l=0.28u
X78 a_9609_407# a_8723_63# m2_9431_79# w_n310_281# pfet_03v3 ad=0.675p pd=2.675u as=0.725p ps=2.725u w=2u l=0.28u
X79 via_dev$5$7_9/VSUBS a_4290_63# a_5042_n37# via_dev$5$7_9/VSUBS nfet_03v3 ad=0.65p pd=3.3u as=0.3625p ps=1.725u w=1u l=0.28u
X80 m2_6151_79# a_2419_63# a_6128_n37# via_dev$5$7_9/VSUBS nfet_03v3 ad=0.3375p pd=1.675u as=0.3625p ps=1.725u w=1u l=0.28u
X81 w_n310_281# m2_24_342# a_1845_466# w_n310_281# pfet_03v3 ad=0.735p pd=2.47u as=0.42p ps=1.84u w=1u l=0.28u
X82 a_870_n37# a_378_271# via_dev$5$7_9/VSUBS via_dev$5$7_9/VSUBS nfet_03v3 ad=0.3625p pd=1.725u as=0.54p ps=3.08u w=1u l=0.28u
X83 a_12559_3# a_11922_3# w_n310_281# w_n310_281# pfet_03v3 ad=0.65p pd=3.3u as=0.675p ps=3.35u w=1u l=0.28u
C0 a_1845_466# a_1845_n37# 0.01333f
C1 a_1845_n37# m2_1295_79# 0.00942f
C2 m2_6151_79# a_7410_63# 0
C3 a_8723_63# m2_9431_79# 0.13485f
C4 a_2861_3# a_1845_466# 0
C5 a_3940_63# a_5768_63# 0
C6 a_4290_63# a_5768_63# 0.01093f
C7 a_2861_3# m2_1295_79# 0.15381f
C8 a_3498_3# a_5768_63# 0
C9 a_5042_407# m2_1295_79# 0.03487f
C10 m2_6151_79# a_5042_n37# 0
C11 a_2861_3# a_3940_63# 0
C12 a_2419_63# a_8723_63# 0.00649f
C13 m2_9431_79# a_10906_466# 0.00167f
C14 a_510_63# a_1845_n37# 0.0011f
C15 a_6721_407# m2_1295_79# 0.00452f
C16 m2_5700_324# a_8723_63# 0
C17 a_2861_3# a_4290_63# 0
C18 a_2861_391# a_2861_3# 0.01616f
C19 a_8723_63# a_8918_357# 0.1249f
C20 a_9050_63# a_9800_n37# 0.01329f
C21 a_8160_n37# m2_9431_79# 0
C22 a_3940_63# a_5042_407# 0.0941f
C23 a_2861_3# a_3498_3# 0.09846f
C24 a_7083_63# a_9800_n37# 0.00527f
C25 a_4290_63# a_5042_407# 0.38112f
C26 a_2419_63# m2_9431_79# 0.00832f
C27 m2_6151_79# a_5768_63# 0.35511f
C28 a_4650_n37# a_4158_271# 0.00383f
C29 w_n310_281# a_8723_63# 0.33516f
C30 m2_7791_79# a_8723_63# 0.08381f
C31 a_10906_466# a_11922_3# 0
C32 a_2419_63# a_10906_466# 0.00833f
C33 a_378_271# a_1845_466# 0.01278f
C34 a_5042_407# a_3498_3# 0.02015f
C35 m2_9431_79# a_8918_357# 0.03217f
C36 a_1845_466# a_705_407# 0.0126f
C37 a_9800_n37# a_4158_271# 0.00497f
C38 a_378_271# m2_1295_79# 0.02669f
C39 a_6721_407# a_3498_3# 0
C40 a_705_407# m2_1295_79# 0.30816f
C41 m2_9431_79# a_7768_n37# 0
C42 w_n310_281# a_160_63# 0.30515f
C43 w_n310_281# m2_9431_79# 0.46253f
C44 a_9050_63# a_8723_63# 0.5277f
C45 a_2419_63# a_11922_3# 0.16984f
C46 m2_7791_79# m2_9431_79# 0.01571f
C47 a_2419_63# a_5243_407# 0
C48 a_7083_63# a_8723_63# 0.15796f
C49 a_2419_63# m2_5700_324# 0.074f
C50 m2_5700_324# a_5243_407# 0.01927f
C51 w_n310_281# a_10906_466# 0.44509f
C52 a_2419_63# a_8918_357# 0.01449f
C53 m2_6151_79# a_5042_407# 0.20459f
C54 m2_5700_324# a_8918_357# 0
C55 a_6520_n37# a_7083_63# 0.00272f
C56 a_12559_3# a_10906_466# 0
C57 a_8361_407# a_8723_63# 0.01268f
C58 a_9050_63# m2_9431_79# 0.328f
C59 a_2861_391# a_705_407# 0
C60 a_8160_n37# m2_7791_79# 0.01048f
C61 m2_6151_79# a_6721_407# 0.4935f
C62 a_7083_63# m2_9431_79# 0.19293f
C63 a_8723_63# a_4158_271# 0
C64 w_n310_281# a_11922_3# 0.46598f
C65 a_378_271# a_510_63# 0.14298f
C66 w_n310_281# a_2419_63# 0.75124f
C67 a_10363_63# a_8723_63# 0
C68 a_2419_63# m2_7791_79# 0.00843f
C69 w_n310_281# a_5243_407# 0.78984f
C70 a_510_63# a_705_407# 0.13828f
C71 w_n310_281# m2_5700_324# 1.65678f
C72 a_9609_407# a_8723_63# 0.0593f
C73 m2_5700_324# m2_7791_79# 0.05245f
C74 a_12559_3# a_11922_3# 0.0899f
C75 a_7083_63# a_10906_466# 0
C76 a_2419_63# a_12559_3# 0
C77 a_6520_n37# a_4158_271# 0.00406f
C78 w_n310_281# a_8918_357# 0.49453f
C79 m2_7791_79# a_8918_357# 0.02763f
C80 a_4650_n37# a_3940_63# 0.00441f
C81 a_8361_407# m2_9431_79# 0
C82 a_4650_n37# a_4290_63# 0.01502f
C83 a_4158_271# m2_9431_79# 0.05572f
C84 a_8160_n37# a_7083_63# 0.00507f
C85 a_2419_63# a_9050_63# 0.00801f
C86 a_10363_63# m2_9431_79# 0.07766f
C87 m2_7791_79# a_7768_n37# 0.01733f
C88 a_378_271# m2_24_342# 0.56715f
C89 a_9609_407# m2_9431_79# 0.49779f
C90 a_705_407# m2_24_342# 0.10607f
C91 a_2419_63# a_7083_63# 0.01345f
C92 w_n310_281# m2_7791_79# 0.45143f
C93 a_4158_271# a_10906_466# 0.03873f
C94 m2_5700_324# a_7083_63# 0.12051f
C95 a_10363_63# a_10906_466# 0.02047f
C96 a_9050_63# a_8918_357# 0.09973f
C97 a_9609_407# a_10906_466# 0
C98 w_n310_281# a_12559_3# 0.08598f
C99 a_7083_63# a_8918_357# 0.01057f
C100 a_2419_63# a_8361_407# 0
C101 a_1262_n37# a_1845_466# 0
C102 m2_1295_79# a_8723_63# 0.00796f
C103 m2_5700_324# a_8361_407# 0.05956f
C104 a_4158_271# a_11922_3# 0.0013f
C105 a_7083_63# a_7768_n37# 0.0028f
C106 a_2419_63# a_4158_271# 0.14782f
C107 w_n310_281# a_9050_63# 0.28931f
C108 m2_7791_79# a_9050_63# 0.00127f
C109 a_5243_407# a_4158_271# 0.02964f
C110 a_2419_63# a_10363_63# 0.00126f
C111 a_1262_n37# m2_1295_79# 0.01607f
C112 m2_5700_324# a_4158_271# 0.00861f
C113 a_1845_466# a_160_63# 0
C114 a_8361_407# a_8918_357# 0
C115 a_7410_63# a_5042_407# 0
C116 w_n310_281# a_7083_63# 0.31663f
C117 a_2419_63# a_9609_407# 0
C118 m2_7791_79# a_7083_63# 0.14708f
C119 a_4158_271# a_8918_357# 0.00101f
C120 a_160_63# m2_1295_79# 0.09339f
C121 a_10363_63# a_8918_357# 0
C122 a_8361_407# a_7768_n37# 0
C123 m2_1295_79# m2_9431_79# 0.0078f
C124 a_9609_407# a_8918_357# 0.02942f
C125 w_n310_281# a_8361_407# 0.75753f
C126 m2_7791_79# a_8361_407# 0.49779f
C127 m2_1295_79# a_10906_466# 0.0692f
C128 a_7083_63# a_9050_63# 0.21474f
C129 w_n310_281# a_4158_271# 0.66883f
C130 m2_7791_79# a_4158_271# 0
C131 w_n310_281# a_10363_63# 0.15741f
C132 a_5042_407# a_5042_n37# 0.01726f
C133 a_3498_3# a_8723_63# 0.00575f
C134 w_n310_281# a_9609_407# 0.7653f
C135 a_9609_407# m2_7791_79# 0
C136 a_870_n37# a_160_63# 0.00441f
C137 a_2419_63# a_1845_466# 0.10509f
C138 a_1262_n37# a_510_63# 0.00898f
C139 a_9050_63# a_8361_407# 0
C140 m2_1295_79# a_11922_3# 0
C141 a_2419_63# m2_1295_79# 0.3246f
C142 m2_1295_79# a_5243_407# 0.10989f
C143 a_7083_63# a_8361_407# 0.01453f
C144 a_9050_63# a_4158_271# 0.00717f
C145 m2_5700_324# m2_1295_79# 0.07849f
C146 a_10363_63# a_9050_63# 0.01385f
C147 a_510_63# a_160_63# 0.28903f
C148 a_3498_3# m2_9431_79# 0
C149 a_7083_63# a_4158_271# 1.09132f
C150 a_9609_407# a_9050_63# 0.1261f
C151 m2_1295_79# a_8918_357# 0.01371f
C152 a_5042_407# a_5768_63# 0.22596f
C153 a_10363_63# a_7083_63# 0.00582f
C154 a_9609_407# a_7083_63# 0.0285f
C155 w_n310_281# a_1845_466# 0.44517f
C156 a_6721_407# a_5768_63# 0.14017f
C157 a_2419_63# a_3940_63# 0.00879f
C158 a_3940_63# a_5243_407# 0.06737f
C159 m2_5700_324# a_3940_63# 0.00132f
C160 a_2419_63# a_4290_63# 0.00652f
C161 a_4290_63# a_5243_407# 0.14023f
C162 w_n310_281# m2_1295_79# 2.35223f
C163 m2_7791_79# m2_1295_79# 0.05731f
C164 a_160_63# m2_24_342# 0.42316f
C165 m2_5700_324# a_4290_63# 0.01531f
C166 a_2861_391# a_2419_63# 0.0163f
C167 a_9609_407# a_8361_407# 0.00466f
C168 a_6520_n37# m2_6151_79# 0.00766f
C169 a_10363_63# a_4158_271# 0.02222f
C170 a_9609_407# a_4158_271# 0
C171 a_2419_63# a_3498_3# 0.01177f
C172 a_3498_3# a_5243_407# 0.16427f
C173 a_2861_3# a_5042_407# 0
C174 a_10363_63# a_9609_407# 0.01306f
C175 m2_5700_324# a_3498_3# 0.55174f
C176 w_n310_281# a_3940_63# 0.30087f
C177 a_9050_63# m2_1295_79# 0.00716f
C178 a_11922_391# a_11922_3# 0.01891f
C179 w_n310_281# a_4290_63# 0.2819f
C180 a_2419_63# a_11922_391# 0.00754f
C181 a_7083_63# m2_1295_79# 0.01071f
C182 a_2861_391# w_n310_281# 0.03535f
C183 a_2419_63# m2_24_342# 0.00234f
C184 a_6721_407# a_5042_407# 0.03265f
C185 w_n310_281# a_3498_3# 1.03377f
C186 m2_7791_79# a_3498_3# 0.0296f
C187 m2_6151_79# a_6128_n37# 0.01733f
C188 w_n310_281# a_510_63# 0.28255f
C189 a_8361_407# m2_1295_79# 0.02509f
C190 a_2419_63# m2_6151_79# 0.05852f
C191 m2_6151_79# m2_5700_324# 0.14941f
C192 m2_1295_79# a_4158_271# 0.16058f
C193 a_10363_63# m2_1295_79# 0.00179f
C194 w_n310_281# a_11922_391# 0.03535f
C195 a_9609_407# m2_1295_79# 0.0093f
C196 a_2861_3# a_705_407# 0
C197 a_7410_63# a_8723_63# 0.01398f
C198 w_n310_281# m2_24_342# 0.66878f
C199 a_7083_63# a_3498_3# 0.01356f
C200 a_3940_63# a_4158_271# 0.16366f
C201 w_n310_281# m2_6151_79# 0.44301f
C202 m2_6151_79# m2_7791_79# 0.00114f
C203 a_4290_63# a_4158_271# 0.11363f
C204 m2_9431_79# a_11480_63# 0
C205 a_8361_407# a_3498_3# 0.12093f
C206 a_7410_63# m2_9431_79# 0.00105f
C207 a_10906_466# a_11480_63# 0.1131f
C208 a_3498_3# a_4158_271# 0.00829f
C209 a_1845_466# m2_1295_79# 0.09644f
C210 m2_6151_79# a_7083_63# 0.08089f
C211 a_11480_63# a_11922_3# 0.04054f
C212 a_4650_n37# a_5042_407# 0.00712f
C213 a_8160_n37# a_7410_63# 0.01329f
C214 a_2419_63# a_11480_63# 0.0769f
C215 a_1845_466# a_3940_63# 0
C216 a_2419_63# a_7410_63# 0.00801f
C217 a_1845_466# a_870_n37# 0
C218 m2_5700_324# a_7410_63# 0.14432f
C219 a_3940_63# m2_1295_79# 0.46061f
C220 a_378_271# a_705_407# 0.02817f
C221 a_870_n37# m2_1295_79# 0.00639f
C222 m2_6151_79# a_4158_271# 0.04334f
C223 a_4290_63# m2_1295_79# 0.13519f
C224 a_7410_63# a_8918_357# 0
C225 a_10906_n37# a_10906_466# 0.01333f
C226 a_6520_n37# a_5768_63# 0.01329f
C227 a_1845_466# a_3498_3# 0.00105f
C228 a_2861_391# m2_1295_79# 0.00841f
C229 a_1845_466# a_510_63# 0.01433f
C230 a_7410_63# a_7768_n37# 0.00935f
C231 m2_1295_79# a_3498_3# 0.3391f
C232 w_n310_281# a_11480_63# 0.37298f
C233 a_510_63# m2_1295_79# 0.39896f
C234 a_5243_407# a_5042_n37# 0
C235 w_n310_281# a_7410_63# 0.31086f
C236 m2_7791_79# a_7410_63# 0.36168f
C237 a_3940_63# a_4290_63# 0.28903f
C238 a_1845_466# m2_24_342# 0.06999f
C239 a_3940_63# a_3498_3# 0.04602f
C240 a_9408_n37# m2_9431_79# 0.01733f
C241 m2_24_342# m2_1295_79# 0.04399f
C242 a_6128_n37# a_5768_63# 0.00935f
C243 a_4290_63# a_3498_3# 0.00876f
C244 a_870_n37# a_510_63# 0.01502f
C245 a_2419_63# a_5768_63# 0.07749f
C246 a_2861_391# a_3498_3# 0.00454f
C247 a_5243_407# a_5768_63# 0.00722f
C248 m2_6151_79# m2_1295_79# 0.00667f
C249 a_7083_63# a_7410_63# 0.07718f
C250 m2_5700_324# a_5768_63# 0.16447f
C251 a_6520_n37# a_5042_407# 0.00483f
C252 w_n310_281# a_10906_n37# 0
C253 a_7410_63# a_8361_407# 0.1423f
C254 a_4158_271# a_11480_63# 0.00295f
C255 a_10363_63# a_11480_63# 0
C256 a_7410_63# a_4158_271# 0
C257 a_9609_407# a_11480_63# 0
C258 a_2861_3# a_2419_63# 0.21478f
C259 w_n310_281# a_5768_63# 0.31314f
C260 m2_7791_79# a_5768_63# 0
C261 m2_6151_79# a_4290_63# 0
C262 a_2861_3# a_5243_407# 0
C263 m2_24_342# a_3498_3# 0
C264 a_510_63# m2_24_342# 0.13025f
C265 a_6128_n37# a_5042_407# 0.00376f
C266 w_n310_281# a_1845_n37# 0
C267 m2_6151_79# a_3498_3# 0
C268 a_2419_63# a_5042_407# 0.08051f
C269 a_5042_407# a_5243_407# 0.29512f
C270 a_1262_n37# a_705_407# 0
C271 a_6128_n37# a_6721_407# 0
C272 m2_5700_324# a_5042_407# 0.06917f
C273 a_4158_271# a_5042_n37# 0
C274 m2_7791_79# a_9408_n37# 0
C275 a_2419_63# a_6721_407# 0.01825f
C276 a_378_271# a_160_63# 0.09182f
C277 a_7083_63# a_5768_63# 0.01494f
C278 w_n310_281# a_2861_3# 0.4655f
C279 m2_5700_324# a_6721_407# 0.50857f
C280 a_160_63# a_705_407# 0.06737f
C281 a_10906_n37# a_4158_271# 0.00824f
C282 a_10363_63# a_10906_n37# 0
C283 m2_1295_79# a_11480_63# 0.00126f
C284 a_7410_63# m2_1295_79# 0.07614f
C285 w_n310_281# a_5042_407# 0.29911f
C286 a_9050_63# a_9408_n37# 0.00935f
C287 m2_7791_79# a_5042_407# 0.00555f
C288 a_4158_271# a_5768_63# 0.00573f
C289 a_7083_63# a_9408_n37# 0.00336f
C290 w_n310_281# a_6721_407# 0.72579f
C291 a_2419_63# a_705_407# 0
C292 a_7083_63# a_5042_407# 0.02611f
C293 a_9800_n37# m2_9431_79# 0.0074f
C294 a_9609_407# a_9408_n37# 0
C295 a_7083_63# a_6721_407# 0.01268f
C296 a_7410_63# a_3498_3# 0.11774f
C297 w_n310_281# a_378_271# 0.63374f
C298 w_n310_281# a_705_407# 0.79414f
C299 a_11922_391# a_11480_63# 0.00152f
C300 a_5042_407# a_4158_271# 0.63867f
C301 a_4290_63# a_5042_n37# 0.00898f
C302 m2_1295_79# a_5768_63# 0.00766f
C303 a_4158_271# via_dev$5$7_9/VSUBS 2.6385f
C304 a_7083_63# via_dev$5$7_9/VSUBS 0.86585f
C305 a_8723_63# via_dev$5$7_9/VSUBS 0.40969f
C306 m2_9431_79# via_dev$5$7_9/VSUBS 0.75255f
C307 m2_7791_79# via_dev$5$7_9/VSUBS 0.74612f
C308 a_8361_407# via_dev$5$7_9/VSUBS 0.05216f
C309 m2_6151_79# via_dev$5$7_9/VSUBS 0.72815f
C310 a_6721_407# via_dev$5$7_9/VSUBS 0.01698f
C311 a_5042_407# via_dev$5$7_9/VSUBS 0.88916f
C312 a_3940_63# via_dev$5$7_9/VSUBS 0.46864f
C313 m2_1295_79# via_dev$5$7_9/VSUBS 3.34416f
C314 a_160_63# via_dev$5$7_9/VSUBS 0.5921f
C315 a_5243_407# via_dev$5$7_9/VSUBS 0.01661f
C316 a_705_407# via_dev$5$7_9/VSUBS 0.13677f
C317 a_3498_3# via_dev$5$7_9/VSUBS 1.27724f
C318 a_10906_n37# via_dev$5$7_9/VSUBS 0.02232f
C319 a_9800_n37# via_dev$5$7_9/VSUBS 0.01742f
C320 a_9408_n37# via_dev$5$7_9/VSUBS 0.007f
C321 a_8160_n37# via_dev$5$7_9/VSUBS 0.01743f
C322 a_7768_n37# via_dev$5$7_9/VSUBS 0.007f
C323 a_6520_n37# via_dev$5$7_9/VSUBS 0.01743f
C324 a_6128_n37# via_dev$5$7_9/VSUBS 0.007f
C325 a_5042_n37# via_dev$5$7_9/VSUBS 0.00833f
C326 a_4650_n37# via_dev$5$7_9/VSUBS 0.01565f
C327 a_12559_3# via_dev$5$7_9/VSUBS 0.19481f
C328 a_11922_3# via_dev$5$7_9/VSUBS 0.64569f
C329 a_11922_391# via_dev$5$7_9/VSUBS 0.00119f
C330 a_10906_466# via_dev$5$7_9/VSUBS 0.59796f
C331 a_11480_63# via_dev$5$7_9/VSUBS 0.42359f
C332 a_10363_63# via_dev$5$7_9/VSUBS 0.13924f
C333 a_9050_63# via_dev$5$7_9/VSUBS 0.53264f
C334 a_8918_357# via_dev$5$7_9/VSUBS 0.52045f
C335 a_7410_63# via_dev$5$7_9/VSUBS 0.53731f
C336 a_5768_63# via_dev$5$7_9/VSUBS 0.54f
C337 a_1845_n37# via_dev$5$7_9/VSUBS 0.01974f
C338 a_1262_n37# via_dev$5$7_9/VSUBS 0.0069f
C339 a_870_n37# via_dev$5$7_9/VSUBS 0.01517f
C340 a_4290_63# via_dev$5$7_9/VSUBS 0.57048f
C341 a_2861_3# via_dev$5$7_9/VSUBS 0.62907f
C342 a_1845_466# via_dev$5$7_9/VSUBS 0.59853f
C343 a_2419_63# via_dev$5$7_9/VSUBS 6.64114f
C344 a_510_63# via_dev$5$7_9/VSUBS 0.55998f
C345 a_378_271# via_dev$5$7_9/VSUBS 1.37769f
C346 w_n310_281# via_dev$5$7_9/VSUBS 27.06926f
C347 m2_5700_324# via_dev$5$7_9/VSUBS 1.14834f
C348 m2_24_342# via_dev$5$7_9/VSUBS 1.98211f
C349 a_9609_407# via_dev$5$7_9/VSUBS 0.11967f
.ends

.subckt x1bitblock$1$4 a_2861_3# a_8361_407# a_6520_n37# a_1262_n37# a_2861_391# a_1845_466#
+ a_10906_n37# a_510_63# a_870_n37# a_6721_407# a_9800_n37# a_11480_63# a_6128_n37#
+ a_5768_63# m2_6151_79# a_3498_3# a_11922_391# a_5042_n37# a_9408_n37# a_9609_407#
+ a_5042_407# a_8160_n37# a_4158_271# a_11922_3# a_2419_63# m2_9431_79# a_10906_466#
+ a_4650_n37# a_9050_63# a_5243_407# a_7768_n37# a_160_63# a_3940_63# a_8919_370#
+ m2_7791_79# a_10363_63# a_4290_63# a_7083_63# a_705_407# a_12559_3# a_7410_63# m2_5700_324#
+ a_1845_n37# via_dev$5$1$4_9/VSUBS m2_24_342# m2_1295_79# a_8723_63# a_378_271# w_n310_281#
X0 a_2419_63# a_1845_466# via_dev$5$1$4_9/VSUBS via_dev$5$1$4_9/VSUBS nfet_03v3 ad=0.315p pd=2.26u as=0.2425p ps=1.97u w=0.5u l=0.28u
X1 a_1845_466# m2_24_342# a_1845_n37# via_dev$5$1$4_9/VSUBS nfet_03v3 ad=0.65p pd=3.3u as=0.42p ps=1.84u w=1u l=0.28u
X2 a_3940_63# m2_1295_79# w_n310_281# w_n310_281# pfet_03v3 ad=0.63p pd=3.26u as=0.65p ps=3.3u w=1u l=0.28u
X3 via_dev$5$1$4_9/VSUBS a_510_63# a_1262_n37# via_dev$5$1$4_9/VSUBS nfet_03v3 ad=0.65p pd=3.3u as=0.3625p ps=1.725u w=1u l=0.28u
X4 a_5243_407# a_4290_63# a_5042_407# w_n310_281# pfet_03v3 ad=1.3p pd=5.3u as=0.725p ps=2.725u w=2u l=0.28u
X5 a_6721_407# a_2419_63# m2_6151_79# w_n310_281# pfet_03v3 ad=0.675p pd=2.675u as=0.725p ps=2.725u w=2u l=0.28u
X6 a_10906_466# a_4158_271# w_n310_281# w_n310_281# pfet_03v3 ad=0.42p pd=1.84u as=0.65p ps=3.3u w=1u l=0.28u
X7 a_4290_63# a_4158_271# via_dev$5$1$4_9/VSUBS via_dev$5$1$4_9/VSUBS nfet_03v3 ad=0.315p pd=2.26u as=0.28p ps=2.12u w=0.5u l=0.28u
X8 w_n310_281# a_378_271# a_705_407# w_n310_281# pfet_03v3 ad=0.725p pd=2.725u as=1.09p ps=5.09u w=2u l=0.28u
X9 a_2861_3# m2_1295_79# via_dev$5$1$4_9/VSUBS via_dev$5$1$4_9/VSUBS nfet_03v3 ad=0.18125p pd=1.225u as=0.325p ps=2.3u w=0.5u l=0.28u
X10 via_dev$5$1$4_9/VSUBS a_2419_63# a_2861_3# via_dev$5$1$4_9/VSUBS nfet_03v3 ad=0.315p pd=2.26u as=0.18125p ps=1.225u w=0.5u l=0.28u
X11 m2_7791_79# m2_1295_79# a_7768_n37# via_dev$5$1$4_9/VSUBS nfet_03v3 ad=0.3375p pd=1.675u as=0.3625p ps=1.725u w=1u l=0.28u
X12 a_10906_n37# a_4158_271# via_dev$5$1$4_9/VSUBS via_dev$5$1$4_9/VSUBS nfet_03v3 ad=0.42p pd=1.84u as=0.63p ps=3.26u w=1u l=0.28u
X13 a_9050_63# a_8919_370# via_dev$5$1$4_9/VSUBS via_dev$5$1$4_9/VSUBS nfet_03v3 ad=0.31p pd=2.24u as=0.24p ps=1.96u w=0.5u l=0.28u
X14 a_11922_3# a_11480_63# via_dev$5$1$4_9/VSUBS via_dev$5$1$4_9/VSUBS nfet_03v3 ad=0.18125p pd=1.225u as=0.325p ps=2.3u w=0.5u l=0.28u
X15 via_dev$5$1$4_9/VSUBS a_2419_63# a_11922_3# via_dev$5$1$4_9/VSUBS nfet_03v3 ad=0.315p pd=2.26u as=0.18125p ps=1.225u w=0.5u l=0.28u
X16 a_705_407# a_510_63# m2_1295_79# w_n310_281# pfet_03v3 ad=1.3p pd=5.3u as=0.725p ps=2.725u w=2u l=0.28u
X17 a_4650_n37# a_4158_271# via_dev$5$1$4_9/VSUBS via_dev$5$1$4_9/VSUBS nfet_03v3 ad=0.3625p pd=1.725u as=0.54p ps=3.08u w=1u l=0.28u
X18 a_2861_3# a_2419_63# a_2861_391# w_n310_281# pfet_03v3 ad=1.3p pd=5.3u as=0.725p ps=2.725u w=2u l=0.28u
X19 a_5768_63# m2_5700_324# via_dev$5$1$4_9/VSUBS via_dev$5$1$4_9/VSUBS nfet_03v3 ad=0.315p pd=2.26u as=0.3175p ps=2.27u w=0.5u l=0.28u
X20 via_dev$5$1$4_9/VSUBS a_9050_63# a_9800_n37# via_dev$5$1$4_9/VSUBS nfet_03v3 ad=0.65p pd=3.3u as=0.3625p ps=1.725u w=1u l=0.28u
X21 a_8361_407# m2_1295_79# m2_7791_79# w_n310_281# pfet_03v3 ad=0.675p pd=2.675u as=0.725p ps=2.725u w=2u l=0.28u
X22 a_9408_n37# a_8919_370# via_dev$5$1$4_9/VSUBS via_dev$5$1$4_9/VSUBS nfet_03v3 ad=0.3625p pd=1.725u as=0.54p ps=3.08u w=1u l=0.28u
X23 a_3498_3# a_2861_3# w_n310_281# w_n310_281# pfet_03v3 ad=0.65p pd=3.3u as=0.675p ps=3.35u w=1u l=0.28u
X24 a_7410_63# m2_5700_324# via_dev$5$1$4_9/VSUBS via_dev$5$1$4_9/VSUBS nfet_03v3 ad=0.31p pd=2.24u as=0.24p ps=1.96u w=0.5u l=0.28u
X25 via_dev$5$1$4_9/VSUBS a_7410_63# a_8160_n37# via_dev$5$1$4_9/VSUBS nfet_03v3 ad=0.65p pd=3.3u as=0.3625p ps=1.725u w=1u l=0.28u
X26 a_8723_63# m2_7791_79# via_dev$5$1$4_9/VSUBS via_dev$5$1$4_9/VSUBS nfet_03v3 ad=0.2625p pd=2.05u as=0.265p ps=2.06u w=0.5u l=0.28u
X27 w_n310_281# a_4158_271# a_5243_407# w_n310_281# pfet_03v3 ad=0.725p pd=2.725u as=1.09p ps=5.09u w=2u l=0.28u
X28 a_5768_63# m2_5700_324# w_n310_281# w_n310_281# pfet_03v3 ad=0.65p pd=3.3u as=0.635p ps=3.27u w=1u l=0.28u
X29 a_9050_63# a_8919_370# w_n310_281# w_n310_281# pfet_03v3 ad=0.64p pd=3.28u as=0.48p ps=2.96u w=1u l=0.28u
X30 a_11922_391# a_11480_63# w_n310_281# w_n310_281# pfet_03v3 ad=0.725p pd=2.725u as=1.3p ps=5.3u w=2u l=0.28u
X31 a_160_63# m2_24_342# via_dev$5$1$4_9/VSUBS via_dev$5$1$4_9/VSUBS nfet_03v3 ad=0.315p pd=2.26u as=0.325p ps=2.3u w=0.5u l=0.28u
X32 a_9609_407# a_9050_63# w_n310_281# w_n310_281# pfet_03v3 ad=1.3p pd=5.3u as=0.725p ps=2.725u w=2u l=0.28u
X33 a_6128_n37# m2_5700_324# via_dev$5$1$4_9/VSUBS via_dev$5$1$4_9/VSUBS nfet_03v3 ad=0.3625p pd=1.725u as=0.54p ps=3.08u w=1u l=0.28u
X34 via_dev$5$1$4_9/VSUBS a_5768_63# a_6520_n37# via_dev$5$1$4_9/VSUBS nfet_03v3 ad=0.65p pd=3.3u as=0.3625p ps=1.725u w=1u l=0.28u
X35 a_7410_63# m2_5700_324# w_n310_281# w_n310_281# pfet_03v3 ad=0.64p pd=3.28u as=0.48p ps=2.96u w=1u l=0.28u
X36 m2_9431_79# a_8919_370# a_9609_407# w_n310_281# pfet_03v3 ad=0.725p pd=2.725u as=1.09p ps=5.09u w=2u l=0.28u
X37 a_11480_63# a_10906_466# via_dev$5$1$4_9/VSUBS via_dev$5$1$4_9/VSUBS nfet_03v3 ad=0.315p pd=2.26u as=0.2425p ps=1.97u w=0.5u l=0.28u
X38 a_1845_466# a_378_271# w_n310_281# w_n310_281# pfet_03v3 ad=0.42p pd=1.84u as=0.65p ps=3.3u w=1u l=0.28u
X39 a_8361_407# a_7410_63# w_n310_281# w_n310_281# pfet_03v3 ad=1.3p pd=5.3u as=0.725p ps=2.725u w=2u l=0.28u
X40 w_n310_281# m2_1295_79# a_10906_466# w_n310_281# pfet_03v3 ad=0.735p pd=2.47u as=0.42p ps=1.84u w=1u l=0.28u
X41 a_7083_63# m2_6151_79# via_dev$5$1$4_9/VSUBS via_dev$5$1$4_9/VSUBS nfet_03v3 ad=0.2625p pd=2.05u as=0.265p ps=2.06u w=0.5u l=0.28u
X42 a_510_63# a_378_271# w_n310_281# w_n310_281# pfet_03v3 ad=0.65p pd=3.3u as=0.56p ps=3.12u w=1u l=0.28u
X43 a_10363_63# m2_9431_79# w_n310_281# w_n310_281# pfet_03v3 ad=0.715p pd=3.43u as=0.53p ps=3.06u w=1u l=0.28u
X44 a_510_63# a_378_271# via_dev$5$1$4_9/VSUBS via_dev$5$1$4_9/VSUBS nfet_03v3 ad=0.315p pd=2.26u as=0.28p ps=2.12u w=0.5u l=0.28u
X45 a_1262_n37# a_160_63# m2_1295_79# via_dev$5$1$4_9/VSUBS nfet_03v3 ad=0.3625p pd=1.725u as=0.3375p ps=1.675u w=1u l=0.28u
X46 a_1845_n37# a_378_271# via_dev$5$1$4_9/VSUBS via_dev$5$1$4_9/VSUBS nfet_03v3 ad=0.42p pd=1.84u as=0.63p ps=3.26u w=1u l=0.28u
X47 m2_6151_79# m2_5700_324# a_6721_407# w_n310_281# pfet_03v3 ad=0.725p pd=2.725u as=1.09p ps=5.09u w=2u l=0.28u
X48 a_6721_407# a_5768_63# w_n310_281# w_n310_281# pfet_03v3 ad=1.3p pd=5.3u as=0.725p ps=2.725u w=2u l=0.28u
X49 a_10363_63# m2_9431_79# via_dev$5$1$4_9/VSUBS via_dev$5$1$4_9/VSUBS nfet_03v3 ad=0.3575p pd=2.43u as=0.265p ps=2.06u w=0.5u l=0.28u
X50 a_10906_466# m2_1295_79# a_10906_n37# via_dev$5$1$4_9/VSUBS nfet_03v3 ad=0.65p pd=3.3u as=0.42p ps=1.84u w=1u l=0.28u
X51 a_8723_63# m2_7791_79# w_n310_281# w_n310_281# pfet_03v3 ad=0.545p pd=3.09u as=0.53p ps=3.06u w=1u l=0.28u
X52 a_11480_63# a_10906_466# w_n310_281# w_n310_281# pfet_03v3 ad=0.65p pd=3.3u as=0.735p ps=2.47u w=1u l=0.28u
X53 a_12559_3# a_11922_3# via_dev$5$1$4_9/VSUBS via_dev$5$1$4_9/VSUBS nfet_03v3 ad=0.315p pd=2.26u as=0.325p ps=2.3u w=0.5u l=0.28u
X54 a_7083_63# m2_6151_79# w_n310_281# w_n310_281# pfet_03v3 ad=0.545p pd=3.09u as=0.53p ps=3.06u w=1u l=0.28u
X55 a_7768_n37# m2_5700_324# via_dev$5$1$4_9/VSUBS via_dev$5$1$4_9/VSUBS nfet_03v3 ad=0.3625p pd=1.725u as=0.54p ps=3.08u w=1u l=0.28u
X56 a_160_63# m2_24_342# w_n310_281# w_n310_281# pfet_03v3 ad=0.63p pd=3.26u as=0.65p ps=3.3u w=1u l=0.28u
X57 m2_1295_79# a_160_63# a_705_407# w_n310_281# pfet_03v3 ad=0.725p pd=2.725u as=0.675p ps=2.675u w=2u l=0.28u
X58 a_5042_n37# a_3940_63# a_5042_407# via_dev$5$1$4_9/VSUBS nfet_03v3 ad=0.3625p pd=1.725u as=0.3375p ps=1.675u w=1u l=0.28u
X59 m2_1295_79# m2_24_342# a_870_n37# via_dev$5$1$4_9/VSUBS nfet_03v3 ad=0.3375p pd=1.675u as=0.3625p ps=1.725u w=1u l=0.28u
X60 a_11922_3# a_2419_63# a_11922_391# w_n310_281# pfet_03v3 ad=1.3p pd=5.3u as=0.725p ps=2.725u w=2u l=0.28u
X61 a_9800_n37# a_7083_63# m2_9431_79# via_dev$5$1$4_9/VSUBS nfet_03v3 ad=0.3625p pd=1.725u as=0.3375p ps=1.675u w=1u l=0.28u
X62 m2_7791_79# m2_5700_324# a_8361_407# w_n310_281# pfet_03v3 ad=0.725p pd=2.725u as=1.09p ps=5.09u w=2u l=0.28u
X63 a_5042_407# a_3940_63# a_5243_407# w_n310_281# pfet_03v3 ad=0.725p pd=2.725u as=0.675p ps=2.675u w=2u l=0.28u
X64 a_3940_63# m2_1295_79# via_dev$5$1$4_9/VSUBS via_dev$5$1$4_9/VSUBS nfet_03v3 ad=0.315p pd=2.26u as=0.325p ps=2.3u w=0.5u l=0.28u
X65 a_8160_n37# a_3498_3# m2_7791_79# via_dev$5$1$4_9/VSUBS nfet_03v3 ad=0.3625p pd=1.725u as=0.3375p ps=1.675u w=1u l=0.28u
X66 a_705_407# m2_24_342# w_n310_281# w_n310_281# pfet_03v3 ad=0.675p pd=2.675u as=0.725p ps=2.725u w=2u l=0.28u
X67 a_5042_407# m2_1295_79# a_4650_n37# via_dev$5$1$4_9/VSUBS nfet_03v3 ad=0.3375p pd=1.675u as=0.3625p ps=1.725u w=1u l=0.28u
X68 a_6520_n37# a_5042_407# m2_6151_79# via_dev$5$1$4_9/VSUBS nfet_03v3 ad=0.3625p pd=1.725u as=0.3375p ps=1.675u w=1u l=0.28u
X69 w_n310_281# a_7083_63# a_9609_407# w_n310_281# pfet_03v3 ad=0.725p pd=2.725u as=0.675p ps=2.675u w=2u l=0.28u
X70 a_2419_63# a_1845_466# w_n310_281# w_n310_281# pfet_03v3 ad=0.65p pd=3.3u as=0.735p ps=2.47u w=1u l=0.28u
X71 m2_9431_79# a_8723_63# a_9408_n37# via_dev$5$1$4_9/VSUBS nfet_03v3 ad=0.3375p pd=1.675u as=0.3625p ps=1.725u w=1u l=0.28u
X72 w_n310_281# a_3498_3# a_8361_407# w_n310_281# pfet_03v3 ad=0.725p pd=2.725u as=0.675p ps=2.675u w=2u l=0.28u
X73 a_2861_391# m2_1295_79# w_n310_281# w_n310_281# pfet_03v3 ad=0.725p pd=2.725u as=1.3p ps=5.3u w=2u l=0.28u
X74 a_4290_63# a_4158_271# w_n310_281# w_n310_281# pfet_03v3 ad=0.65p pd=3.3u as=0.56p ps=3.12u w=1u l=0.28u
X75 a_5243_407# m2_1295_79# w_n310_281# w_n310_281# pfet_03v3 ad=0.675p pd=2.675u as=0.725p ps=2.725u w=2u l=0.28u
X76 w_n310_281# a_5042_407# a_6721_407# w_n310_281# pfet_03v3 ad=0.725p pd=2.725u as=0.675p ps=2.675u w=2u l=0.28u
X77 a_3498_3# a_2861_3# via_dev$5$1$4_9/VSUBS via_dev$5$1$4_9/VSUBS nfet_03v3 ad=0.315p pd=2.26u as=0.325p ps=2.3u w=0.5u l=0.28u
X78 a_9609_407# a_8723_63# m2_9431_79# w_n310_281# pfet_03v3 ad=0.675p pd=2.675u as=0.725p ps=2.725u w=2u l=0.28u
X79 via_dev$5$1$4_9/VSUBS a_4290_63# a_5042_n37# via_dev$5$1$4_9/VSUBS nfet_03v3 ad=0.65p pd=3.3u as=0.3625p ps=1.725u w=1u l=0.28u
X80 m2_6151_79# a_2419_63# a_6128_n37# via_dev$5$1$4_9/VSUBS nfet_03v3 ad=0.3375p pd=1.675u as=0.3625p ps=1.725u w=1u l=0.28u
X81 w_n310_281# m2_24_342# a_1845_466# w_n310_281# pfet_03v3 ad=0.735p pd=2.47u as=0.42p ps=1.84u w=1u l=0.28u
X82 a_870_n37# a_378_271# via_dev$5$1$4_9/VSUBS via_dev$5$1$4_9/VSUBS nfet_03v3 ad=0.3625p pd=1.725u as=0.54p ps=3.08u w=1u l=0.28u
X83 a_12559_3# a_11922_3# w_n310_281# w_n310_281# pfet_03v3 ad=0.65p pd=3.3u as=0.675p ps=3.35u w=1u l=0.28u
C0 m2_5700_324# a_3498_3# 0.55174f
C1 a_11480_63# a_9609_407# 0
C2 m2_6151_79# a_6128_n37# 0.01733f
C3 a_2419_63# a_11922_391# 0.00754f
C4 a_7083_63# a_4158_271# 1.09133f
C5 m2_5700_324# m2_1295_79# 0.07849f
C6 a_2419_63# m2_9431_79# 0.00832f
C7 w_n310_281# a_160_63# 0.30515f
C8 m2_7791_79# a_8361_407# 0.49779f
C9 a_1845_466# a_1262_n37# 0
C10 m2_5700_324# m2_6151_79# 0.14941f
C11 a_1845_466# a_160_63# 0
C12 a_5042_407# a_6721_407# 0.03265f
C13 a_2419_63# a_4158_271# 0.14782f
C14 a_6721_407# a_5768_63# 0.14017f
C15 m2_5700_324# a_5243_407# 0.01927f
C16 a_378_271# w_n310_281# 0.6337f
C17 a_5042_n37# a_5042_407# 0.01726f
C18 a_705_407# a_2419_63# 0
C19 a_6721_407# a_3498_3# 0
C20 a_11922_3# a_10906_466# 0
C21 m2_1295_79# a_6721_407# 0.00452f
C22 a_378_271# a_1845_466# 0.01278f
C23 a_7083_63# a_8723_63# 0.15796f
C24 a_7410_63# a_8919_370# 0
C25 a_7083_63# a_9800_n37# 0.00527f
C26 m2_7791_79# a_9408_n37# 0
C27 a_3940_63# a_2861_3# 0
C28 m2_6151_79# a_6721_407# 0.4935f
C29 a_510_63# a_870_n37# 0.01502f
C30 w_n310_281# a_7083_63# 0.31663f
C31 a_8361_407# a_9609_407# 0.00466f
C32 m2_7791_79# a_9609_407# 0
C33 a_2419_63# a_8723_63# 0.00661f
C34 m2_1295_79# a_1262_n37# 0.01607f
C35 a_4290_63# a_4650_n37# 0.01502f
C36 a_5042_n37# m2_6151_79# 0
C37 m2_1295_79# a_160_63# 0.09339f
C38 a_8919_370# m2_9431_79# 0.03216f
C39 w_n310_281# a_2419_63# 0.75141f
C40 a_5042_n37# a_5243_407# 0
C41 a_705_407# m2_24_342# 0.10607f
C42 w_n310_281# a_12559_3# 0.08598f
C43 a_4158_271# a_8919_370# 0.001f
C44 a_7083_63# a_9050_63# 0.21474f
C45 m2_5700_324# a_8361_407# 0.05956f
C46 m2_5700_324# m2_7791_79# 0.05245f
C47 a_1845_466# a_2419_63# 0.10509f
C48 a_7083_63# a_10363_63# 0.00582f
C49 a_378_271# m2_1295_79# 0.02669f
C50 a_10906_466# m2_9431_79# 0.00167f
C51 a_5042_407# a_7083_63# 0.02611f
C52 a_9408_n37# a_9609_407# 0
C53 a_2861_391# a_2419_63# 0.0163f
C54 a_7083_63# a_5768_63# 0.01494f
C55 a_2419_63# a_9050_63# 0.00801f
C56 a_11922_3# a_11922_391# 0.01891f
C57 a_2419_63# a_10363_63# 0.00126f
C58 m2_5700_324# a_4290_63# 0.01531f
C59 a_7083_63# a_3498_3# 0.01356f
C60 a_4158_271# a_10906_466# 0.03873f
C61 a_5042_407# a_2419_63# 0.08051f
C62 m2_1295_79# a_7083_63# 0.01071f
C63 a_6520_n37# a_7083_63# 0.00272f
C64 a_2419_63# a_5768_63# 0.07749f
C65 w_n310_281# m2_24_342# 0.66878f
C66 a_8919_370# a_8723_63# 0.12581f
C67 a_11922_3# a_4158_271# 0.0013f
C68 a_2419_63# a_3498_3# 0.01177f
C69 a_3940_63# a_4158_271# 0.16366f
C70 a_7410_63# a_8160_n37# 0.01329f
C71 m2_6151_79# a_7083_63# 0.08089f
C72 a_160_63# a_870_n37# 0.00441f
C73 m2_24_342# a_1845_466# 0.06999f
C74 a_705_407# a_2861_3# 0
C75 m2_1295_79# a_2419_63# 0.32461f
C76 w_n310_281# a_8919_370# 0.50001f
C77 a_7410_63# m2_9431_79# 0.00105f
C78 m2_6151_79# a_2419_63# 0.05852f
C79 m2_9431_79# a_8160_n37# 0
C80 a_11480_63# a_2419_63# 0.0769f
C81 a_5042_n37# a_4290_63# 0.00898f
C82 a_5243_407# a_2419_63# 0
C83 a_7410_63# a_4158_271# 0
C84 w_n310_281# a_10906_466# 0.44509f
C85 a_8919_370# a_9050_63# 0.10006f
C86 a_10363_63# a_8919_370# 0
C87 m2_24_342# a_3498_3# 0
C88 w_n310_281# a_11922_3# 0.46598f
C89 w_n310_281# a_2861_3# 0.4655f
C90 w_n310_281# a_3940_63# 0.30087f
C91 a_6721_407# a_6128_n37# 0
C92 a_7768_n37# a_8361_407# 0
C93 m2_1295_79# m2_24_342# 0.04399f
C94 m2_7791_79# a_7768_n37# 0.01733f
C95 a_4158_271# m2_9431_79# 0.05572f
C96 a_1845_466# a_2861_3# 0
C97 a_1845_466# a_3940_63# 0
C98 w_n310_281# a_1845_n37# 0
C99 a_10363_63# a_10906_466# 0.02047f
C100 m2_1295_79# a_8919_370# 0.01372f
C101 m2_7791_79# a_7083_63# 0.14708f
C102 a_7083_63# a_8361_407# 0.01453f
C103 m2_5700_324# a_6721_407# 0.50857f
C104 a_7410_63# a_8723_63# 0.01398f
C105 a_1845_466# a_1845_n37# 0.01333f
C106 a_2861_391# a_2861_3# 0.01616f
C107 a_510_63# a_1262_n37# 0.00898f
C108 a_510_63# a_160_63# 0.28903f
C109 w_n310_281# a_7410_63# 0.31086f
C110 a_2419_63# a_8361_407# 0
C111 m2_7791_79# a_2419_63# 0.00843f
C112 a_5042_407# a_2861_3# 0
C113 a_5042_407# a_3940_63# 0.0941f
C114 m2_9431_79# a_8723_63# 0.13485f
C115 m2_1295_79# a_10906_466# 0.0692f
C116 a_3940_63# a_5768_63# 0
C117 a_9800_n37# m2_9431_79# 0.0074f
C118 a_3498_3# a_2861_3# 0.09846f
C119 a_3940_63# a_3498_3# 0.04602f
C120 a_378_271# a_510_63# 0.14298f
C121 w_n310_281# a_11922_391# 0.03535f
C122 w_n310_281# m2_9431_79# 0.46254f
C123 a_4290_63# a_2419_63# 0.00652f
C124 a_11922_3# m2_1295_79# 0
C125 a_7083_63# a_9408_n37# 0.00336f
C126 m2_1295_79# a_2861_3# 0.15381f
C127 m2_1295_79# a_3940_63# 0.46061f
C128 a_4158_271# a_8723_63# 0
C129 a_11480_63# a_10906_466# 0.1131f
C130 a_4158_271# a_9800_n37# 0.00497f
C131 a_7083_63# a_9609_407# 0.0285f
C132 m2_1295_79# a_1845_n37# 0.00942f
C133 a_5042_407# a_7410_63# 0
C134 w_n310_281# a_4158_271# 0.66883f
C135 a_11480_63# a_11922_3# 0.04054f
C136 a_705_407# w_n310_281# 0.79414f
C137 a_5243_407# a_2861_3# 0
C138 m2_9431_79# a_9050_63# 0.328f
C139 a_5243_407# a_3940_63# 0.06737f
C140 a_7410_63# a_3498_3# 0.11774f
C141 a_2419_63# a_9609_407# 0
C142 a_10363_63# m2_9431_79# 0.07766f
C143 m2_5700_324# a_7083_63# 0.12051f
C144 m2_1295_79# a_7410_63# 0.07614f
C145 a_705_407# a_1845_466# 0.0126f
C146 m2_7791_79# a_8919_370# 0.02774f
C147 a_8919_370# a_8361_407# 0
C148 a_4158_271# a_9050_63# 0.00717f
C149 a_4158_271# a_10363_63# 0.02222f
C150 m2_6151_79# a_7410_63# 0
C151 a_3498_3# m2_9431_79# 0
C152 a_705_407# a_2861_391# 0
C153 m2_5700_324# a_2419_63# 0.074f
C154 a_5042_407# a_4158_271# 0.63867f
C155 w_n310_281# a_8723_63# 0.33581f
C156 m2_1295_79# m2_9431_79# 0.0078f
C157 a_4158_271# a_5768_63# 0.00573f
C158 a_4158_271# a_3498_3# 0.00829f
C159 a_378_271# a_160_63# 0.09182f
C160 a_11480_63# a_11922_391# 0.00152f
C161 a_6721_407# a_7083_63# 0.01268f
C162 m2_1295_79# a_4158_271# 0.16058f
C163 a_11480_63# m2_9431_79# 0
C164 a_6520_n37# a_4158_271# 0.00406f
C165 w_n310_281# a_1845_466# 0.44517f
C166 a_8723_63# a_9050_63# 0.53121f
C167 a_705_407# m2_1295_79# 0.30816f
C168 a_510_63# m2_24_342# 0.13025f
C169 a_10363_63# a_8723_63# 0
C170 a_9800_n37# a_9050_63# 0.01329f
C171 m2_6151_79# a_4158_271# 0.04334f
C172 a_8919_370# a_9609_407# 0.02942f
C173 a_6721_407# a_2419_63# 0.01825f
C174 a_11480_63# a_4158_271# 0.00295f
C175 w_n310_281# a_2861_391# 0.03535f
C176 w_n310_281# a_9050_63# 0.28931f
C177 w_n310_281# a_10363_63# 0.15741f
C178 a_5243_407# a_4158_271# 0.02964f
C179 a_4290_63# a_2861_3# 0
C180 a_4290_63# a_3940_63# 0.28903f
C181 a_3498_3# a_8723_63# 0.00575f
C182 w_n310_281# a_5042_407# 0.29911f
C183 a_3940_63# a_4650_n37# 0.00441f
C184 w_n310_281# a_5768_63# 0.31314f
C185 m2_1295_79# a_8723_63# 0.00803f
C186 a_10906_466# a_9609_407# 0
C187 m2_5700_324# a_8919_370# 0
C188 a_7410_63# a_8361_407# 0.1423f
C189 m2_7791_79# a_7410_63# 0.36168f
C190 w_n310_281# a_3498_3# 1.03377f
C191 m2_7791_79# a_8160_n37# 0.01048f
C192 a_10363_63# a_9050_63# 0.01385f
C193 w_n310_281# m2_1295_79# 2.35219f
C194 a_1845_466# a_3498_3# 0.00105f
C195 a_7768_n37# a_7083_63# 0.0028f
C196 a_8361_407# m2_9431_79# 0
C197 m2_7791_79# m2_9431_79# 0.01571f
C198 m2_1295_79# a_1845_466# 0.09644f
C199 w_n310_281# m2_6151_79# 0.44301f
C200 a_2861_391# a_3498_3# 0.00454f
C201 a_11480_63# w_n310_281# 0.37298f
C202 a_10906_n37# a_10906_466# 0.01333f
C203 a_5042_407# a_5768_63# 0.22596f
C204 w_n310_281# a_5243_407# 0.78984f
C205 m2_1295_79# a_2861_391# 0.00841f
C206 m2_1295_79# a_9050_63# 0.00716f
C207 m2_7791_79# a_4158_271# 0
C208 a_510_63# a_1845_n37# 0.0011f
C209 m2_5700_324# a_3940_63# 0.00132f
C210 a_5042_407# a_3498_3# 0.02015f
C211 m2_1295_79# a_10363_63# 0.00179f
C212 m2_24_342# a_160_63# 0.42316f
C213 a_3498_3# a_5768_63# 0
C214 a_7083_63# a_2419_63# 0.01345f
C215 a_5042_407# m2_1295_79# 0.03487f
C216 a_5042_407# a_6520_n37# 0.00483f
C217 m2_1295_79# a_5768_63# 0.00766f
C218 a_6520_n37# a_5768_63# 0.01329f
C219 a_11480_63# a_10363_63# 0
C220 a_4290_63# a_4158_271# 0.11363f
C221 m2_1295_79# a_3498_3# 0.3391f
C222 a_5042_407# m2_6151_79# 0.20459f
C223 a_9408_n37# m2_9431_79# 0.01733f
C224 m2_6151_79# a_5768_63# 0.35511f
C225 a_378_271# m2_24_342# 0.56715f
C226 a_4158_271# a_4650_n37# 0.00383f
C227 m2_9431_79# a_9609_407# 0.49779f
C228 m2_6151_79# a_3498_3# 0
C229 a_2419_63# a_12559_3# 0
C230 a_5042_407# a_5243_407# 0.29512f
C231 m2_5700_324# a_7410_63# 0.14432f
C232 m2_7791_79# a_8723_63# 0.08396f
C233 a_8361_407# a_8723_63# 0.01268f
C234 a_5243_407# a_5768_63# 0.00722f
C235 m2_6151_79# m2_1295_79# 0.00667f
C236 a_6520_n37# m2_6151_79# 0.00766f
C237 a_5243_407# a_3498_3# 0.16427f
C238 a_4158_271# a_9609_407# 0
C239 a_11480_63# m2_1295_79# 0.00126f
C240 a_1845_466# a_870_n37# 0
C241 w_n310_281# a_8361_407# 0.75753f
C242 w_n310_281# m2_7791_79# 0.45139f
C243 a_5243_407# m2_1295_79# 0.10989f
C244 a_705_407# a_510_63# 0.13828f
C245 a_7083_63# a_8919_370# 0.01057f
C246 m2_24_342# a_2419_63# 0.00234f
C247 w_n310_281# a_4290_63# 0.2819f
C248 m2_5700_324# a_4158_271# 0.00861f
C249 m2_7791_79# a_9050_63# 0.00127f
C250 a_8361_407# a_9050_63# 0
C251 a_4158_271# a_10906_n37# 0.00824f
C252 a_8723_63# a_9609_407# 0.0593f
C253 a_2419_63# a_8919_370# 0.01445f
C254 m2_7791_79# a_5042_407# 0.00555f
C255 m2_7791_79# a_5768_63# 0
C256 m2_1295_79# a_870_n37# 0.00639f
C257 a_7083_63# a_10906_466# 0
C258 w_n310_281# a_9609_407# 0.7653f
C259 a_8361_407# a_3498_3# 0.12093f
C260 m2_7791_79# a_3498_3# 0.0296f
C261 m2_1295_79# a_8361_407# 0.02509f
C262 m2_7791_79# m2_1295_79# 0.05731f
C263 a_4290_63# a_5042_407# 0.38112f
C264 a_510_63# w_n310_281# 0.28255f
C265 m2_5700_324# a_8723_63# 0
C266 a_2419_63# a_10906_466# 0.00833f
C267 a_4290_63# a_5768_63# 0.01093f
C268 a_9408_n37# a_9050_63# 0.00935f
C269 a_5042_407# a_4650_n37# 0.00712f
C270 a_5042_n37# a_4158_271# 0
C271 a_12559_3# a_10906_466# 0
C272 m2_7791_79# m2_6151_79# 0.00114f
C273 a_4290_63# a_3498_3# 0.00876f
C274 a_510_63# a_1845_466# 0.01433f
C275 m2_5700_324# w_n310_281# 1.65678f
C276 a_9050_63# a_9609_407# 0.1261f
C277 a_11922_3# a_2419_63# 0.16984f
C278 a_2419_63# a_2861_3# 0.21478f
C279 a_3940_63# a_2419_63# 0.00879f
C280 a_10363_63# a_9609_407# 0.01306f
C281 a_7768_n37# a_7410_63# 0.00935f
C282 w_n310_281# a_10906_n37# 0
C283 a_4290_63# m2_1295_79# 0.13519f
C284 a_11922_3# a_12559_3# 0.0899f
C285 a_705_407# a_1262_n37# 0
C286 a_705_407# a_160_63# 0.06737f
C287 a_4290_63# m2_6151_79# 0
C288 a_5042_407# a_6128_n37# 0.00376f
C289 a_7083_63# a_7410_63# 0.07718f
C290 a_7083_63# a_8160_n37# 0.00507f
C291 a_5768_63# a_6128_n37# 0.00935f
C292 a_7768_n37# m2_9431_79# 0
C293 a_4290_63# a_5243_407# 0.14023f
C294 m2_1295_79# a_9609_407# 0.0093f
C295 a_10363_63# a_10906_n37# 0
C296 w_n310_281# a_6721_407# 0.72579f
C297 a_7410_63# a_2419_63# 0.00801f
C298 m2_5700_324# a_5042_407# 0.06917f
C299 a_705_407# a_378_271# 0.02817f
C300 a_7083_63# m2_9431_79# 0.19293f
C301 m2_5700_324# a_5768_63# 0.16447f
C302 a_510_63# m2_1295_79# 0.39896f
C303 a_4158_271# via_dev$5$1$4_9/VSUBS 2.63898f
C304 a_7083_63# via_dev$5$1$4_9/VSUBS 0.86585f
C305 a_8723_63# via_dev$5$1$4_9/VSUBS 0.41121f
C306 m2_9431_79# via_dev$5$1$4_9/VSUBS 0.75255f
C307 m2_7791_79# via_dev$5$1$4_9/VSUBS 0.74612f
C308 a_9609_407# via_dev$5$1$4_9/VSUBS 0.11967f
C309 a_8361_407# via_dev$5$1$4_9/VSUBS 0.05216f
C310 m2_6151_79# via_dev$5$1$4_9/VSUBS 0.72815f
C311 a_6721_407# via_dev$5$1$4_9/VSUBS 0.01698f
C312 a_5042_407# via_dev$5$1$4_9/VSUBS 0.88916f
C313 a_3940_63# via_dev$5$1$4_9/VSUBS 0.46864f
C314 m2_1295_79# via_dev$5$1$4_9/VSUBS 3.37184f
C315 a_160_63# via_dev$5$1$4_9/VSUBS 0.5921f
C316 a_5243_407# via_dev$5$1$4_9/VSUBS 0.01661f
C317 a_705_407# via_dev$5$1$4_9/VSUBS 0.13677f
C318 a_3498_3# via_dev$5$1$4_9/VSUBS 1.27724f
C319 a_10906_n37# via_dev$5$1$4_9/VSUBS 0.02232f
C320 a_9800_n37# via_dev$5$1$4_9/VSUBS 0.01742f
C321 a_9408_n37# via_dev$5$1$4_9/VSUBS 0.007f
C322 a_8160_n37# via_dev$5$1$4_9/VSUBS 0.01743f
C323 a_7768_n37# via_dev$5$1$4_9/VSUBS 0.007f
C324 a_6520_n37# via_dev$5$1$4_9/VSUBS 0.01743f
C325 a_6128_n37# via_dev$5$1$4_9/VSUBS 0.007f
C326 a_5042_n37# via_dev$5$1$4_9/VSUBS 0.00833f
C327 a_4650_n37# via_dev$5$1$4_9/VSUBS 0.01565f
C328 a_12559_3# via_dev$5$1$4_9/VSUBS 0.19481f
C329 a_11922_3# via_dev$5$1$4_9/VSUBS 0.64569f
C330 a_11922_391# via_dev$5$1$4_9/VSUBS 0.00119f
C331 a_10906_466# via_dev$5$1$4_9/VSUBS 0.59796f
C332 a_11480_63# via_dev$5$1$4_9/VSUBS 0.42359f
C333 a_10363_63# via_dev$5$1$4_9/VSUBS 0.13924f
C334 a_9050_63# via_dev$5$1$4_9/VSUBS 0.53264f
C335 a_8919_370# via_dev$5$1$4_9/VSUBS 0.51824f
C336 a_7410_63# via_dev$5$1$4_9/VSUBS 0.53731f
C337 a_5768_63# via_dev$5$1$4_9/VSUBS 0.54f
C338 a_1845_n37# via_dev$5$1$4_9/VSUBS 0.01974f
C339 a_1262_n37# via_dev$5$1$4_9/VSUBS 0.0069f
C340 a_870_n37# via_dev$5$1$4_9/VSUBS 0.01517f
C341 a_4290_63# via_dev$5$1$4_9/VSUBS 0.57048f
C342 a_2861_3# via_dev$5$1$4_9/VSUBS 0.62907f
C343 a_1845_466# via_dev$5$1$4_9/VSUBS 0.59853f
C344 a_2419_63# via_dev$5$1$4_9/VSUBS 6.64124f
C345 a_510_63# via_dev$5$1$4_9/VSUBS 0.55998f
C346 a_378_271# via_dev$5$1$4_9/VSUBS 1.37769f
C347 w_n310_281# via_dev$5$1$4_9/VSUBS 27.06296f
C348 m2_24_342# via_dev$5$1$4_9/VSUBS 1.98211f
C349 m2_5700_324# via_dev$5$1$4_9/VSUBS 1.14834f
.ends

.subckt AND4$5 w_237_91# a_992_79# a_372_n441# a_1200_79# a_1686_n317# a_784_79# a_704_n441#
+ a_576_79# a_912_n441# a_518_229# a_1120_n441#
X0 w_237_91# a_992_79# a_518_229# w_237_91# pfet_03v3 ad=0.38p pd=1.76u as=0.38p ps=1.76u w=1u l=0.28u
X1 a_518_229# a_784_79# w_237_91# w_237_91# pfet_03v3 ad=0.38p pd=1.76u as=0.38p ps=1.76u w=1u l=0.28u
X2 a_1686_n317# a_518_229# w_237_91# w_237_91# pfet_03v3 ad=0.65p pd=3.3u as=0.65p ps=3.3u w=1u l=0.28u
X3 a_912_n441# a_784_79# a_704_n441# a_372_n441# nfet_03v3 ad=0.76p pd=2.76u as=0.76p ps=2.76u w=2u l=0.28u
X4 w_237_91# a_576_79# a_518_229# w_237_91# pfet_03v3 ad=0.38p pd=1.76u as=0.65p ps=3.3u w=1u l=0.28u
X5 a_704_n441# a_576_79# a_372_n441# a_372_n441# nfet_03v3 ad=0.76p pd=2.76u as=1.34p ps=5.34u w=2u l=0.28u
X6 a_518_229# a_1200_79# a_1120_n441# a_372_n441# nfet_03v3 ad=1.14p pd=5.14u as=0.76p ps=2.76u w=2u l=0.28u
X7 a_1686_n317# a_518_229# a_372_n441# a_372_n441# nfet_03v3 ad=0.315p pd=2.26u as=0.295p ps=2.18u w=0.5u l=0.28u
X8 a_518_229# a_1200_79# w_237_91# w_237_91# pfet_03v3 ad=0.55p pd=3.1u as=0.38p ps=1.76u w=1u l=0.28u
X9 a_1120_n441# a_992_79# a_912_n441# a_372_n441# nfet_03v3 ad=0.76p pd=2.76u as=0.76p ps=2.76u w=2u l=0.28u
C0 a_1120_n441# a_518_229# 0.02253f
C1 a_1200_79# a_992_79# 0.06396f
C2 a_1200_79# w_237_91# 0.15686f
C3 a_992_79# w_237_91# 0.1469f
C4 a_1686_n317# w_237_91# 0.1612f
C5 a_1200_79# a_518_229# 0.20239f
C6 a_992_79# a_912_n441# 0.00663f
C7 a_992_79# a_784_79# 0.06396f
C8 a_784_79# w_237_91# 0.14715f
C9 a_518_229# a_992_79# 0.12168f
C10 a_518_229# w_237_91# 1.12672f
C11 a_1686_n317# a_518_229# 0.12995f
C12 w_237_91# a_576_79# 0.16514f
C13 a_518_229# a_912_n441# 0.01471f
C14 a_518_229# a_784_79# 0.11673f
C15 a_1200_79# a_1120_n441# 0.00663f
C16 a_704_n441# a_784_79# 0.00663f
C17 a_784_79# a_576_79# 0.06396f
C18 a_704_n441# a_518_229# 0.01032f
C19 a_518_229# a_576_79# 0.11544f
C20 a_1120_n441# a_372_n441# 0.02626f
C21 a_912_n441# a_372_n441# 0.02949f
C22 a_704_n441# a_372_n441# 0.03642f
C23 a_1686_n317# a_372_n441# 0.20646f
C24 a_518_229# a_372_n441# 0.81795f
C25 a_1200_79# a_372_n441# 0.2334f
C26 a_992_79# a_372_n441# 0.22559f
C27 a_784_79# a_372_n441# 0.22803f
C28 a_576_79# a_372_n441# 0.27946f
C29 w_237_91# a_372_n441# 2.88366f
.ends

.subckt x4bitblock_LAST 1bitblock$3$4_0/a_7410_63# 1bitblock$3$4_0/a_11922_391# 1bitblock$7_0/a_4290_63#
+ 1bitblock$7_0/a_705_407# 1bitblock$7_0/m2_7791_79# 1bitblock$2$4_0/a_7768_n37# 1bitblock$2$4_0/m2_24_342#
+ 1bitblock$3$4_0/a_10906_466# 1bitblock$7_0/a_7410_63# 1bitblock$7_0/a_10363_63#
+ 1bitblock$1$4_0/a_5042_407# 1bitblock$1$4_0/a_2419_63# 1bitblock$2$4_0/m2_7791_79#
+ 1bitblock$7_0/a_510_63# 1bitblock$3$4_0/a_8723_63# 1bitblock$2$4_0/a_10363_63# 1bitblock$3$4_0/a_378_271#
+ 1bitblock$2$4_0/a_10906_n37# 1bitblock$7_0/a_8723_63# 1bitblock$7_0/a_378_271# 1bitblock$1$4_0/m2_7791_79#
+ 1bitblock$1$4_0/a_10363_63# 1bitblock$3$4_0/a_8361_407# 1bitblock$3$4_0/a_6520_n37#
+ 1bitblock$2$4_0/a_11922_3# 1bitblock$7_0/a_3498_3# 1bitblock$2$4_0/a_2419_63# 1bitblock$1$4_0/a_7083_63#
+ 1bitblock$3$4_0/m2_24_342# 1bitblock$3$4_0/a_5768_63# 1bitblock$2$4_0/a_9050_63#
+ MUX21$4_0/a_1472_63# 1bitblock$7_0/a_8361_407# 1bitblock$7_0/a_10906_466# 1bitblock$2$4_0/a_10906_466#
+ 1bitblock$7_0/a_870_n37# 1bitblock$3$4_0/a_9800_n37# 1bitblock$3$4_0/a_6721_407#
+ 1bitblock$3$4_0/a_11480_63# 1bitblock$3$4_0/a_6128_n37# 1bitblock$7_0/a_160_63#
+ 1bitblock$7_0/a_5768_63# 1bitblock$7_0/a_1845_466# 1bitblock$3$4_0/m2_6151_79# 1bitblock$1$4_0/a_8723_63#
+ MUX21$4_0/a_157_63# 1bitblock$2$4_0/a_3498_3# 1bitblock$1$4_0/a_378_271# 1bitblock$3$4_0/a_11922_3#
+ 1bitblock$7_0/a_6721_407# m1_10807_n176# 1bitblock$7_0/a_7083_63# 1bitblock$7_0/a_11480_63#
+ 1bitblock$3$4_0/a_2419_63# 1bitblock$2$4_0/a_7083_63# m2_10721_n3315# 1bitblock$3$4_0/a_9408_n37#
+ 1bitblock$2$4_0/a_9800_n37# m1_14167_n1145# MUX21$4_0/a_909_n37# 1bitblock$2$4_0/a_11480_63#
+ 1bitblock$7_0/a_11922_3# 1bitblock$3$4_0/a_9609_407# 1bitblock$3$4_0/a_8160_n37#
+ 1bitblock$7_0/m2_6151_79# 1bitblock$3$4_0/a_9050_63# 1bitblock$2$4_0/a_7410_63#
+ 1bitblock$1$4_0/m2_24_342# m1_8729_n3942# 1bitblock$7_0/a_2419_63# 1bitblock$3$4_0/m2_9431_79#
+ m2_2396_n2595# 1bitblock$3$4_0/a_10906_n37# 1bitblock$3$4_0/a_5243_407# 1bitblock$2$4_0/m2_6151_79#
+ m2_1701_n784# 1bitblock$7_0/a_9050_63# 1bitblock$3$4_0/a_5042_407# 1bitblock$7_0/a_9609_407#
+ MUX21$4_0/a_517_n37# 1bitblock$7_0/a_5042_407# m2_5443_n3913# 1bitblock$7_0/m2_24_342#
+ MUX21$4_0/a_718_407# 1bitblock$3$4_0/a_7768_n37# m1_13543_n1146# 1bitblock$7_0/m2_9431_79#
+ 1bitblock$2$4_0/a_8723_63# 1bitblock$2$4_0/a_9408_n37# m1_12486_242# 1bitblock$2$4_0/a_378_271#
+ 1bitblock$3$4_0/a_3498_3# MUX21$4_0/m2_540_79# 1bitblock$7_0/a_3940_63# m2_14516_n651#
+ 1bitblock$2$4_0/a_8160_n37# 1bitblock$3$4_0/m2_7791_79# 1bitblock$3$4_0/a_7083_63#
+ m1_n563_n4361# AND4$5_0/a_518_229# 1bitblock$2$4_0/m2_9431_79# 1bitblock$7_0/a_5243_407#
+ m1_12484_n953# 1bitblock$7_0/a_2861_3# 1bitblock$3$4_0/a_10363_63# VSUBS m1_12480_n3815#
X1bitblock$3$4_0 1bitblock$3$4_0/a_2861_3# 1bitblock$3$4_0/a_8361_407# 1bitblock$3$4_0/a_6520_n37#
+ 1bitblock$3$4_0/a_1262_n37# 1bitblock$3$4_0/a_2861_391# 1bitblock$3$4_0/a_1845_466#
+ 1bitblock$3$4_0/a_10906_n37# 1bitblock$3$4_0/a_510_63# 1bitblock$3$4_0/a_870_n37#
+ 1bitblock$3$4_0/a_6721_407# 1bitblock$3$4_0/a_9800_n37# 1bitblock$3$4_0/a_11480_63#
+ 1bitblock$3$4_0/a_6128_n37# 1bitblock$3$4_0/a_5768_63# 1bitblock$3$4_0/m2_6151_79#
+ 1bitblock$3$4_0/a_11922_391# 1bitblock$3$4_0/a_5042_n37# 1bitblock$3$4_0/a_9408_n37#
+ 1bitblock$3$4_0/a_9609_407# 1bitblock$3$4_0/a_8160_n37# m2_10721_n3315# 1bitblock$3$4_0/a_11922_3#
+ m1_8729_n3942# 1bitblock$3$4_0/a_2419_63# 1bitblock$3$4_0/m2_9431_79# 1bitblock$3$4_0/a_10906_466#
+ 1bitblock$3$4_0/a_4650_n37# 1bitblock$3$4_0/a_5243_407# 1bitblock$3$4_0/a_3498_3#
+ 1bitblock$3$4_0/a_9050_63# 1bitblock$3$4_0/a_7768_n37# 1bitblock$3$4_0/a_5042_407#
+ 1bitblock$3$4_0/a_3940_63# 1bitblock$3$4_0/m2_7791_79# 1bitblock$3$4_0/a_10363_63#
+ 1bitblock$3$4_0/a_160_63# 1bitblock$3$4_0/a_4290_63# 1bitblock$3$4_0/a_7083_63#
+ 1bitblock$3$4_0/a_705_407# m1_12480_n3815# 1bitblock$3$4_0/a_7410_63# 1bitblock$3$4_0/a_1845_n37#
+ VSUBS m1_13543_n1146# 1bitblock$3$4_0/a_8723_63# 1bitblock$3$4_0/a_378_271# m2_5443_n3913#
+ m1_n563_n4361# 1bitblock$3$4_0/m2_24_342# x1bitblock$3$4
X1bitblock$2$4_0 1bitblock$2$4_0/a_2861_3# 1bitblock$2$4_0/a_8361_407# 1bitblock$2$4_0/a_6520_n37#
+ 1bitblock$2$4_0/a_1262_n37# 1bitblock$2$4_0/a_2861_391# 1bitblock$2$4_0/a_1845_466#
+ 1bitblock$2$4_0/a_10906_n37# 1bitblock$2$4_0/a_510_63# 1bitblock$2$4_0/a_870_n37#
+ 1bitblock$2$4_0/a_6721_407# 1bitblock$2$4_0/a_9800_n37# 1bitblock$2$4_0/a_11480_63#
+ 1bitblock$2$4_0/a_6128_n37# 1bitblock$2$4_0/a_5768_63# m1_8729_n3942# 1bitblock$2$4_0/m2_6151_79#
+ 1bitblock$2$4_0/a_11922_391# 1bitblock$2$4_0/a_5042_n37# 1bitblock$2$4_0/a_9408_n37#
+ 1bitblock$2$4_0/a_9609_407# 1bitblock$2$4_0/a_5042_407# 1bitblock$2$4_0/a_8160_n37#
+ m1_12484_n953# 1bitblock$2$4_0/a_11922_3# 1bitblock$2$4_0/a_2419_63# 1bitblock$2$4_0/m2_9431_79#
+ 1bitblock$2$4_0/a_10906_466# 1bitblock$2$4_0/a_4650_n37# 1bitblock$2$4_0/a_9050_63#
+ 1bitblock$2$4_0/a_5243_407# 1bitblock$2$4_0/a_7768_n37# 1bitblock$2$4_0/a_3940_63#
+ 1bitblock$2$4_0/m2_7791_79# 1bitblock$2$4_0/a_10363_63# 1bitblock$2$4_0/a_160_63#
+ 1bitblock$2$4_0/a_4290_63# 1bitblock$2$4_0/a_7083_63# 1bitblock$2$4_0/a_705_407#
+ m2_10721_n3315# 1bitblock$2$4_0/a_7410_63# 1bitblock$2$4_0/a_1845_n37# VSUBS m2_5443_n3913#
+ m2_2396_n2595# 1bitblock$2$4_0/a_8723_63# 1bitblock$2$4_0/a_378_271# 1bitblock$2$4_0/a_3498_3#
+ m1_n563_n4361# 1bitblock$2$4_0/m2_24_342# x1bitblock$2$4
XMUX21$4_0 MUX21$4_0/a_1472_63# MUX21$4_0/a_157_63# m2_14516_n651# MUX21$4_0/a_909_n37#
+ m1_10807_n176# MUX21$4_0/a_517_n37# MUX21$4_0/a_718_407# MUX21$4_0/m2_540_79# VSUBS
+ m1_12480_n3815# m1_n563_n4361# MUX21$4
X1bitblock$7_0 1bitblock$7_0/a_2861_3# 1bitblock$7_0/a_8361_407# 1bitblock$7_0/a_6520_n37#
+ 1bitblock$7_0/a_1262_n37# 1bitblock$7_0/a_2861_391# 1bitblock$7_0/a_1845_466# 1bitblock$7_0/a_10906_n37#
+ 1bitblock$7_0/a_510_63# 1bitblock$7_0/a_870_n37# 1bitblock$7_0/a_6721_407# 1bitblock$7_0/a_9800_n37#
+ 1bitblock$7_0/a_11480_63# 1bitblock$7_0/a_6128_n37# 1bitblock$7_0/a_5768_63# 1bitblock$7_0/m2_6151_79#
+ 1bitblock$7_0/a_3498_3# 1bitblock$7_0/a_11922_391# 1bitblock$7_0/a_5042_n37# 1bitblock$7_0/a_9408_n37#
+ m1_8729_n3942# 1bitblock$7_0/a_9609_407# 1bitblock$7_0/a_5042_407# 1bitblock$7_0/a_8160_n37#
+ m1_10807_n176# 1bitblock$7_0/a_11922_3# 1bitblock$7_0/a_2419_63# 1bitblock$7_0/m2_9431_79#
+ 1bitblock$7_0/a_10906_466# 1bitblock$7_0/a_4650_n37# 1bitblock$7_0/a_9050_63# 1bitblock$7_0/a_5243_407#
+ 1bitblock$7_0/a_7768_n37# 1bitblock$7_0/a_3940_63# 1bitblock$7_0/m2_7791_79# 1bitblock$7_0/a_10363_63#
+ 1bitblock$7_0/a_160_63# 1bitblock$7_0/a_4290_63# 1bitblock$7_0/a_7083_63# 1bitblock$7_0/a_705_407#
+ m1_12486_242# 1bitblock$7_0/a_7410_63# m2_5443_n3913# 1bitblock$7_0/a_1845_n37#
+ VSUBS m1_14167_n1145# 1bitblock$7_0/a_8723_63# 1bitblock$7_0/a_378_271# m1_n563_n4361#
+ 1bitblock$7_0/m2_24_342# x1bitblock$7
X1bitblock$1$4_0 1bitblock$1$4_0/a_2861_3# 1bitblock$1$4_0/a_8361_407# 1bitblock$1$4_0/a_6520_n37#
+ 1bitblock$1$4_0/a_1262_n37# 1bitblock$1$4_0/a_2861_391# 1bitblock$1$4_0/a_1845_466#
+ 1bitblock$1$4_0/a_10906_n37# 1bitblock$1$4_0/a_510_63# 1bitblock$1$4_0/a_870_n37#
+ 1bitblock$1$4_0/a_6721_407# 1bitblock$1$4_0/a_9800_n37# 1bitblock$1$4_0/a_11480_63#
+ 1bitblock$1$4_0/a_6128_n37# 1bitblock$1$4_0/a_5768_63# 1bitblock$1$4_0/m2_6151_79#
+ 1bitblock$1$4_0/a_3498_3# 1bitblock$1$4_0/a_11922_391# 1bitblock$1$4_0/a_5042_n37#
+ 1bitblock$1$4_0/a_9408_n37# 1bitblock$1$4_0/a_9609_407# 1bitblock$1$4_0/a_5042_407#
+ 1bitblock$1$4_0/a_8160_n37# m1_12486_242# 1bitblock$1$4_0/a_11922_3# 1bitblock$1$4_0/a_2419_63#
+ 1bitblock$1$4_0/m2_9431_79# 1bitblock$1$4_0/a_10906_466# 1bitblock$1$4_0/a_4650_n37#
+ 1bitblock$1$4_0/a_9050_63# 1bitblock$1$4_0/a_5243_407# 1bitblock$1$4_0/a_7768_n37#
+ 1bitblock$1$4_0/a_160_63# 1bitblock$1$4_0/a_3940_63# m1_8729_n3942# 1bitblock$1$4_0/m2_7791_79#
+ 1bitblock$1$4_0/a_10363_63# 1bitblock$1$4_0/a_4290_63# 1bitblock$1$4_0/a_7083_63#
+ 1bitblock$1$4_0/a_705_407# m1_12484_n953# 1bitblock$1$4_0/a_7410_63# m2_5443_n3913#
+ 1bitblock$1$4_0/a_1845_n37# VSUBS 1bitblock$1$4_0/m2_24_342# m2_1701_n784# 1bitblock$1$4_0/a_8723_63#
+ 1bitblock$1$4_0/a_378_271# m1_n563_n4361# x1bitblock$1$4
XAND4$5_0 m1_n563_n4361# m2_2396_n2595# VSUBS m1_13543_n1146# m2_14516_n651# m2_1701_n784#
+ AND4$5_0/a_704_n441# m1_14167_n1145# AND4$5_0/a_912_n441# AND4$5_0/a_518_229# AND4$5_0/a_1120_n441#
+ AND4$5
C0 m2_10721_n3315# 1bitblock$3$4_0/a_10906_466# 0.0161f
C1 m2_5443_n3913# 1bitblock$1$4_0/a_6128_n37# 0
C2 m2_5443_n3913# 1bitblock$7_0/a_3940_63# 0.00286f
C3 1bitblock$3$4_0/m2_7791_79# m1_13543_n1146# 0.01676f
C4 1bitblock$3$4_0/a_378_271# 1bitblock$2$4_0/a_705_407# 0
C5 MUX21$4_0/m2_540_79# MUX21$4_0/a_157_63# 0
C6 1bitblock$7_0/a_9050_63# 1bitblock$7_0/m2_7791_79# -0
C7 m1_12484_n953# m2_14516_n651# 0.10897f
C8 1bitblock$1$4_0/a_5768_63# m2_1701_n784# 0
C9 m1_n563_n4361# MUX21$4_0/m2_540_79# -0.00173f
C10 m2_1701_n784# 1bitblock$1$4_0/m2_7791_79# 0
C11 m2_5443_n3913# 1bitblock$2$4_0/a_3940_63# 0.00421f
C12 m2_5443_n3913# 1bitblock$3$4_0/a_3940_63# 0.00284f
C13 m1_n563_n4361# 1bitblock$3$4_0/m2_9431_79# -0.00106f
C14 1bitblock$3$4_0/a_378_271# 1bitblock$3$4_0/a_705_407# -0
C15 m2_5443_n3913# 1bitblock$3$4_0/a_6520_n37# 0.00151f
C16 1bitblock$1$4_0/a_11922_3# m1_12486_242# 0.01722f
C17 m1_13543_n1146# m2_14516_n651# 0.00988f
C18 1bitblock$3$4_0/a_7410_63# m1_8729_n3942# 0.00461f
C19 AND4$5_0/a_912_n441# m2_14516_n651# 0.00402f
C20 m1_8729_n3942# 1bitblock$1$4_0/a_9050_63# 0.02224f
C21 m2_1701_n784# 1bitblock$1$4_0/a_9609_407# -0
C22 1bitblock$3$4_0/a_160_63# m1_13543_n1146# 0
C23 m1_n563_n4361# 1bitblock$1$4_0/m2_24_342# 0.03103f
C24 1bitblock$2$4_0/a_2419_63# m2_2396_n2595# 0.07185f
C25 m2_1701_n784# m1_12486_242# 0.92821f
C26 m1_n563_n4361# 1bitblock$7_0/a_705_407# -0
C27 m1_8729_n3942# 1bitblock$2$4_0/a_7410_63# 0.00637f
C28 1bitblock$3$4_0/a_510_63# m1_13543_n1146# 0.00107f
C29 1bitblock$1$4_0/a_2419_63# 1bitblock$1$4_0/a_3940_63# -0
C30 1bitblock$1$4_0/a_11922_391# m1_12486_242# 0.00397f
C31 m2_1701_n784# 1bitblock$1$4_0/a_8361_407# -0
C32 1bitblock$1$4_0/a_11922_3# m2_1701_n784# 0
C33 1bitblock$2$4_0/a_705_407# 1bitblock$1$4_0/m2_24_342# 0
C34 m1_n563_n4361# 1bitblock$2$4_0/a_378_271# 0.00489f
C35 1bitblock$7_0/a_378_271# m1_14167_n1145# 0.00199f
C36 m2_1701_n784# 1bitblock$1$4_0/a_7083_63# 0.03418f
C37 1bitblock$7_0/a_1845_n37# m2_1701_n784# 0.00311f
C38 m1_14167_n1145# 1bitblock$1$4_0/a_1845_n37# 0
C39 1bitblock$7_0/a_9050_63# m1_14167_n1145# 0.0052f
C40 m1_n563_n4361# 1bitblock$7_0/a_3498_3# -0.00886f
C41 m1_12480_n3815# MUX21$4_0/a_718_407# 0.00296f
C42 m2_10721_n3315# 1bitblock$3$4_0/a_10906_n37# 0.00484f
C43 1bitblock$1$4_0/a_1845_466# m2_1701_n784# 0.01233f
C44 1bitblock$1$4_0/a_10906_466# m1_12486_242# 0.0161f
C45 m1_n563_n4361# 1bitblock$7_0/a_2419_63# 0
C46 m2_5443_n3913# 1bitblock$1$4_0/a_6520_n37# 0.00151f
C47 m1_n563_n4361# 1bitblock$7_0/a_160_63# 0.02528f
C48 m1_n563_n4361# MUX21$4_0/a_718_407# 0.0018f
C49 1bitblock$2$4_0/a_378_271# 1bitblock$2$4_0/a_705_407# -0
C50 m2_5443_n3913# m1_12484_n953# 0.05387f
C51 m1_8729_n3942# m1_12484_n953# 0.05077f
C52 m1_n563_n4361# 1bitblock$2$4_0/a_160_63# 0.02629f
C53 m2_1701_n784# 1bitblock$1$4_0/a_8723_63# -0
C54 m1_n563_n4361# 1bitblock$7_0/m2_9431_79# -0.00109f
C55 1bitblock$3$4_0/a_705_407# 1bitblock$2$4_0/a_1262_n37# 0
C56 1bitblock$3$4_0/m2_24_342# m1_13543_n1146# 0.0031f
C57 m1_n563_n4361# AND4$5_0/a_518_229# 0.0239f
C58 m1_8729_n3942# 1bitblock$3$4_0/a_8723_63# 0.08003f
C59 m2_10721_n3315# 1bitblock$2$4_0/a_3940_63# 0
C60 1bitblock$2$4_0/a_10906_466# m2_10721_n3315# 0
C61 m1_n563_n4361# 1bitblock$2$4_0/m2_9431_79# -0
C62 1bitblock$2$4_0/a_378_271# 1bitblock$3$4_0/a_705_407# 0
C63 m2_5443_n3913# m1_13543_n1146# 0.00329f
C64 m1_n563_n4361# 1bitblock$7_0/a_5042_407# 0
C65 1bitblock$1$4_0/a_10906_466# m2_1701_n784# 0
C66 m1_8729_n3942# m1_13543_n1146# 0.01251f
C67 1bitblock$2$4_0/a_378_271# 1bitblock$1$4_0/a_705_407# 0
C68 m1_n563_n4361# 1bitblock$2$4_0/a_5042_407# 0
C69 1bitblock$7_0/a_1262_n37# 1bitblock$7_0/a_705_407# 0
C70 1bitblock$3$4_0/a_705_407# 1bitblock$2$4_0/a_160_63# 0
C71 1bitblock$7_0/a_705_407# 1bitblock$1$4_0/a_160_63# 0
C72 1bitblock$7_0/a_160_63# 1bitblock$1$4_0/a_705_407# 0
C73 1bitblock$3$4_0/a_2861_391# m1_13543_n1146# 0.01584f
C74 m1_n563_n4361# 1bitblock$2$4_0/a_3940_63# 0
C75 1bitblock$2$4_0/a_10906_466# m1_n563_n4361# 0.00105f
C76 1bitblock$2$4_0/a_160_63# 1bitblock$1$4_0/a_705_407# 0
C77 m1_n563_n4361# 1bitblock$3$4_0/a_3940_63# 0
C78 1bitblock$1$4_0/a_2861_3# m2_1701_n784# 0
C79 1bitblock$7_0/a_9609_407# 1bitblock$7_0/m2_7791_79# -0
C80 1bitblock$3$4_0/a_2861_3# 1bitblock$3$4_0/a_705_407# -0
C81 m2_5443_n3913# 1bitblock$2$4_0/a_2419_63# 0.00972f
C82 m1_n563_n4361# 1bitblock$1$4_0/a_378_271# 0.00489f
C83 m1_8729_n3942# 1bitblock$2$4_0/a_2419_63# 0.00665f
C84 1bitblock$7_0/a_2419_63# 1bitblock$1$4_0/a_2419_63# 1.63229f
C85 m1_n563_n4361# 1bitblock$1$4_0/a_9050_63# 0
C86 1bitblock$7_0/a_160_63# 1bitblock$1$4_0/a_160_63# 0.04611f
C87 1bitblock$3$4_0/a_3498_3# m2_2396_n2595# 0
C88 m2_5443_n3913# 1bitblock$7_0/a_6128_n37# 0
C89 m2_10721_n3315# m1_12484_n953# 1.58949f
C90 m1_n563_n4361# 1bitblock$2$4_0/a_7410_63# 0
C91 1bitblock$2$4_0/a_160_63# 1bitblock$1$4_0/a_160_63# 0.00196f
C92 1bitblock$7_0/a_5768_63# m2_1701_n784# 0
C93 m1_10807_n176# m1_12486_242# 1.92011f
C94 1bitblock$7_0/m2_7791_79# m2_1701_n784# 0
C95 1bitblock$1$4_0/a_2419_63# AND4$5_0/a_518_229# 0.00114f
C96 1bitblock$2$4_0/a_705_407# 1bitblock$1$4_0/a_378_271# 0
C97 1bitblock$1$4_0/a_4290_63# m2_1701_n784# 0
C98 1bitblock$3$4_0/a_1845_466# 1bitblock$2$4_0/m2_24_342# 0
C99 1bitblock$3$4_0/a_2419_63# 1bitblock$2$4_0/a_3940_63# 0
C100 m2_2396_n2595# 1bitblock$1$4_0/m2_7791_79# 0.0169f
C101 1bitblock$3$4_0/a_1845_466# m2_2396_n2595# 0.00179f
C102 m2_10721_n3315# m1_13543_n1146# 0.17094f
C103 m1_10807_n176# 1bitblock$1$4_0/a_11922_3# 0
C104 1bitblock$7_0/a_11922_3# m1_12486_242# 0.01844f
C105 1bitblock$1$4_0/a_7410_63# m2_1701_n784# 0
C106 m1_8729_n3942# 1bitblock$2$4_0/a_9408_n37# 0
C107 m1_n563_n4361# 1bitblock$7_0/m2_24_342# 0.01777f
C108 1bitblock$3$4_0/a_11922_3# m1_12484_n953# 0
C109 m1_8729_n3942# 1bitblock$7_0/a_9050_63# 0.01686f
C110 m1_12480_n3815# m1_12484_n953# 0
C111 m2_5443_n3913# 1bitblock$3$4_0/a_5768_63# 0.01326f
C112 m1_10807_n176# m2_1701_n784# 2.16295f
C113 m1_14167_n1145# m1_12486_242# 0.0897f
C114 m2_2396_n2595# 1bitblock$1$4_0/a_9609_407# 0.1012f
C115 1bitblock$7_0/a_11922_3# 1bitblock$1$4_0/a_11922_3# 0.00177f
C116 1bitblock$7_0/a_9609_407# m1_14167_n1145# 0.10113f
C117 1bitblock$7_0/a_2419_63# 1bitblock$1$4_0/a_3940_63# 0
C118 m1_n563_n4361# m1_12484_n953# 0.32612f
C119 1bitblock$7_0/a_3940_63# 1bitblock$1$4_0/a_2419_63# 0
C120 1bitblock$7_0/a_11922_391# m1_12486_242# 0.00287f
C121 1bitblock$3$4_0/a_11922_3# m1_13543_n1146# 0.01495f
C122 m2_2396_n2595# m1_12486_242# 0.0866f
C123 m1_12480_n3815# m1_13543_n1146# 0.07257f
C124 m1_n563_n4361# 1bitblock$3$4_0/a_8723_63# -0.00531f
C125 1bitblock$3$4_0/a_1262_n37# m2_2396_n2595# 0
C126 m1_13543_n1146# AND4$5_0/a_1120_n441# 0.0044f
C127 1bitblock$7_0/a_11922_3# m2_1701_n784# 0
C128 m1_13543_n1146# MUX21$4_0/a_157_63# 0
C129 1bitblock$7_0/a_7083_63# m2_1701_n784# 0.02635f
C130 m2_2396_n2595# 1bitblock$1$4_0/a_10363_63# 0.00482f
C131 1bitblock$7_0/a_1845_n37# m1_14167_n1145# 0
C132 m1_8729_n3942# 1bitblock$1$4_0/a_9408_n37# 0
C133 m2_2396_n2595# 1bitblock$1$4_0/a_8361_407# 0.03598f
C134 m1_n563_n4361# m1_13543_n1146# 0.69902f
C135 1bitblock$3$4_0/a_8361_407# m1_13543_n1146# 0.03557f
C136 m2_2396_n2595# 1bitblock$1$4_0/a_11922_3# 0.01205f
C137 m1_14167_n1145# 1bitblock$1$4_0/a_1845_466# 0.00183f
C138 1bitblock$7_0/a_1845_466# m2_1701_n784# 0.00247f
C139 1bitblock$7_0/a_1845_466# 1bitblock$1$4_0/a_1845_466# 0.00192f
C140 1bitblock$2$4_0/a_1845_466# m1_13543_n1146# 0.00178f
C141 m1_14167_n1145# m2_1701_n784# 0.36644f
C142 1bitblock$7_0/a_10906_466# m1_12486_242# 0.00953f
C143 m2_5443_n3913# 1bitblock$7_0/a_6520_n37# 0.0015f
C144 m2_2396_n2595# 1bitblock$1$4_0/a_7083_63# 0.00482f
C145 m1_8729_n3942# 1bitblock$3$4_0/a_7768_n37# 0
C146 1bitblock$3$4_0/a_378_271# 1bitblock$2$4_0/a_160_63# 0.00364f
C147 m2_10721_n3315# 1bitblock$2$4_0/a_2419_63# 0.00198f
C148 1bitblock$2$4_0/m2_24_342# m2_1701_n784# 0
C149 m2_2396_n2595# 1bitblock$1$4_0/a_1845_466# 0.0015f
C150 m1_12484_n953# 1bitblock$2$4_0/a_11922_3# 0.03273f
C151 m2_2396_n2595# m2_1701_n784# 1.22078f
C152 m2_5443_n3913# 1bitblock$3$4_0/a_4650_n37# 0.00118f
C153 1bitblock$7_0/m2_24_342# 1bitblock$1$4_0/a_705_407# 0
C154 1bitblock$7_0/a_8723_63# m2_1701_n784# 0
C155 m1_13543_n1146# 1bitblock$2$4_0/a_705_407# 0
C156 1bitblock$1$4_0/m2_24_342# 1bitblock$7_0/a_705_407# 0
C157 m2_14516_n651# m1_12486_242# 0.00988f
C158 1bitblock$3$4_0/a_2419_63# m1_12484_n953# 0.04408f
C159 m2_2396_n2595# 1bitblock$1$4_0/a_11922_391# 0.00705f
C160 1bitblock$1$4_0/a_9050_63# 1bitblock$1$4_0/m2_9431_79# -0
C161 1bitblock$3$4_0/m2_24_342# 1bitblock$3$4_0/a_3498_3# -0
C162 1bitblock$3$4_0/a_5042_407# m2_5443_n3913# 0.05824f
C163 m2_2396_n2595# 1bitblock$1$4_0/a_8723_63# 0.02997f
C164 1bitblock$7_0/a_3940_63# 1bitblock$1$4_0/a_3940_63# 0.01129f
C165 1bitblock$3$4_0/a_11922_3# 1bitblock$2$4_0/a_2419_63# 0
C166 m1_13543_n1146# 1bitblock$2$4_0/a_11922_3# 0
C167 m1_8729_n3942# 1bitblock$2$4_0/a_9800_n37# 0.0014f
C168 1bitblock$1$4_0/a_510_63# m2_1701_n784# 0.00173f
C169 1bitblock$3$4_0/a_705_407# m1_13543_n1146# 0.00558f
C170 1bitblock$2$4_0/a_378_271# 1bitblock$1$4_0/m2_24_342# 0
C171 1bitblock$1$4_0/a_11922_3# m2_14516_n651# 0.00533f
C172 m2_5443_n3913# 1bitblock$3$4_0/a_3498_3# 0
C173 m2_5443_n3913# 1bitblock$2$4_0/a_5243_407# 0.01246f
C174 m1_13543_n1146# 1bitblock$2$4_0/a_3498_3# 0
C175 1bitblock$3$4_0/a_2419_63# m1_13543_n1146# 0.07504f
C176 m1_8729_n3942# 1bitblock$3$4_0/a_3498_3# 0.0014f
C177 m1_12484_n953# 1bitblock$2$4_0/a_10906_n37# 0.00483f
C178 m2_2396_n2595# 1bitblock$1$4_0/a_10906_466# 0.0111f
C179 1bitblock$7_0/m2_24_342# 1bitblock$1$4_0/a_160_63# 0.00441f
C180 m1_n563_n4361# 1bitblock$2$4_0/a_2419_63# 0.00232f
C181 1bitblock$1$4_0/m2_24_342# 1bitblock$7_0/a_160_63# 0.00432f
C182 m2_14516_n651# m2_1701_n784# 0.85907f
C183 1bitblock$7_0/a_2419_63# 1bitblock$7_0/a_705_407# -0
C184 m1_12484_n953# 1bitblock$1$4_0/a_2419_63# 0.00245f
C185 1bitblock$2$4_0/a_160_63# 1bitblock$1$4_0/m2_24_342# 0
C186 m2_5443_n3913# 1bitblock$1$4_0/a_5768_63# 0.01876f
C187 1bitblock$3$4_0/a_2861_391# 1bitblock$3$4_0/a_3498_3# -0
C188 m1_8729_n3942# 1bitblock$1$4_0/m2_7791_79# 0.02398f
C189 1bitblock$2$4_0/a_510_63# m2_2396_n2595# 0.00105f
C190 m1_8729_n3942# 1bitblock$1$4_0/a_9800_n37# 0.0014f
C191 1bitblock$2$4_0/a_2419_63# 1bitblock$2$4_0/a_705_407# -0
C192 m2_5443_n3913# 1bitblock$3$4_0/m2_6151_79# 0.01067f
C193 1bitblock$7_0/a_2861_3# m2_1701_n784# 0.00149f
C194 m2_5443_n3913# 1bitblock$1$4_0/a_5243_407# 0.01246f
C195 m1_14167_n1145# 1bitblock$1$4_0/a_2861_3# 0.00149f
C196 1bitblock$2$4_0/a_9050_63# 1bitblock$2$4_0/m2_7791_79# -0
C197 1bitblock$7_0/a_2419_63# 1bitblock$7_0/a_3498_3# -0
C198 m1_13543_n1146# 1bitblock$1$4_0/a_2419_63# 0
C199 1bitblock$2$4_0/a_2861_3# 1bitblock$1$4_0/a_2861_3# 0
C200 1bitblock$1$4_0/a_10906_466# m2_14516_n651# 0
C201 1bitblock$3$4_0/a_9050_63# 1bitblock$3$4_0/m2_7791_79# -0
C202 1bitblock$2$4_0/a_9609_407# 1bitblock$2$4_0/m2_7791_79# -0
C203 m2_2396_n2595# 1bitblock$1$4_0/a_2861_3# 0.01004f
C204 m1_8729_n3942# 1bitblock$1$4_0/a_9609_407# 0.01871f
C205 1bitblock$2$4_0/a_510_63# 1bitblock$1$4_0/a_510_63# 0.00154f
C206 1bitblock$2$4_0/a_2419_63# 1bitblock$2$4_0/a_3498_3# -0
C207 1bitblock$2$4_0/a_2419_63# 1bitblock$3$4_0/a_2419_63# 1.31417f
C208 m1_12484_n953# 1bitblock$1$4_0/a_11480_63# 0.00279f
C209 1bitblock$7_0/a_3498_3# 1bitblock$7_0/m2_9431_79# -0
C210 1bitblock$1$4_0/a_870_n37# m2_1701_n784# 0
C211 m2_5443_n3913# m1_12486_242# 0.0535f
C212 m1_8729_n3942# m1_12486_242# 0.05039f
C213 m1_14167_n1145# 1bitblock$7_0/m2_7791_79# 0.01686f
C214 m1_8729_n3942# 1bitblock$7_0/a_9609_407# 0.00143f
C215 1bitblock$7_0/a_4290_63# m2_1701_n784# 0
C216 m1_8729_n3942# 1bitblock$1$4_0/a_10363_63# 0.00192f
C217 m2_10721_n3315# 1bitblock$3$4_0/a_11480_63# 0.01269f
C218 m1_8729_n3942# 1bitblock$1$4_0/a_8361_407# 0.00891f
C219 1bitblock$3$4_0/a_160_63# 1bitblock$2$4_0/a_510_63# 0
C220 MUX21$4_0/a_718_407# AND4$5_0/a_518_229# 0
C221 1bitblock$3$4_0/a_160_63# 1bitblock$2$4_0/a_870_n37# 0.00135f
C222 1bitblock$3$4_0/a_7410_63# 1bitblock$3$4_0/m2_9431_79# -0
C223 1bitblock$7_0/a_7410_63# m2_1701_n784# 0
C224 1bitblock$7_0/a_11922_3# m1_10807_n176# 0
C225 m2_5443_n3913# 1bitblock$1$4_0/a_7083_63# 0.00187f
C226 m1_8729_n3942# 1bitblock$1$4_0/a_7083_63# 0.05469f
C227 m2_2396_n2595# 1bitblock$2$4_0/m2_7791_79# 0.01632f
C228 1bitblock$2$4_0/a_2419_63# 1bitblock$1$4_0/a_3498_3# 0
C229 m2_5443_n3913# m2_1701_n784# 0.03676f
C230 m1_8729_n3942# m2_1701_n784# 0.03255f
C231 m2_2396_n2595# 1bitblock$1$4_0/a_7410_63# 0.00161f
C232 AND4$5_0/a_704_n441# m2_1701_n784# 0.01591f
C233 m1_14167_n1145# m1_10807_n176# 0.08339f
C234 1bitblock$7_0/a_2861_391# 1bitblock$7_0/a_705_407# -0
C235 1bitblock$2$4_0/a_2419_63# 1bitblock$1$4_0/a_2419_63# 0.00365f
C236 1bitblock$2$4_0/a_9050_63# m2_2396_n2595# 0.00483f
C237 1bitblock$7_0/a_378_271# 1bitblock$1$4_0/a_705_407# 0
C238 1bitblock$7_0/a_705_407# 1bitblock$1$4_0/a_378_271# 0
C239 1bitblock$7_0/a_10363_63# m1_14167_n1145# 0.00489f
C240 m2_2396_n2595# m1_10807_n176# 0
C241 m1_8729_n3942# 1bitblock$1$4_0/a_8723_63# 0.09524f
C242 m1_14167_n1145# 1bitblock$7_0/a_8361_407# 0.03596f
C243 m2_2396_n2595# 1bitblock$2$4_0/a_9609_407# 0.09632f
C244 1bitblock$7_0/a_11922_3# m1_14167_n1145# 0.01214f
C245 1bitblock$3$4_0/a_378_271# m1_13543_n1146# 0.00199f
C246 1bitblock$3$4_0/a_5042_407# m1_n563_n4361# 0
C247 m1_14167_n1145# 1bitblock$7_0/a_7083_63# 0.00482f
C248 1bitblock$2$4_0/a_378_271# 1bitblock$1$4_0/a_378_271# 0.00593f
C249 m1_8729_n3942# 1bitblock$7_0/a_9408_n37# 0
C250 1bitblock$7_0/a_1845_466# m1_14167_n1145# 0.01466f
C251 1bitblock$7_0/a_10906_466# m1_10807_n176# 0.00242f
C252 1bitblock$2$4_0/a_11480_63# m2_2396_n2595# 0.00938f
C253 1bitblock$7_0/a_378_271# 1bitblock$1$4_0/a_160_63# 0.00372f
C254 1bitblock$7_0/a_160_63# 1bitblock$1$4_0/a_378_271# 0.00373f
C255 m1_n563_n4361# 1bitblock$3$4_0/a_3498_3# -0.0086f
C256 m1_13543_n1146# 1bitblock$3$4_0/a_9609_407# 0.10003f
C257 m2_5443_n3913# 1bitblock$3$4_0/a_7083_63# 0.00109f
C258 m1_8729_n3942# 1bitblock$3$4_0/a_9408_n37# 0
C259 1bitblock$1$4_0/a_1262_n37# m2_1701_n784# 0
C260 m2_2396_n2595# 1bitblock$2$4_0/a_8361_407# 0.03425f
C261 m1_8729_n3942# 1bitblock$3$4_0/a_7083_63# 0.0537f
C262 1bitblock$7_0/m2_24_342# 1bitblock$1$4_0/m2_24_342# 0.16333f
C263 1bitblock$7_0/a_11922_391# m1_14167_n1145# 0.00712f
C264 1bitblock$2$4_0/a_4290_63# m2_5443_n3913# 0.00738f
C265 m2_2396_n2595# m1_14167_n1145# 0.00193f
C266 m1_13543_n1146# 1bitblock$3$4_0/a_10363_63# 0.00478f
C267 m1_14167_n1145# 1bitblock$7_0/a_8723_63# 0.0292f
C268 m2_2396_n2595# 1bitblock$2$4_0/a_7083_63# 0.00471f
C269 1bitblock$3$4_0/a_8723_63# 1bitblock$3$4_0/m2_9431_79# -0
C270 1bitblock$2$4_0/m2_24_342# m2_2396_n2595# 0.00302f
C271 1bitblock$2$4_0/a_2861_3# m2_2396_n2595# 0.01973f
C272 m1_10807_n176# m2_14516_n651# 0.13336f
C273 1bitblock$3$4_0/a_9050_63# m1_8729_n3942# 0.01697f
C274 m2_5443_n3913# 1bitblock$1$4_0/a_4650_n37# 0.00119f
C275 m1_n563_n4361# 1bitblock$1$4_0/a_5768_63# 0
C276 m1_13543_n1146# 1bitblock$3$4_0/m2_9431_79# 0.0201f
C277 m1_n563_n4361# 1bitblock$1$4_0/m2_7791_79# -0
C278 m1_13543_n1146# 1bitblock$3$4_0/a_11922_391# 0.00701f
C279 1bitblock$7_0/a_10906_466# m1_14167_n1145# 0.01125f
C280 1bitblock$3$4_0/a_1845_466# m1_n563_n4361# 0
C281 1bitblock$7_0/a_510_63# m2_1701_n784# 0
C282 m1_14167_n1145# 1bitblock$1$4_0/a_510_63# 0
C283 1bitblock$3$4_0/a_1845_466# 1bitblock$2$4_0/a_1845_466# 0.00184f
C284 1bitblock$7_0/m2_24_342# 1bitblock$7_0/a_3498_3# -0
C285 m2_2396_n2595# 1bitblock$2$4_0/a_8723_63# 0.02885f
C286 1bitblock$3$4_0/m2_6151_79# m1_n563_n4361# 0
C287 1bitblock$2$4_0/m2_24_342# 1bitblock$1$4_0/a_510_63# 0
C288 1bitblock$7_0/m2_24_342# 1bitblock$7_0/a_160_63# -0
C289 m1_13543_n1146# 1bitblock$3$4_0/a_10906_466# 0.01097f
C290 1bitblock$3$4_0/a_2419_63# 1bitblock$3$4_0/a_3498_3# -0
C291 m1_14167_n1145# m2_14516_n651# 0.09216f
C292 m1_13543_n1146# 1bitblock$2$4_0/a_1262_n37# 0
C293 1bitblock$7_0/a_7410_63# 1bitblock$7_0/m2_7791_79# 0
C294 m1_n563_n4361# m1_12486_242# 0.12729f
C295 1bitblock$3$4_0/a_3940_63# 1bitblock$2$4_0/a_3940_63# 0.01104f
C296 1bitblock$3$4_0/a_160_63# 1bitblock$2$4_0/m2_24_342# 0.00437f
C297 m2_2396_n2595# m2_14516_n651# 0.00583f
C298 m2_5443_n3913# 1bitblock$7_0/a_5768_63# 0.01316f
C299 m1_8729_n3942# 1bitblock$7_0/m2_7791_79# 0.01993f
C300 m2_5443_n3913# 1bitblock$2$4_0/a_6128_n37# 0
C301 1bitblock$2$4_0/a_378_271# m1_13543_n1146# 0.0025f
C302 m1_8729_n3942# 1bitblock$7_0/a_9800_n37# 0.00139f
C303 1bitblock$3$4_0/a_160_63# m2_2396_n2595# 0.00103f
C304 m2_5443_n3913# 1bitblock$3$4_0/a_4290_63# 0.00473f
C305 m2_5443_n3913# 1bitblock$1$4_0/a_4290_63# 0.00738f
C306 1bitblock$7_0/a_2861_3# m1_14167_n1145# 0.0205f
C307 m1_n563_n4361# 1bitblock$1$4_0/a_11922_3# 0.00267f
C308 m1_8729_n3942# 1bitblock$2$4_0/m2_7791_79# 0.02388f
C309 m1_12484_n953# AND4$5_0/a_518_229# 0.00876f
C310 AND4$5_0/a_1120_n441# m2_1701_n784# 0.00916f
C311 1bitblock$3$4_0/a_510_63# m2_2396_n2595# 0
C312 m1_n563_n4361# 1bitblock$1$4_0/a_7083_63# 0
C313 MUX21$4_0/a_157_63# m2_1701_n784# 0
C314 1bitblock$2$4_0/a_2861_391# m2_2396_n2595# 0.01578f
C315 m1_8729_n3942# 1bitblock$1$4_0/a_7410_63# 0.00637f
C316 1bitblock$3$4_0/a_1262_n37# 1bitblock$2$4_0/a_705_407# 0
C317 m1_8729_n3942# 1bitblock$2$4_0/a_9050_63# 0.02224f
C318 m1_n563_n4361# 1bitblock$1$4_0/a_1845_466# 0.00107f
C319 m1_n563_n4361# m2_1701_n784# 0.08054f
C320 m1_13543_n1146# 1bitblock$2$4_0/a_160_63# 0.00107f
C321 1bitblock$2$4_0/a_1845_466# 1bitblock$1$4_0/a_1845_466# 0.00145f
C322 1bitblock$2$4_0/a_1845_466# m2_1701_n784# 0.0015f
C323 m2_5443_n3913# m1_10807_n176# 0.05217f
C324 m1_8729_n3942# m1_10807_n176# 0.0504f
C325 m1_13543_n1146# AND4$5_0/a_518_229# 0.05606f
C326 m1_8729_n3942# 1bitblock$2$4_0/a_9609_407# 0.01866f
C327 m2_5443_n3913# 1bitblock$1$4_0/a_5042_n37# 0
C328 AND4$5_0/a_518_229# AND4$5_0/a_912_n441# -0
C329 1bitblock$2$4_0/a_11922_391# m1_12484_n953# 0.00755f
C330 m1_n563_n4361# 1bitblock$1$4_0/a_8723_63# -0.00527f
C331 m1_8729_n3942# 1bitblock$7_0/a_10363_63# 0.00105f
C332 1bitblock$2$4_0/a_705_407# m2_1701_n784# 0.00123f
C333 m1_8729_n3942# 1bitblock$7_0/a_8361_407# 0
C334 1bitblock$2$4_0/a_11922_3# 1bitblock$1$4_0/a_11922_3# 0
C335 1bitblock$3$4_0/m2_24_342# 1bitblock$2$4_0/m2_24_342# 0.14833f
C336 1bitblock$7_0/a_7410_63# m1_14167_n1145# 0.00163f
C337 m2_5443_n3913# 1bitblock$7_0/a_7083_63# 0.00107f
C338 1bitblock$3$4_0/a_2861_3# m1_13543_n1146# 0.01984f
C339 m1_8729_n3942# 1bitblock$7_0/a_7083_63# 0.05365f
C340 1bitblock$3$4_0/a_10906_n37# m1_13543_n1146# 0.00152f
C341 1bitblock$3$4_0/m2_24_342# m2_2396_n2595# 0.00389f
C342 m1_8729_n3942# 1bitblock$2$4_0/a_8361_407# 0.00891f
C343 m1_n563_n4361# 1bitblock$1$4_0/a_10906_466# 0.00111f
C344 m2_5443_n3913# m1_14167_n1145# 0.00325f
C345 1bitblock$2$4_0/a_10906_466# m1_12484_n953# 0.0176f
C346 m1_8729_n3942# m1_14167_n1145# 0.01252f
C347 m2_5443_n3913# 1bitblock$2$4_0/a_7083_63# 0.00187f
C348 1bitblock$1$4_0/m2_7791_79# 1bitblock$1$4_0/m2_9431_79# -0.00474f
C349 AND4$5_0/a_704_n441# m1_14167_n1145# 0.01112f
C350 m1_8729_n3942# 1bitblock$2$4_0/a_7083_63# 0.0547f
C351 1bitblock$2$4_0/a_3498_3# m2_1701_n784# 0.0012f
C352 1bitblock$2$4_0/a_4290_63# m1_n563_n4361# 0
C353 m2_5443_n3913# m2_2396_n2595# 0.06231f
C354 m1_8729_n3942# m2_2396_n2595# 0.09192f
C355 m1_8729_n3942# 1bitblock$7_0/a_8723_63# 0.07922f
C356 m2_5443_n3913# 1bitblock$2$4_0/a_6520_n37# 0.00151f
C357 1bitblock$1$4_0/a_2419_63# m1_12486_242# -0.00165f
C358 m1_13543_n1146# 1bitblock$2$4_0/a_3940_63# 0
C359 MUX21$4_0/a_517_n37# m1_14167_n1145# 0
C360 m1_n563_n4361# 1bitblock$2$4_0/a_510_63# 0
C361 1bitblock$3$4_0/a_3940_63# m1_13543_n1146# 0
C362 m1_8729_n3942# 1bitblock$3$4_0/m2_7791_79# 0.01998f
C363 m1_8729_n3942# 1bitblock$2$4_0/a_8723_63# 0.09622f
C364 m2_1701_n784# 1bitblock$1$4_0/m2_6151_79# 0
C365 1bitblock$1$4_0/a_10906_n37# m1_12486_242# 0.00484f
C366 1bitblock$3$4_0/a_7410_63# m1_13543_n1146# 0.0016f
C367 m2_5443_n3913# 1bitblock$3$4_0/a_5042_n37# 0
C368 m1_n563_n4361# 1bitblock$1$4_0/a_2861_3# 0.00101f
C369 1bitblock$7_0/a_1262_n37# m2_1701_n784# 0
C370 m1_14167_n1145# 1bitblock$1$4_0/a_1262_n37# 0
C371 1bitblock$1$4_0/a_3498_3# m2_1701_n784# -0.0052f
C372 1bitblock$2$4_0/a_2419_63# 1bitblock$3$4_0/a_2861_3# 0
C373 1bitblock$1$4_0/a_160_63# m2_1701_n784# 0
C374 1bitblock$1$4_0/a_2419_63# m2_1701_n784# 0.4677f
C375 1bitblock$1$4_0/a_11480_63# m1_12486_242# 0.01269f
C376 AND4$5_0/a_704_n441# m2_14516_n651# 0.00119f
C377 m2_5443_n3913# 1bitblock$7_0/a_4650_n37# 0.00119f
C378 1bitblock$2$4_0/a_510_63# 1bitblock$3$4_0/a_705_407# 0
C379 m2_1701_n784# 1bitblock$1$4_0/m2_9431_79# 0
C380 m1_n563_n4361# 1bitblock$7_0/m2_7791_79# -0
C381 m2_5443_n3913# 1bitblock$2$4_0/a_5768_63# 0.01877f
C382 m1_n563_n4361# 1bitblock$1$4_0/a_4290_63# 0
C383 1bitblock$7_0/a_510_63# m1_14167_n1145# 0.00107f
C384 MUX21$4_0/a_517_n37# m2_14516_n651# 0
C385 1bitblock$3$4_0/a_3498_3# 1bitblock$3$4_0/m2_9431_79# -0
C386 1bitblock$2$4_0/a_510_63# 1bitblock$1$4_0/a_705_407# 0
C387 m1_n563_n4361# 1bitblock$2$4_0/m2_7791_79# -0
C388 1bitblock$1$4_0/m2_9431_79# 1bitblock$1$4_0/a_8723_63# -0
C389 1bitblock$2$4_0/a_2419_63# 1bitblock$3$4_0/a_3940_63# 0
C390 m2_1701_n784# 1bitblock$1$4_0/a_5042_407# 0.02321f
C391 m1_n563_n4361# 1bitblock$1$4_0/a_7410_63# 0
C392 m1_n563_n4361# 1bitblock$2$4_0/a_9050_63# 0
C393 m1_13543_n1146# m1_12484_n953# 0.08498f
C394 m1_8729_n3942# 1bitblock$2$4_0/a_7768_n37# 0
C395 m1_n563_n4361# m1_10807_n176# 0.00229f
C396 m2_10721_n3315# m2_2396_n2595# 0.01659f
C397 1bitblock$3$4_0/a_8723_63# m1_13543_n1146# 0.02911f
C398 m2_1701_n784# 1bitblock$1$4_0/a_3940_63# 0.00175f
C399 m2_5443_n3913# 1bitblock$7_0/a_4290_63# 0.00478f
C400 m1_12480_n3815# m1_14167_n1145# 0
C401 m1_n563_n4361# 1bitblock$7_0/a_11922_3# 0
C402 1bitblock$2$4_0/a_11480_63# m1_n563_n4361# 0
C403 MUX21$4_0/a_157_63# m1_14167_n1145# 0.0056f
C404 m1_8729_n3942# 1bitblock$7_0/a_7410_63# 0.00465f
C405 m2_2396_n2595# AND4$5_0/a_1120_n441# 0
C406 m1_n563_n4361# 1bitblock$7_0/a_1845_466# 0
C407 m1_n563_n4361# m1_14167_n1145# 0.68409f
C408 m1_8729_n3942# m2_5443_n3913# 0.00777f
C409 m1_8729_n3942# 1bitblock$1$4_0/a_7768_n37# 0
C410 m1_n563_n4361# 1bitblock$2$4_0/a_7083_63# 0
C411 m2_2396_n2595# MUX21$4_0/a_157_63# 0
C412 m1_n563_n4361# 1bitblock$2$4_0/m2_24_342# 0.03105f
C413 m2_5443_n3913# 1bitblock$3$4_0/a_6128_n37# 0
C414 m1_n563_n4361# 1bitblock$2$4_0/a_2861_3# 0.00101f
C415 m2_10721_n3315# m2_14516_n651# 0.00204f
C416 m2_5443_n3913# 1bitblock$7_0/a_5042_n37# 0
C417 m1_n563_n4361# m2_2396_n2595# 1.58588f
C418 m1_n563_n4361# 1bitblock$7_0/a_8723_63# -0.0053f
C419 1bitblock$2$4_0/a_1845_466# m2_2396_n2595# 0.01396f
C420 1bitblock$2$4_0/a_2419_63# m1_12484_n953# 0.03322f
C421 m1_n563_n4361# 1bitblock$3$4_0/m2_7791_79# -0
C422 m1_n563_n4361# 1bitblock$2$4_0/a_8723_63# -0.0053f
C423 1bitblock$2$4_0/a_2861_3# 1bitblock$2$4_0/a_705_407# -0
C424 m2_2396_n2595# 1bitblock$2$4_0/a_705_407# 0.00549f
C425 m1_n563_n4361# 1bitblock$1$4_0/a_510_63# 0
C426 1bitblock$2$4_0/a_2419_63# m1_13543_n1146# 0.00534f
C427 1bitblock$3$4_0/a_2861_3# 1bitblock$3$4_0/a_3498_3# -0
C428 m1_12480_n3815# m2_14516_n651# 0
C429 AND4$5_0/a_1120_n441# m2_14516_n651# 0.00515f
C430 MUX21$4_0/a_157_63# m2_14516_n651# 0.01121f
C431 m1_8729_n3942# 1bitblock$2$4_0/a_8160_n37# 0.00164f
C432 1bitblock$3$4_0/a_705_407# 1bitblock$2$4_0/m2_24_342# 0
C433 m2_2396_n2595# 1bitblock$2$4_0/a_11922_3# 0.01144f
C434 1bitblock$1$4_0/m2_24_342# m2_1701_n784# 0.02455f
C435 1bitblock$2$4_0/m2_24_342# 1bitblock$2$4_0/a_3498_3# -0
C436 1bitblock$2$4_0/a_2861_3# 1bitblock$2$4_0/a_3498_3# -0
C437 m1_n563_n4361# m2_14516_n651# 0.16195f
C438 1bitblock$2$4_0/a_2861_3# 1bitblock$3$4_0/a_2419_63# 0
C439 m1_10807_n176# 1bitblock$1$4_0/a_2419_63# 0.01284f
C440 1bitblock$7_0/a_2419_63# m1_12486_242# 0.05407f
C441 1bitblock$3$4_0/a_705_407# m2_2396_n2595# 0
C442 m1_14167_n1145# 1bitblock$1$4_0/a_705_407# 0
C443 1bitblock$7_0/a_705_407# m2_1701_n784# 0
C444 1bitblock$3$4_0/a_2419_63# m2_2396_n2595# 0.00529f
C445 1bitblock$2$4_0/a_705_407# 1bitblock$1$4_0/a_510_63# 0
C446 m2_2396_n2595# 1bitblock$2$4_0/a_3498_3# 1.47226f
C447 m1_n563_n4361# 1bitblock$3$4_0/a_160_63# 0.02548f
C448 1bitblock$1$4_0/a_4290_63# 1bitblock$1$4_0/a_5042_407# 0
C449 1bitblock$2$4_0/m2_24_342# 1bitblock$1$4_0/a_705_407# 0
C450 m2_2396_n2595# 1bitblock$1$4_0/a_705_407# 0.00123f
C451 m1_n563_n4361# 1bitblock$2$4_0/a_5768_63# 0
C452 1bitblock$7_0/m2_6151_79# m2_1701_n784# 0
C453 1bitblock$7_0/a_10906_n37# m1_12486_242# 0.00168f
C454 1bitblock$7_0/a_2419_63# 1bitblock$1$4_0/a_11922_3# 0
C455 1bitblock$2$4_0/a_378_271# m2_1701_n784# 0
C456 m1_8729_n3942# 1bitblock$1$4_0/a_8160_n37# 0.00164f
C457 m1_14167_n1145# 1bitblock$1$4_0/a_3498_3# 0
C458 1bitblock$7_0/a_3498_3# m2_1701_n784# 0
C459 1bitblock$3$4_0/a_160_63# 1bitblock$2$4_0/a_705_407# 0
C460 m2_2396_n2595# 1bitblock$2$4_0/a_10906_n37# 0.00148f
C461 m2_5443_n3913# m2_10721_n3315# 0.04805f
C462 m1_14167_n1145# 1bitblock$1$4_0/a_160_63# 0.00107f
C463 1bitblock$7_0/a_160_63# m2_1701_n784# 0.00109f
C464 1bitblock$7_0/a_2419_63# m2_1701_n784# 0.36366f
C465 m1_14167_n1145# 1bitblock$1$4_0/a_2419_63# 0.004f
C466 1bitblock$7_0/a_11480_63# m1_12486_242# 0.00896f
C467 m1_8729_n3942# m2_10721_n3315# 0.0463f
C468 m2_2396_n2595# 1bitblock$1$4_0/a_3498_3# 1.69486f
C469 1bitblock$2$4_0/m2_24_342# 1bitblock$1$4_0/a_160_63# 0
C470 AND4$5_0/a_518_229# 1bitblock$1$4_0/a_11922_3# 0.0046f
C471 1bitblock$3$4_0/a_9050_63# 1bitblock$3$4_0/m2_9431_79# -0
C472 1bitblock$3$4_0/a_510_63# 1bitblock$2$4_0/a_705_407# 0
C473 MUX21$4_0/a_718_407# m2_1701_n784# 0
C474 1bitblock$2$4_0/a_2861_391# 1bitblock$2$4_0/a_705_407# -0
C475 1bitblock$2$4_0/a_1845_n37# m1_13543_n1146# 0.00179f
C476 m2_2396_n2595# 1bitblock$1$4_0/a_2419_63# 0.01135f
C477 1bitblock$3$4_0/a_160_63# 1bitblock$3$4_0/a_705_407# 0
C478 1bitblock$7_0/m2_9431_79# m2_1701_n784# 0
C479 AND4$5_0/a_518_229# m2_1701_n784# 0.02153f
C480 1bitblock$2$4_0/a_510_63# 1bitblock$1$4_0/m2_24_342# 0
C481 1bitblock$7_0/a_3940_63# m1_12486_242# 0
C482 1bitblock$1$4_0/a_9050_63# 1bitblock$1$4_0/m2_7791_79# -0
C483 1bitblock$2$4_0/a_11480_63# 1bitblock$1$4_0/a_11480_63# 0.00182f
C484 m2_2396_n2595# 1bitblock$1$4_0/m2_9431_79# 0.0203f
C485 1bitblock$3$4_0/m2_24_342# m1_n563_n4361# 0.018f
C486 m2_2396_n2595# 1bitblock$1$4_0/a_10906_n37# 0.00153f
C487 1bitblock$7_0/a_5042_407# m2_1701_n784# 0.01787f
C488 1bitblock$3$4_0/a_870_n37# 1bitblock$2$4_0/a_160_63# 0.00135f
C489 m2_5443_n3913# m1_n563_n4361# 0.18639f
C490 m1_8729_n3942# m1_n563_n4361# 0.27477f
C491 m1_8729_n3942# 1bitblock$3$4_0/a_8361_407# 0
C492 m2_2396_n2595# 1bitblock$1$4_0/a_11480_63# 0.00982f
C493 1bitblock$3$4_0/m2_24_342# 1bitblock$2$4_0/a_705_407# 0
C494 1bitblock$1$4_0/a_2419_63# m2_14516_n651# 0.00162f
C495 m1_14167_n1145# 1bitblock$1$4_0/a_3940_63# 0
C496 1bitblock$7_0/a_3940_63# m2_1701_n784# 0.00164f
C497 1bitblock$3$4_0/a_11480_63# m1_13543_n1146# 0.0097f
C498 1bitblock$2$4_0/a_10363_63# m2_2396_n2595# 0.00459f
C499 MUX21$4_0/m2_540_79# m1_10807_n176# 0.00138f
C500 m1_13543_n1146# 1bitblock$3$4_0/a_3498_3# 1.66674f
C501 1bitblock$7_0/a_2419_63# 1bitblock$1$4_0/a_2861_3# 0
C502 1bitblock$7_0/a_2861_3# 1bitblock$1$4_0/a_2419_63# 0
C503 m1_8729_n3942# 1bitblock$7_0/a_7768_n37# 0
C504 1bitblock$1$4_0/a_378_271# m2_1701_n784# 0.00848f
C505 1bitblock$3$4_0/a_378_271# m2_2396_n2595# 0.00248f
C506 1bitblock$1$4_0/a_11480_63# m2_14516_n651# 0
C507 1bitblock$1$4_0/a_9050_63# m2_1701_n784# 0
C508 m2_5443_n3913# 1bitblock$3$4_0/a_2419_63# 0.00867f
C509 m2_2396_n2595# 1bitblock$1$4_0/a_2861_391# 0.00705f
C510 m2_5443_n3913# 1bitblock$2$4_0/a_3498_3# 0.05092f
C511 m1_8729_n3942# 1bitblock$2$4_0/a_3498_3# 0.00389f
C512 m1_8729_n3942# 1bitblock$3$4_0/a_2419_63# 0.00663f
C513 1bitblock$3$4_0/a_1845_466# m1_13543_n1146# 0.01449f
C514 1bitblock$2$4_0/a_10906_466# 1bitblock$1$4_0/a_10906_466# 0.00145f
C515 MUX21$4_0/m2_540_79# m1_14167_n1145# 0.01323f
C516 m1_12484_n953# m1_12486_242# 0.0157f
C517 1bitblock$3$4_0/a_2861_391# 1bitblock$3$4_0/a_705_407# -0
C518 1bitblock$3$4_0/a_11922_3# m2_10721_n3315# 0.01722f
C519 m2_5443_n3913# 1bitblock$1$4_0/m2_6151_79# 0.01607f
C520 1bitblock$3$4_0/m2_7791_79# 1bitblock$3$4_0/a_9609_407# -0
C521 m1_12480_n3815# m2_10721_n3315# 0.02463f
C522 1bitblock$7_0/m2_7791_79# 1bitblock$7_0/m2_9431_79# -0.00444f
C523 m2_5443_n3913# 1bitblock$1$4_0/a_3498_3# 0.05026f
C524 1bitblock$7_0/m2_24_342# 1bitblock$1$4_0/a_1845_466# 0
C525 1bitblock$7_0/m2_24_342# m2_1701_n784# 0.01532f
C526 m1_8729_n3942# 1bitblock$1$4_0/a_3498_3# 0.00389f
C527 m1_12484_n953# 1bitblock$1$4_0/a_11922_3# 0.01185f
C528 MUX21$4_0/a_909_n37# m2_14516_n651# 0
C529 m2_5443_n3913# 1bitblock$1$4_0/a_2419_63# 0.00541f
C530 m1_n563_n4361# m2_10721_n3315# 0.09259f
C531 1bitblock$1$4_0/m2_24_342# m1_14167_n1145# 0.00373f
C532 m1_8729_n3942# 1bitblock$1$4_0/a_2419_63# 0.00237f
C533 1bitblock$3$4_0/a_1262_n37# m1_13543_n1146# -0
C534 1bitblock$7_0/a_2419_63# m1_10807_n176# 0.07066f
C535 1bitblock$2$4_0/m2_24_342# 1bitblock$1$4_0/m2_24_342# 0.0286f
C536 1bitblock$7_0/a_705_407# m1_14167_n1145# 0.00558f
C537 1bitblock$3$4_0/a_1845_n37# m2_2396_n2595# 0.00179f
C538 m2_5443_n3913# 1bitblock$1$4_0/a_6721_407# 0.01358f
C539 1bitblock$3$4_0/m2_7791_79# 1bitblock$3$4_0/m2_9431_79# -0.00447f
C540 m1_12484_n953# m2_1701_n784# 0.00165f
C541 1bitblock$2$4_0/a_510_63# 1bitblock$1$4_0/a_378_271# 0
C542 m1_12480_n3815# 1bitblock$3$4_0/a_11922_3# 0.00447f
C543 m2_2396_n2595# 1bitblock$1$4_0/m2_24_342# 0
C544 1bitblock$2$4_0/m2_7791_79# 1bitblock$2$4_0/m2_9431_79# -0.00474f
C545 MUX21$4_0/a_718_407# m1_10807_n176# 0
C546 m1_8729_n3942# 1bitblock$3$4_0/a_9800_n37# 0.0014f
C547 m1_8729_n3942# 1bitblock$1$4_0/m2_9431_79# 0.02467f
C548 m1_13543_n1146# 1bitblock$1$4_0/a_11922_3# 0
C549 1bitblock$7_0/a_10906_n37# m1_10807_n176# 0.00266f
C550 m1_12484_n953# 1bitblock$1$4_0/a_11922_391# 0.00359f
C551 m1_10807_n176# AND4$5_0/a_518_229# 0
C552 MUX21$4_0/m2_540_79# m2_14516_n651# 0.00787f
C553 m1_n563_n4361# 1bitblock$3$4_0/a_11922_3# 0
C554 m2_5443_n3913# 1bitblock$2$4_0/a_4650_n37# 0.00119f
C555 m1_12480_n3815# m1_n563_n4361# 0.04173f
C556 1bitblock$7_0/a_1845_466# 1bitblock$7_0/a_3498_3# -0
C557 1bitblock$7_0/a_3498_3# m1_14167_n1145# 1.79259f
C558 m1_8729_n3942# 1bitblock$7_0/a_8160_n37# 0.00164f
C559 m2_5443_n3913# 1bitblock$1$4_0/a_5042_407# 0.06275f
C560 m1_13543_n1146# m2_1701_n784# 0.0051f
C561 m1_n563_n4361# MUX21$4_0/a_157_63# 0.00149f
C562 AND4$5_0/a_912_n441# m2_1701_n784# 0.01194f
C563 1bitblock$7_0/a_2419_63# m1_14167_n1145# 0.07947f
C564 1bitblock$2$4_0/a_378_271# m2_2396_n2595# 0.00194f
C565 1bitblock$7_0/a_160_63# m1_14167_n1145# 0
C566 1bitblock$7_0/a_11480_63# m1_10807_n176# 0
C567 m2_10721_n3315# 1bitblock$2$4_0/a_11922_3# 0.00362f
C568 1bitblock$7_0/a_510_63# 1bitblock$1$4_0/a_705_407# 0
C569 1bitblock$7_0/a_705_407# 1bitblock$1$4_0/a_510_63# 0
C570 m1_12484_n953# 1bitblock$1$4_0/a_10906_466# 0
C571 MUX21$4_0/a_718_407# m1_14167_n1145# 0
C572 m1_n563_n4361# 1bitblock$2$4_0/a_1845_466# 0.00109f
C573 m2_10721_n3315# 1bitblock$3$4_0/a_2419_63# 0.02256f
C574 m2_2396_n2595# 1bitblock$7_0/a_2419_63# 0
C575 m1_14167_n1145# 1bitblock$7_0/m2_9431_79# 0.02029f
C576 1bitblock$7_0/a_10906_n37# m1_14167_n1145# 0.00154f
C577 1bitblock$2$4_0/m2_24_342# 1bitblock$2$4_0/a_160_63# 0
C578 m2_5443_n3913# 1bitblock$1$4_0/a_3940_63# 0.00421f
C579 m1_14167_n1145# AND4$5_0/a_518_229# 0.01521f
C580 m1_8729_n3942# 1bitblock$2$4_0/a_10363_63# 0.00192f
C581 MUX21$4_0/a_718_407# m2_2396_n2595# 0.00276f
C582 1bitblock$2$4_0/a_378_271# 1bitblock$1$4_0/a_510_63# 0
C583 1bitblock$2$4_0/a_160_63# m2_2396_n2595# 0
C584 1bitblock$3$4_0/a_11922_3# 1bitblock$2$4_0/a_11922_3# 0.0017f
C585 1bitblock$7_0/m2_9431_79# 1bitblock$7_0/a_8723_63# -0
C586 m1_n563_n4361# 1bitblock$2$4_0/a_705_407# 0.00817f
C587 m2_2396_n2595# AND4$5_0/a_518_229# 0.05061f
C588 1bitblock$7_0/a_11480_63# m1_14167_n1145# 0.00995f
C589 1bitblock$7_0/a_510_63# 1bitblock$1$4_0/a_160_63# 0
C590 1bitblock$7_0/a_160_63# 1bitblock$1$4_0/a_510_63# 0
C591 m1_13543_n1146# 1bitblock$3$4_0/a_7083_63# 0.0048f
C592 m2_2396_n2595# 1bitblock$2$4_0/m2_9431_79# 0.01952f
C593 m1_n563_n4361# 1bitblock$2$4_0/a_11922_3# 0.00103f
C594 1bitblock$7_0/a_2861_3# 1bitblock$7_0/a_705_407# -0
C595 1bitblock$3$4_0/a_160_63# 1bitblock$2$4_0/a_378_271# 0.00362f
C596 1bitblock$2$4_0/a_2419_63# m2_1701_n784# 0
C597 m1_n563_n4361# 1bitblock$3$4_0/a_705_407# -0
C598 1bitblock$3$4_0/a_2861_3# m2_2396_n2595# 0.00145f
C599 1bitblock$2$4_0/a_510_63# m1_13543_n1146# 0
C600 m1_n563_n4361# 1bitblock$2$4_0/a_3498_3# 0.02184f
C601 m1_n563_n4361# 1bitblock$3$4_0/a_2419_63# 0
C602 1bitblock$2$4_0/m2_9431_79# 1bitblock$2$4_0/a_8723_63# -0
C603 m1_14167_n1145# 1bitblock$7_0/a_3940_63# 0
C604 m1_8729_n3942# 1bitblock$3$4_0/a_9609_407# 0.00145f
C605 1bitblock$3$4_0/a_9050_63# m1_13543_n1146# 0.00508f
C606 1bitblock$2$4_0/a_1845_466# 1bitblock$2$4_0/a_3498_3# -0
C607 1bitblock$2$4_0/a_11922_391# m2_2396_n2595# 0.00681f
C608 m1_8729_n3942# 1bitblock$3$4_0/a_10363_63# 0.00105f
C609 m1_n563_n4361# 1bitblock$1$4_0/a_705_407# 0.00876f
C610 m2_5443_n3913# 1bitblock$2$4_0/a_5042_n37# 0
C611 1bitblock$7_0/a_2861_3# 1bitblock$7_0/a_3498_3# -0
C612 1bitblock$3$4_0/a_160_63# 1bitblock$2$4_0/a_160_63# 0.0454f
C613 AND4$5_0/a_518_229# m2_14516_n651# 0.01804f
C614 1bitblock$7_0/a_2861_391# m1_14167_n1145# 0.01608f
C615 m1_8729_n3942# 1bitblock$3$4_0/m2_9431_79# 0.02041f
C616 m1_n563_n4361# 1bitblock$1$4_0/m2_6151_79# 0
C617 m2_2396_n2595# 1bitblock$2$4_0/a_3940_63# 0
C618 1bitblock$2$4_0/a_10906_466# m2_2396_n2595# 0.01059f
C619 1bitblock$7_0/a_378_271# m2_1701_n784# 0.00257f
C620 m1_14167_n1145# 1bitblock$1$4_0/a_378_271# 0.00256f
C621 1bitblock$3$4_0/a_510_63# 1bitblock$2$4_0/a_160_63# 0
C622 1bitblock$2$4_0/a_705_407# 1bitblock$1$4_0/a_705_407# 0.04927f
C623 1bitblock$1$4_0/a_1845_n37# m2_1701_n784# 0.00561f
C624 m1_n563_n4361# 1bitblock$1$4_0/a_3498_3# 0.03072f
C625 1bitblock$7_0/a_9050_63# m2_1701_n784# 0
C626 1bitblock$3$4_0/a_3940_63# m2_2396_n2595# 0
C627 1bitblock$2$4_0/m2_24_342# 1bitblock$1$4_0/a_378_271# 0
C628 m1_n563_n4361# 1bitblock$1$4_0/a_2419_63# 0.00292f
C629 m1_n563_n4361# 1bitblock$1$4_0/a_160_63# 0.0263f
C630 1bitblock$3$4_0/a_2419_63# 1bitblock$3$4_0/a_705_407# -0
C631 m2_2396_n2595# 1bitblock$1$4_0/a_378_271# 0
C632 1bitblock$7_0/a_870_n37# 1bitblock$1$4_0/a_160_63# 0.00138f
C633 1bitblock$7_0/a_160_63# 1bitblock$1$4_0/a_870_n37# 0.00138f
C634 m2_2396_n2595# 1bitblock$1$4_0/a_9050_63# 0.00507f
C635 m1_n563_n4361# 1bitblock$1$4_0/m2_9431_79# -0
C636 1bitblock$3$4_0/a_1845_466# 1bitblock$3$4_0/a_3498_3# -0
C637 1bitblock$2$4_0/a_7410_63# m2_2396_n2595# 0.00156f
C638 m2_5443_n3913# 1bitblock$7_0/m2_6151_79# 0.01043f
C639 1bitblock$2$4_0/a_705_407# 1bitblock$1$4_0/a_160_63# 0
C640 m2_5443_n3913# 1bitblock$7_0/a_3498_3# 0
C641 1bitblock$7_0/m2_24_342# m1_14167_n1145# 0.0031f
C642 m1_n563_n4361# 1bitblock$1$4_0/a_5042_407# 0
C643 m1_8729_n3942# 1bitblock$7_0/a_3498_3# 0.00142f
C644 m2_5443_n3913# 1bitblock$2$4_0/m2_6151_79# 0.01608f
C645 1bitblock$3$4_0/m2_24_342# 1bitblock$2$4_0/a_160_63# 0.00419f
C646 m1_n563_n4361# 1bitblock$1$4_0/a_11480_63# 0
C647 m1_13543_n1146# m1_10807_n176# 0
C648 m2_5443_n3913# 1bitblock$7_0/a_2419_63# 0.00862f
C649 1bitblock$2$4_0/a_11480_63# m1_12484_n953# 0.0167f
C650 m1_8729_n3942# 1bitblock$7_0/a_2419_63# 0.00658f
C651 1bitblock$2$4_0/a_3498_3# 1bitblock$1$4_0/a_3498_3# 0.01312f
C652 1bitblock$7_0/a_7410_63# 1bitblock$7_0/m2_9431_79# -0
C653 1bitblock$7_0/a_4290_63# 1bitblock$7_0/a_5042_407# -0
C654 1bitblock$2$4_0/a_3498_3# 1bitblock$1$4_0/a_2419_63# 0
C655 1bitblock$7_0/a_1262_n37# 1bitblock$1$4_0/a_705_407# 0
C656 1bitblock$7_0/a_705_407# 1bitblock$1$4_0/a_1262_n37# 0
C657 m1_8729_n3942# 1bitblock$3$4_0/a_8160_n37# 0.00163f
C658 m1_8729_n3942# 1bitblock$7_0/m2_9431_79# 0.02012f
C659 m1_n563_n4361# 1bitblock$1$4_0/a_3940_63# 0
C660 m2_5443_n3913# 1bitblock$2$4_0/a_6721_407# 0.01358f
C661 m1_12484_n953# m2_2396_n2595# 0.16107f
C662 1bitblock$1$4_0/a_9609_407# 1bitblock$1$4_0/m2_7791_79# -0
C663 m1_8729_n3942# 1bitblock$2$4_0/m2_9431_79# 0.02467f
C664 m2_5443_n3913# 1bitblock$7_0/a_5042_407# 0.05822f
C665 1bitblock$3$4_0/a_378_271# m1_n563_n4361# 0
C666 m2_10721_n3315# 1bitblock$3$4_0/a_11922_391# 0.00397f
C667 1bitblock$2$4_0/m2_24_342# m1_13543_n1146# 0.00392f
C668 1bitblock$2$4_0/a_2861_3# m1_13543_n1146# 0.00145f
C669 m2_5443_n3913# 1bitblock$2$4_0/a_5042_407# 0.06277f
C670 m1_13543_n1146# m2_2396_n2595# 0.33711f
C671 1bitblock$3$4_0/m2_7791_79# 1bitblock$3$4_0/a_8723_63# 0
C672 m2_2396_n2595# AND4$5_0/a_912_n441# 0.0044f
C673 AND4$5_0/a_1120_n441# VSUBS 0.02626f
C674 AND4$5_0/a_912_n441# VSUBS 0.02949f
C675 AND4$5_0/a_704_n441# VSUBS 0.03642f
C676 m2_14516_n651# VSUBS 2.96205f
C677 AND4$5_0/a_518_229# VSUBS 0.81913f
C678 m1_12486_242# VSUBS 3.28362f
C679 1bitblock$1$4_0/a_7083_63# VSUBS 0.85222f
C680 1bitblock$1$4_0/a_8723_63# VSUBS 0.40722f
C681 1bitblock$1$4_0/m2_9431_79# VSUBS 0.62597f
C682 1bitblock$1$4_0/m2_7791_79# VSUBS 0.61991f
C683 1bitblock$1$4_0/a_9609_407# VSUBS 0.11896f
C684 1bitblock$1$4_0/a_8361_407# VSUBS 0.05045f
C685 1bitblock$1$4_0/m2_6151_79# VSUBS 0.6012f
C686 1bitblock$1$4_0/a_6721_407# VSUBS 0.01523f
C687 1bitblock$1$4_0/a_5042_407# VSUBS 0.79698f
C688 1bitblock$1$4_0/a_3940_63# VSUBS 0.46873f
C689 m2_1701_n784# VSUBS 7.90146f
C690 1bitblock$1$4_0/a_160_63# VSUBS 0.60582f
C691 1bitblock$1$4_0/a_5243_407# VSUBS 0.01459f
C692 1bitblock$1$4_0/a_705_407# VSUBS 0.14113f
C693 1bitblock$1$4_0/a_3498_3# VSUBS 1.27913f
C694 1bitblock$1$4_0/a_10906_n37# VSUBS 0.02232f
C695 1bitblock$1$4_0/a_9800_n37# VSUBS 0.01742f
C696 1bitblock$1$4_0/a_9408_n37# VSUBS 0.01326f
C697 1bitblock$1$4_0/a_8160_n37# VSUBS 0.01743f
C698 1bitblock$1$4_0/a_7768_n37# VSUBS 0.01327f
C699 1bitblock$1$4_0/a_6520_n37# VSUBS 0.01743f
C700 1bitblock$1$4_0/a_6128_n37# VSUBS 0.01327f
C701 1bitblock$1$4_0/a_5042_n37# VSUBS 0.01422f
C702 1bitblock$1$4_0/a_4650_n37# VSUBS 0.01569f
C703 1bitblock$1$4_0/a_11922_3# VSUBS 0.64605f
C704 1bitblock$1$4_0/a_11922_391# VSUBS 0.00119f
C705 1bitblock$1$4_0/a_10906_466# VSUBS 0.59827f
C706 1bitblock$1$4_0/a_11480_63# VSUBS 0.42359f
C707 1bitblock$1$4_0/a_10363_63# VSUBS 0.13924f
C708 1bitblock$1$4_0/a_9050_63# VSUBS 0.55145f
C709 1bitblock$1$4_0/a_7410_63# VSUBS 0.55612f
C710 1bitblock$1$4_0/a_5768_63# VSUBS 0.55881f
C711 1bitblock$1$4_0/a_1845_n37# VSUBS 0.01974f
C712 1bitblock$1$4_0/a_1262_n37# VSUBS 0.0127f
C713 1bitblock$1$4_0/a_870_n37# VSUBS 0.01586f
C714 1bitblock$1$4_0/a_4290_63# VSUBS 0.59067f
C715 1bitblock$1$4_0/a_2861_3# VSUBS 0.62907f
C716 1bitblock$1$4_0/a_1845_466# VSUBS 0.59871f
C717 1bitblock$1$4_0/a_2419_63# VSUBS 6.60418f
C718 1bitblock$1$4_0/a_510_63# VSUBS 0.58168f
C719 1bitblock$1$4_0/a_378_271# VSUBS 1.38973f
C720 1bitblock$1$4_0/m2_24_342# VSUBS 1.99971f
C721 m1_10807_n176# VSUBS 4.87062f
C722 1bitblock$7_0/a_7083_63# VSUBS 0.85222f
C723 1bitblock$7_0/a_8723_63# VSUBS 0.40569f
C724 1bitblock$7_0/m2_9431_79# VSUBS 0.62597f
C725 1bitblock$7_0/m2_7791_79# VSUBS 0.61991f
C726 1bitblock$7_0/a_8361_407# VSUBS 0.05045f
C727 1bitblock$7_0/m2_6151_79# VSUBS 0.6012f
C728 1bitblock$7_0/a_6721_407# VSUBS 0.01523f
C729 1bitblock$7_0/a_5042_407# VSUBS 0.79698f
C730 1bitblock$7_0/a_3940_63# VSUBS 0.46873f
C731 m1_14167_n1145# VSUBS 4.02061f
C732 1bitblock$7_0/a_160_63# VSUBS 0.59457f
C733 1bitblock$7_0/a_5243_407# VSUBS 0.01459f
C734 1bitblock$7_0/a_705_407# VSUBS 0.13654f
C735 1bitblock$7_0/a_3498_3# VSUBS 1.27913f
C736 1bitblock$7_0/a_10906_n37# VSUBS 0.02232f
C737 1bitblock$7_0/a_9800_n37# VSUBS 0.01742f
C738 1bitblock$7_0/a_9408_n37# VSUBS 0.01326f
C739 1bitblock$7_0/a_8160_n37# VSUBS 0.01743f
C740 1bitblock$7_0/a_7768_n37# VSUBS 0.01327f
C741 1bitblock$7_0/a_6520_n37# VSUBS 0.01743f
C742 1bitblock$7_0/a_6128_n37# VSUBS 0.01327f
C743 1bitblock$7_0/a_5042_n37# VSUBS 0.01422f
C744 1bitblock$7_0/a_4650_n37# VSUBS 0.01569f
C745 1bitblock$7_0/a_11922_3# VSUBS 0.64588f
C746 1bitblock$7_0/a_11922_391# VSUBS 0.00119f
C747 1bitblock$7_0/a_10906_466# VSUBS 0.59827f
C748 1bitblock$7_0/a_11480_63# VSUBS 0.42359f
C749 1bitblock$7_0/a_10363_63# VSUBS 0.13924f
C750 1bitblock$7_0/a_9050_63# VSUBS 0.55145f
C751 1bitblock$7_0/a_7410_63# VSUBS 0.55612f
C752 1bitblock$7_0/a_5768_63# VSUBS 0.55881f
C753 1bitblock$7_0/a_1845_n37# VSUBS 0.01974f
C754 1bitblock$7_0/a_1262_n37# VSUBS 0.0127f
C755 1bitblock$7_0/a_870_n37# VSUBS 0.01517f
C756 1bitblock$7_0/a_4290_63# VSUBS 0.59067f
C757 1bitblock$7_0/a_2861_3# VSUBS 0.62907f
C758 1bitblock$7_0/a_1845_466# VSUBS 0.5987f
C759 1bitblock$7_0/a_2419_63# VSUBS 6.63957f
C760 1bitblock$7_0/a_510_63# VSUBS 0.58009f
C761 1bitblock$7_0/a_378_271# VSUBS 1.3862f
C762 1bitblock$7_0/m2_24_342# VSUBS 1.9762f
C763 1bitblock$7_0/a_9609_407# VSUBS 0.11896f
C764 MUX21$4_0/m2_540_79# VSUBS 0.82007f
C765 MUX21$4_0/a_718_407# VSUBS 0.15145f
C766 MUX21$4_0/a_909_n37# VSUBS 0.01743f
C767 MUX21$4_0/a_517_n37# VSUBS 0.01327f
C768 MUX21$4_0/a_1472_63# VSUBS 0.17252f
C769 MUX21$4_0/a_157_63# VSUBS 0.65278f
C770 m1_12484_n953# VSUBS 3.35763f
C771 1bitblock$2$4_0/a_7083_63# VSUBS 0.85965f
C772 1bitblock$2$4_0/a_8723_63# VSUBS 0.40727f
C773 1bitblock$2$4_0/m2_9431_79# VSUBS 0.62602f
C774 1bitblock$2$4_0/m2_7791_79# VSUBS 0.61996f
C775 1bitblock$2$4_0/a_9609_407# VSUBS 0.11896f
C776 1bitblock$2$4_0/a_8361_407# VSUBS 0.05045f
C777 1bitblock$2$4_0/m2_6151_79# VSUBS 0.60126f
C778 1bitblock$2$4_0/a_6721_407# VSUBS 0.01523f
C779 1bitblock$2$4_0/a_5042_407# VSUBS 0.80196f
C780 1bitblock$2$4_0/a_3940_63# VSUBS 0.46875f
C781 m2_2396_n2595# VSUBS 3.96635f
C782 1bitblock$2$4_0/a_160_63# VSUBS 0.60571f
C783 1bitblock$2$4_0/a_5243_407# VSUBS 0.01459f
C784 1bitblock$2$4_0/a_705_407# VSUBS 0.14113f
C785 1bitblock$2$4_0/a_3498_3# VSUBS 1.27919f
C786 1bitblock$2$4_0/a_10906_n37# VSUBS 0.02232f
C787 1bitblock$2$4_0/a_9800_n37# VSUBS 0.01742f
C788 1bitblock$2$4_0/a_9408_n37# VSUBS 0.01326f
C789 1bitblock$2$4_0/a_8160_n37# VSUBS 0.01743f
C790 1bitblock$2$4_0/a_7768_n37# VSUBS 0.01327f
C791 1bitblock$2$4_0/a_6520_n37# VSUBS 0.01743f
C792 1bitblock$2$4_0/a_6128_n37# VSUBS 0.01327f
C793 1bitblock$2$4_0/a_5042_n37# VSUBS 0.01422f
C794 1bitblock$2$4_0/a_4650_n37# VSUBS 0.01569f
C795 1bitblock$2$4_0/a_11922_3# VSUBS 0.64587f
C796 1bitblock$2$4_0/a_11922_391# VSUBS 0.00119f
C797 1bitblock$2$4_0/a_10906_466# VSUBS 0.59833f
C798 1bitblock$2$4_0/a_11480_63# VSUBS 0.42359f
C799 1bitblock$2$4_0/a_10363_63# VSUBS 0.13924f
C800 1bitblock$2$4_0/a_9050_63# VSUBS 0.55151f
C801 1bitblock$2$4_0/a_7410_63# VSUBS 0.55618f
C802 1bitblock$2$4_0/a_5768_63# VSUBS 0.55887f
C803 1bitblock$2$4_0/a_1845_n37# VSUBS 0.01974f
C804 1bitblock$2$4_0/a_1262_n37# VSUBS 0.0127f
C805 1bitblock$2$4_0/a_870_n37# VSUBS 0.01586f
C806 1bitblock$2$4_0/a_4290_63# VSUBS 0.59072f
C807 1bitblock$2$4_0/a_2861_3# VSUBS 0.62907f
C808 1bitblock$2$4_0/a_1845_466# VSUBS 0.59875f
C809 1bitblock$2$4_0/a_2419_63# VSUBS 6.72858f
C810 1bitblock$2$4_0/a_510_63# VSUBS 0.58168f
C811 1bitblock$2$4_0/a_378_271# VSUBS 1.38936f
C812 m1_n563_n4361# VSUBS 0.11736p
C813 1bitblock$2$4_0/m2_24_342# VSUBS 2.00127f
C814 m2_10721_n3315# VSUBS 3.37511f
C815 1bitblock$3$4_0/a_7083_63# VSUBS 0.85964f
C816 1bitblock$3$4_0/a_8723_63# VSUBS 0.40583f
C817 1bitblock$3$4_0/m2_9431_79# VSUBS 0.62602f
C818 1bitblock$3$4_0/m2_7791_79# VSUBS 0.61996f
C819 1bitblock$3$4_0/a_9609_407# VSUBS 0.11896f
C820 1bitblock$3$4_0/a_8361_407# VSUBS 0.05045f
C821 1bitblock$3$4_0/m2_6151_79# VSUBS 0.60126f
C822 1bitblock$3$4_0/a_6721_407# VSUBS 0.01523f
C823 1bitblock$3$4_0/a_5042_407# VSUBS 0.80196f
C824 1bitblock$3$4_0/a_3940_63# VSUBS 0.46874f
C825 m1_13543_n1146# VSUBS 3.90733f
C826 1bitblock$3$4_0/a_160_63# VSUBS 0.59446f
C827 1bitblock$3$4_0/a_5243_407# VSUBS 0.01459f
C828 1bitblock$3$4_0/a_705_407# VSUBS 0.13654f
C829 1bitblock$3$4_0/a_3498_3# VSUBS 1.27919f
C830 1bitblock$3$4_0/a_10906_n37# VSUBS 0.02232f
C831 1bitblock$3$4_0/a_9800_n37# VSUBS 0.01742f
C832 1bitblock$3$4_0/a_9408_n37# VSUBS 0.01326f
C833 1bitblock$3$4_0/a_8160_n37# VSUBS 0.01743f
C834 1bitblock$3$4_0/a_7768_n37# VSUBS 0.01327f
C835 1bitblock$3$4_0/a_6520_n37# VSUBS 0.01743f
C836 1bitblock$3$4_0/a_6128_n37# VSUBS 0.01327f
C837 1bitblock$3$4_0/a_5042_n37# VSUBS 0.01422f
C838 1bitblock$3$4_0/a_4650_n37# VSUBS 0.01569f
C839 m1_12480_n3815# VSUBS 2.92174f
C840 1bitblock$3$4_0/a_11922_3# VSUBS 0.64588f
C841 1bitblock$3$4_0/a_11922_391# VSUBS 0.00119f
C842 1bitblock$3$4_0/a_10906_466# VSUBS 0.59833f
C843 1bitblock$3$4_0/a_11480_63# VSUBS 0.42359f
C844 1bitblock$3$4_0/a_10363_63# VSUBS 0.13924f
C845 1bitblock$3$4_0/a_9050_63# VSUBS 0.55151f
C846 m1_8729_n3942# VSUBS 2.90486f
C847 1bitblock$3$4_0/a_7410_63# VSUBS 0.55618f
C848 1bitblock$3$4_0/a_5768_63# VSUBS 0.55887f
C849 1bitblock$3$4_0/a_1845_n37# VSUBS 0.01974f
C850 1bitblock$3$4_0/a_1262_n37# VSUBS 0.0127f
C851 1bitblock$3$4_0/a_870_n37# VSUBS 0.01517f
C852 1bitblock$3$4_0/a_4290_63# VSUBS 0.59072f
C853 1bitblock$3$4_0/a_2861_3# VSUBS 0.62907f
C854 1bitblock$3$4_0/a_1845_466# VSUBS 0.59877f
C855 1bitblock$3$4_0/a_2419_63# VSUBS 6.72858f
C856 1bitblock$3$4_0/a_510_63# VSUBS 0.58009f
C857 1bitblock$3$4_0/a_378_271# VSUBS 1.38584f
C858 m2_5443_n3913# VSUBS 5.24763f
C859 1bitblock$3$4_0/m2_24_342# VSUBS 1.97803f
.ends

.subckt XOR$8 a_1262_n37# a_510_63# a_870_n37# a_1015_n166# a_1206_n103# a_705_407#
+ a_160_63# m2_1295_79# a_104_n222# via_dev$15_2/VSUBS a_378_271# w_n310_281#
X0 via_dev$15_2/VSUBS a_510_63# a_1262_n37# via_dev$15_2/VSUBS nfet_03v3 ad=0.65p pd=3.3u as=0.3625p ps=1.725u w=1u l=0.28u
X1 w_n310_281# a_378_271# a_705_407# w_n310_281# pfet_03v3 ad=0.725p pd=2.725u as=1.09p ps=5.09u w=2u l=0.28u
X2 a_705_407# a_510_63# m2_1295_79# w_n310_281# pfet_03v3 ad=1.3p pd=5.3u as=0.725p ps=2.725u w=2u l=0.28u
X3 a_160_63# a_104_n222# via_dev$15_2/VSUBS via_dev$15_2/VSUBS nfet_03v3 ad=0.315p pd=2.26u as=0.325p ps=2.3u w=0.5u l=0.28u
X4 a_510_63# a_378_271# w_n310_281# w_n310_281# pfet_03v3 ad=0.65p pd=3.3u as=0.56p ps=3.12u w=1u l=0.28u
X5 a_510_63# a_378_271# via_dev$15_2/VSUBS via_dev$15_2/VSUBS nfet_03v3 ad=0.315p pd=2.26u as=0.28p ps=2.12u w=0.5u l=0.28u
X6 a_1262_n37# a_1206_n103# m2_1295_79# via_dev$15_2/VSUBS nfet_03v3 ad=0.3625p pd=1.725u as=0.3375p ps=1.675u w=1u l=0.28u
X7 a_160_63# a_104_n222# w_n310_281# w_n310_281# pfet_03v3 ad=0.63p pd=3.26u as=0.65p ps=3.3u w=1u l=0.28u
X8 m2_1295_79# a_1206_n103# a_705_407# w_n310_281# pfet_03v3 ad=0.725p pd=2.725u as=0.675p ps=2.675u w=2u l=0.28u
X9 m2_1295_79# a_1015_n166# a_870_n37# via_dev$15_2/VSUBS nfet_03v3 ad=0.3375p pd=1.675u as=0.3625p ps=1.725u w=1u l=0.28u
X10 a_705_407# a_1015_n166# w_n310_281# w_n310_281# pfet_03v3 ad=0.675p pd=2.675u as=0.725p ps=2.725u w=2u l=0.28u
X11 a_870_n37# a_378_271# via_dev$15_2/VSUBS via_dev$15_2/VSUBS nfet_03v3 ad=0.3625p pd=1.725u as=0.54p ps=3.08u w=1u l=0.28u
C0 a_1015_n166# a_378_271# 0.04506f
C1 a_1206_n103# a_1015_n166# 0.06326f
C2 a_160_63# w_n310_281# 0.19309f
C3 m2_1295_79# a_378_271# 0.00751f
C4 a_1206_n103# m2_1295_79# 0.03904f
C5 a_705_407# a_378_271# 0.02752f
C6 a_160_63# a_104_n222# 0.06344f
C7 a_1206_n103# a_705_407# 0.03864f
C8 m2_1295_79# a_870_n37# 0.00639f
C9 m2_1295_79# a_1015_n166# 0.01066f
C10 a_705_407# a_1015_n166# 0.02182f
C11 a_160_63# a_510_63# 0.13239f
C12 a_1262_n37# m2_1295_79# 0.01511f
C13 a_705_407# m2_1295_79# 0.33758f
C14 a_1262_n37# a_705_407# 0
C15 w_n310_281# a_378_271# 0.45625f
C16 a_1206_n103# w_n310_281# 0.13988f
C17 a_104_n222# a_378_271# 0.0218f
C18 a_1015_n166# w_n310_281# 0.18312f
C19 a_104_n222# a_1015_n166# 0
C20 a_510_63# a_378_271# 0.10942f
C21 a_1206_n103# a_510_63# 0.16379f
C22 m2_1295_79# w_n310_281# 0.16951f
C23 a_705_407# w_n310_281# 0.66291f
C24 a_870_n37# a_510_63# 0.01502f
C25 m2_1295_79# a_104_n222# 0
C26 a_705_407# a_104_n222# 0
C27 a_510_63# a_1015_n166# 0.0752f
C28 a_160_63# a_378_271# 0.072f
C29 a_1206_n103# a_160_63# 0.00886f
C30 m2_1295_79# a_510_63# 0.48548f
C31 a_1262_n37# a_510_63# 0.00898f
C32 a_705_407# a_510_63# 0.13798f
C33 a_160_63# a_870_n37# 0.00441f
C34 a_160_63# a_1015_n166# 0.01372f
C35 a_160_63# m2_1295_79# 0.0367f
C36 a_705_407# a_160_63# 0.06438f
C37 a_104_n222# w_n310_281# 0.23193f
C38 a_510_63# w_n310_281# 0.26525f
C39 a_1206_n103# a_378_271# 0
C40 m2_1295_79# via_dev$15_2/VSUBS 0.50117f
C41 a_160_63# via_dev$15_2/VSUBS 0.43201f
C42 a_705_407# via_dev$15_2/VSUBS 0.19655f
C43 a_1262_n37# via_dev$15_2/VSUBS 0.0069f
C44 a_870_n37# via_dev$15_2/VSUBS 0.01517f
C45 a_510_63# via_dev$15_2/VSUBS 0.60964f
C46 a_378_271# via_dev$15_2/VSUBS 0.59801f
C47 w_n310_281# via_dev$15_2/VSUBS 4.42342f
C48 a_1206_n103# via_dev$15_2/VSUBS 0.21814f
C49 a_1015_n166# via_dev$15_2/VSUBS 0.25407f
C50 a_104_n222# via_dev$15_2/VSUBS 0.43986f
.ends

.subckt x1bitblock$2$1 a_2861_3# a_8361_407# a_6520_n37# a_1262_n37# a_2861_391# a_1845_466#
+ a_10906_n37# a_510_63# a_870_n37# a_6721_407# a_9800_n37# a_11480_63# a_6128_n37#
+ a_5768_63# a_8919_367# m2_6151_79# a_11922_391# a_5042_n37# a_9408_n37# a_9609_407#
+ a_5042_407# a_8160_n37# a_4158_271# a_11922_3# a_2419_63# m2_9431_79# a_10906_466#
+ a_4650_n37# a_9050_63# a_5243_407# a_7768_n37# a_3940_63# m2_7791_79# a_10363_63#
+ a_160_63# a_4290_63# a_7083_63# a_705_407# a_12559_3# a_7410_63# a_1845_n37# via_dev$5$2$1_9/VSUBS
+ m2_1295_79# a_8723_63# a_378_271# a_3498_3# w_n310_281# m2_5700_324# m2_24_342#
X0 a_2419_63# a_1845_466# via_dev$5$2$1_9/VSUBS via_dev$5$2$1_9/VSUBS nfet_03v3 ad=0.315p pd=2.26u as=0.2425p ps=1.97u w=0.5u l=0.28u
X1 a_1845_466# m2_24_342# a_1845_n37# via_dev$5$2$1_9/VSUBS nfet_03v3 ad=0.65p pd=3.3u as=0.42p ps=1.84u w=1u l=0.28u
X2 a_3940_63# m2_1295_79# w_n310_281# w_n310_281# pfet_03v3 ad=0.63p pd=3.26u as=0.65p ps=3.3u w=1u l=0.28u
X3 via_dev$5$2$1_9/VSUBS a_510_63# a_1262_n37# via_dev$5$2$1_9/VSUBS nfet_03v3 ad=0.65p pd=3.3u as=0.3625p ps=1.725u w=1u l=0.28u
X4 a_5243_407# a_4290_63# a_5042_407# w_n310_281# pfet_03v3 ad=1.3p pd=5.3u as=0.725p ps=2.725u w=2u l=0.28u
X5 a_6721_407# a_2419_63# m2_6151_79# w_n310_281# pfet_03v3 ad=0.675p pd=2.675u as=0.725p ps=2.725u w=2u l=0.28u
X6 a_10906_466# a_4158_271# w_n310_281# w_n310_281# pfet_03v3 ad=0.42p pd=1.84u as=0.65p ps=3.3u w=1u l=0.28u
X7 a_4290_63# a_4158_271# via_dev$5$2$1_9/VSUBS via_dev$5$2$1_9/VSUBS nfet_03v3 ad=0.315p pd=2.26u as=0.28p ps=2.12u w=0.5u l=0.28u
X8 w_n310_281# a_378_271# a_705_407# w_n310_281# pfet_03v3 ad=0.725p pd=2.725u as=1.09p ps=5.09u w=2u l=0.28u
X9 a_2861_3# m2_1295_79# via_dev$5$2$1_9/VSUBS via_dev$5$2$1_9/VSUBS nfet_03v3 ad=0.18125p pd=1.225u as=0.325p ps=2.3u w=0.5u l=0.28u
X10 via_dev$5$2$1_9/VSUBS a_2419_63# a_2861_3# via_dev$5$2$1_9/VSUBS nfet_03v3 ad=0.315p pd=2.26u as=0.18125p ps=1.225u w=0.5u l=0.28u
X11 m2_7791_79# m2_1295_79# a_7768_n37# via_dev$5$2$1_9/VSUBS nfet_03v3 ad=0.3375p pd=1.675u as=0.3625p ps=1.725u w=1u l=0.28u
X12 a_10906_n37# a_4158_271# via_dev$5$2$1_9/VSUBS via_dev$5$2$1_9/VSUBS nfet_03v3 ad=0.42p pd=1.84u as=0.63p ps=3.26u w=1u l=0.28u
X13 a_9050_63# a_8919_367# via_dev$5$2$1_9/VSUBS via_dev$5$2$1_9/VSUBS nfet_03v3 ad=0.31p pd=2.24u as=0.24p ps=1.96u w=0.5u l=0.28u
X14 a_11922_3# a_11480_63# via_dev$5$2$1_9/VSUBS via_dev$5$2$1_9/VSUBS nfet_03v3 ad=0.18125p pd=1.225u as=0.325p ps=2.3u w=0.5u l=0.28u
X15 via_dev$5$2$1_9/VSUBS a_2419_63# a_11922_3# via_dev$5$2$1_9/VSUBS nfet_03v3 ad=0.315p pd=2.26u as=0.18125p ps=1.225u w=0.5u l=0.28u
X16 a_705_407# a_510_63# m2_1295_79# w_n310_281# pfet_03v3 ad=1.3p pd=5.3u as=0.725p ps=2.725u w=2u l=0.28u
X17 a_4650_n37# a_4158_271# via_dev$5$2$1_9/VSUBS via_dev$5$2$1_9/VSUBS nfet_03v3 ad=0.3625p pd=1.725u as=0.54p ps=3.08u w=1u l=0.28u
X18 a_2861_3# a_2419_63# a_2861_391# w_n310_281# pfet_03v3 ad=1.3p pd=5.3u as=0.725p ps=2.725u w=2u l=0.28u
X19 a_5768_63# m2_5700_324# via_dev$5$2$1_9/VSUBS via_dev$5$2$1_9/VSUBS nfet_03v3 ad=0.315p pd=2.26u as=0.3175p ps=2.27u w=0.5u l=0.28u
X20 via_dev$5$2$1_9/VSUBS a_9050_63# a_9800_n37# via_dev$5$2$1_9/VSUBS nfet_03v3 ad=0.65p pd=3.3u as=0.3625p ps=1.725u w=1u l=0.28u
X21 a_8361_407# m2_1295_79# m2_7791_79# w_n310_281# pfet_03v3 ad=0.675p pd=2.675u as=0.725p ps=2.725u w=2u l=0.28u
X22 a_9408_n37# a_8919_367# via_dev$5$2$1_9/VSUBS via_dev$5$2$1_9/VSUBS nfet_03v3 ad=0.3625p pd=1.725u as=0.54p ps=3.08u w=1u l=0.28u
X23 a_3498_3# a_2861_3# w_n310_281# w_n310_281# pfet_03v3 ad=0.65p pd=3.3u as=0.675p ps=3.35u w=1u l=0.28u
X24 a_7410_63# m2_5700_324# via_dev$5$2$1_9/VSUBS via_dev$5$2$1_9/VSUBS nfet_03v3 ad=0.31p pd=2.24u as=0.24p ps=1.96u w=0.5u l=0.28u
X25 via_dev$5$2$1_9/VSUBS a_7410_63# a_8160_n37# via_dev$5$2$1_9/VSUBS nfet_03v3 ad=0.65p pd=3.3u as=0.3625p ps=1.725u w=1u l=0.28u
X26 a_8723_63# m2_7791_79# via_dev$5$2$1_9/VSUBS via_dev$5$2$1_9/VSUBS nfet_03v3 ad=0.2625p pd=2.05u as=0.265p ps=2.06u w=0.5u l=0.28u
X27 w_n310_281# a_4158_271# a_5243_407# w_n310_281# pfet_03v3 ad=0.725p pd=2.725u as=1.09p ps=5.09u w=2u l=0.28u
X28 a_5768_63# m2_5700_324# w_n310_281# w_n310_281# pfet_03v3 ad=0.65p pd=3.3u as=0.635p ps=3.27u w=1u l=0.28u
X29 a_9050_63# a_8919_367# w_n310_281# w_n310_281# pfet_03v3 ad=0.64p pd=3.28u as=0.48p ps=2.96u w=1u l=0.28u
X30 a_11922_391# a_11480_63# w_n310_281# w_n310_281# pfet_03v3 ad=0.725p pd=2.725u as=1.3p ps=5.3u w=2u l=0.28u
X31 a_160_63# m2_24_342# via_dev$5$2$1_9/VSUBS via_dev$5$2$1_9/VSUBS nfet_03v3 ad=0.315p pd=2.26u as=0.325p ps=2.3u w=0.5u l=0.28u
X32 a_9609_407# a_9050_63# w_n310_281# w_n310_281# pfet_03v3 ad=1.3p pd=5.3u as=0.725p ps=2.725u w=2u l=0.28u
X33 a_6128_n37# m2_5700_324# via_dev$5$2$1_9/VSUBS via_dev$5$2$1_9/VSUBS nfet_03v3 ad=0.3625p pd=1.725u as=0.54p ps=3.08u w=1u l=0.28u
X34 via_dev$5$2$1_9/VSUBS a_5768_63# a_6520_n37# via_dev$5$2$1_9/VSUBS nfet_03v3 ad=0.65p pd=3.3u as=0.3625p ps=1.725u w=1u l=0.28u
X35 a_7410_63# m2_5700_324# w_n310_281# w_n310_281# pfet_03v3 ad=0.64p pd=3.28u as=0.48p ps=2.96u w=1u l=0.28u
X36 m2_9431_79# a_8919_367# a_9609_407# w_n310_281# pfet_03v3 ad=0.725p pd=2.725u as=1.09p ps=5.09u w=2u l=0.28u
X37 a_11480_63# a_10906_466# via_dev$5$2$1_9/VSUBS via_dev$5$2$1_9/VSUBS nfet_03v3 ad=0.315p pd=2.26u as=0.2425p ps=1.97u w=0.5u l=0.28u
X38 a_1845_466# a_378_271# w_n310_281# w_n310_281# pfet_03v3 ad=0.42p pd=1.84u as=0.65p ps=3.3u w=1u l=0.28u
X39 a_8361_407# a_7410_63# w_n310_281# w_n310_281# pfet_03v3 ad=1.3p pd=5.3u as=0.725p ps=2.725u w=2u l=0.28u
X40 w_n310_281# m2_1295_79# a_10906_466# w_n310_281# pfet_03v3 ad=0.735p pd=2.47u as=0.42p ps=1.84u w=1u l=0.28u
X41 a_7083_63# m2_6151_79# via_dev$5$2$1_9/VSUBS via_dev$5$2$1_9/VSUBS nfet_03v3 ad=0.2625p pd=2.05u as=0.265p ps=2.06u w=0.5u l=0.28u
X42 a_510_63# a_378_271# w_n310_281# w_n310_281# pfet_03v3 ad=0.65p pd=3.3u as=0.56p ps=3.12u w=1u l=0.28u
X43 a_10363_63# m2_9431_79# w_n310_281# w_n310_281# pfet_03v3 ad=0.715p pd=3.43u as=0.53p ps=3.06u w=1u l=0.28u
X44 a_510_63# a_378_271# via_dev$5$2$1_9/VSUBS via_dev$5$2$1_9/VSUBS nfet_03v3 ad=0.315p pd=2.26u as=0.28p ps=2.12u w=0.5u l=0.28u
X45 a_1262_n37# a_160_63# m2_1295_79# via_dev$5$2$1_9/VSUBS nfet_03v3 ad=0.3625p pd=1.725u as=0.3375p ps=1.675u w=1u l=0.28u
X46 a_1845_n37# a_378_271# via_dev$5$2$1_9/VSUBS via_dev$5$2$1_9/VSUBS nfet_03v3 ad=0.42p pd=1.84u as=0.63p ps=3.26u w=1u l=0.28u
X47 m2_6151_79# m2_5700_324# a_6721_407# w_n310_281# pfet_03v3 ad=0.725p pd=2.725u as=1.09p ps=5.09u w=2u l=0.28u
X48 a_6721_407# a_5768_63# w_n310_281# w_n310_281# pfet_03v3 ad=1.3p pd=5.3u as=0.725p ps=2.725u w=2u l=0.28u
X49 a_10363_63# m2_9431_79# via_dev$5$2$1_9/VSUBS via_dev$5$2$1_9/VSUBS nfet_03v3 ad=0.3575p pd=2.43u as=0.265p ps=2.06u w=0.5u l=0.28u
X50 a_10906_466# m2_1295_79# a_10906_n37# via_dev$5$2$1_9/VSUBS nfet_03v3 ad=0.65p pd=3.3u as=0.42p ps=1.84u w=1u l=0.28u
X51 a_8723_63# m2_7791_79# w_n310_281# w_n310_281# pfet_03v3 ad=0.545p pd=3.09u as=0.53p ps=3.06u w=1u l=0.28u
X52 a_11480_63# a_10906_466# w_n310_281# w_n310_281# pfet_03v3 ad=0.65p pd=3.3u as=0.735p ps=2.47u w=1u l=0.28u
X53 a_12559_3# a_11922_3# via_dev$5$2$1_9/VSUBS via_dev$5$2$1_9/VSUBS nfet_03v3 ad=0.315p pd=2.26u as=0.325p ps=2.3u w=0.5u l=0.28u
X54 a_7083_63# m2_6151_79# w_n310_281# w_n310_281# pfet_03v3 ad=0.545p pd=3.09u as=0.53p ps=3.06u w=1u l=0.28u
X55 a_7768_n37# m2_5700_324# via_dev$5$2$1_9/VSUBS via_dev$5$2$1_9/VSUBS nfet_03v3 ad=0.3625p pd=1.725u as=0.54p ps=3.08u w=1u l=0.28u
X56 a_160_63# m2_24_342# w_n310_281# w_n310_281# pfet_03v3 ad=0.63p pd=3.26u as=0.65p ps=3.3u w=1u l=0.28u
X57 m2_1295_79# a_160_63# a_705_407# w_n310_281# pfet_03v3 ad=0.725p pd=2.725u as=0.675p ps=2.675u w=2u l=0.28u
X58 a_5042_n37# a_3940_63# a_5042_407# via_dev$5$2$1_9/VSUBS nfet_03v3 ad=0.3625p pd=1.725u as=0.3375p ps=1.675u w=1u l=0.28u
X59 m2_1295_79# m2_24_342# a_870_n37# via_dev$5$2$1_9/VSUBS nfet_03v3 ad=0.3375p pd=1.675u as=0.3625p ps=1.725u w=1u l=0.28u
X60 a_11922_3# a_2419_63# a_11922_391# w_n310_281# pfet_03v3 ad=1.3p pd=5.3u as=0.725p ps=2.725u w=2u l=0.28u
X61 a_9800_n37# a_7083_63# m2_9431_79# via_dev$5$2$1_9/VSUBS nfet_03v3 ad=0.3625p pd=1.725u as=0.3375p ps=1.675u w=1u l=0.28u
X62 m2_7791_79# m2_5700_324# a_8361_407# w_n310_281# pfet_03v3 ad=0.725p pd=2.725u as=1.09p ps=5.09u w=2u l=0.28u
X63 a_5042_407# a_3940_63# a_5243_407# w_n310_281# pfet_03v3 ad=0.725p pd=2.725u as=0.675p ps=2.675u w=2u l=0.28u
X64 a_3940_63# m2_1295_79# via_dev$5$2$1_9/VSUBS via_dev$5$2$1_9/VSUBS nfet_03v3 ad=0.315p pd=2.26u as=0.325p ps=2.3u w=0.5u l=0.28u
X65 a_8160_n37# a_3498_3# m2_7791_79# via_dev$5$2$1_9/VSUBS nfet_03v3 ad=0.3625p pd=1.725u as=0.3375p ps=1.675u w=1u l=0.28u
X66 a_705_407# m2_24_342# w_n310_281# w_n310_281# pfet_03v3 ad=0.675p pd=2.675u as=0.725p ps=2.725u w=2u l=0.28u
X67 a_5042_407# m2_1295_79# a_4650_n37# via_dev$5$2$1_9/VSUBS nfet_03v3 ad=0.3375p pd=1.675u as=0.3625p ps=1.725u w=1u l=0.28u
X68 a_6520_n37# a_5042_407# m2_6151_79# via_dev$5$2$1_9/VSUBS nfet_03v3 ad=0.3625p pd=1.725u as=0.3375p ps=1.675u w=1u l=0.28u
X69 w_n310_281# a_7083_63# a_9609_407# w_n310_281# pfet_03v3 ad=0.725p pd=2.725u as=0.675p ps=2.675u w=2u l=0.28u
X70 a_2419_63# a_1845_466# w_n310_281# w_n310_281# pfet_03v3 ad=0.65p pd=3.3u as=0.735p ps=2.47u w=1u l=0.28u
X71 m2_9431_79# a_8723_63# a_9408_n37# via_dev$5$2$1_9/VSUBS nfet_03v3 ad=0.3375p pd=1.675u as=0.3625p ps=1.725u w=1u l=0.28u
X72 w_n310_281# a_3498_3# a_8361_407# w_n310_281# pfet_03v3 ad=0.725p pd=2.725u as=0.675p ps=2.675u w=2u l=0.28u
X73 a_2861_391# m2_1295_79# w_n310_281# w_n310_281# pfet_03v3 ad=0.725p pd=2.725u as=1.3p ps=5.3u w=2u l=0.28u
X74 a_4290_63# a_4158_271# w_n310_281# w_n310_281# pfet_03v3 ad=0.65p pd=3.3u as=0.56p ps=3.12u w=1u l=0.28u
X75 a_5243_407# m2_1295_79# w_n310_281# w_n310_281# pfet_03v3 ad=0.675p pd=2.675u as=0.725p ps=2.725u w=2u l=0.28u
X76 w_n310_281# a_5042_407# a_6721_407# w_n310_281# pfet_03v3 ad=0.725p pd=2.725u as=0.675p ps=2.675u w=2u l=0.28u
X77 a_3498_3# a_2861_3# via_dev$5$2$1_9/VSUBS via_dev$5$2$1_9/VSUBS nfet_03v3 ad=0.315p pd=2.26u as=0.325p ps=2.3u w=0.5u l=0.28u
X78 a_9609_407# a_8723_63# m2_9431_79# w_n310_281# pfet_03v3 ad=0.675p pd=2.675u as=0.725p ps=2.725u w=2u l=0.28u
X79 via_dev$5$2$1_9/VSUBS a_4290_63# a_5042_n37# via_dev$5$2$1_9/VSUBS nfet_03v3 ad=0.65p pd=3.3u as=0.3625p ps=1.725u w=1u l=0.28u
X80 m2_6151_79# a_2419_63# a_6128_n37# via_dev$5$2$1_9/VSUBS nfet_03v3 ad=0.3375p pd=1.675u as=0.3625p ps=1.725u w=1u l=0.28u
X81 w_n310_281# m2_24_342# a_1845_466# w_n310_281# pfet_03v3 ad=0.735p pd=2.47u as=0.42p ps=1.84u w=1u l=0.28u
X82 a_870_n37# a_378_271# via_dev$5$2$1_9/VSUBS via_dev$5$2$1_9/VSUBS nfet_03v3 ad=0.3625p pd=1.725u as=0.54p ps=3.08u w=1u l=0.28u
X83 a_12559_3# a_11922_3# w_n310_281# w_n310_281# pfet_03v3 ad=0.65p pd=3.3u as=0.675p ps=3.35u w=1u l=0.28u
C0 m2_9431_79# a_7083_63# 0.19293f
C1 a_10363_63# a_7083_63# 0.00582f
C2 m2_5700_324# a_6721_407# 0.50857f
C3 a_5042_407# a_7083_63# 0.02611f
C4 a_2419_63# a_9050_63# 0.00801f
C5 a_4650_n37# a_4158_271# 0.00383f
C6 a_510_63# a_378_271# 0.14298f
C7 a_160_63# m2_24_342# 0.42316f
C8 a_9050_63# m2_7791_79# 0.00127f
C9 a_11922_391# a_11480_63# 0.00152f
C10 w_n310_281# a_510_63# 0.28255f
C11 a_5042_n37# a_4158_271# 0
C12 a_8361_407# a_8919_367# 0
C13 a_2861_3# a_705_407# 0
C14 w_n310_281# a_9050_63# 0.28931f
C15 a_5243_407# a_5042_n37# 0
C16 a_7768_n37# a_7410_63# 0.00935f
C17 a_12559_3# a_11922_3# 0.0899f
C18 a_2419_63# m2_7791_79# 0.00843f
C19 a_7410_63# m2_9431_79# 0.00105f
C20 w_n310_281# a_2419_63# 0.75129f
C21 a_2861_3# a_5042_407# 0
C22 a_3498_3# a_8361_407# 0.12093f
C23 a_4158_271# a_10906_466# 0.03873f
C24 a_7410_63# a_5042_407# 0
C25 a_10363_63# a_8723_63# 0
C26 a_8723_63# m2_9431_79# 0.13485f
C27 w_n310_281# a_378_271# 0.6337f
C28 a_7410_63# a_7083_63# 0.07718f
C29 w_n310_281# m2_7791_79# 0.45139f
C30 a_3940_63# a_5042_407# 0.0941f
C31 a_2419_63# m2_6151_79# 0.05852f
C32 a_4290_63# a_5042_407# 0.38112f
C33 a_8723_63# a_7083_63# 0.15796f
C34 a_510_63# a_1262_n37# 0.00898f
C35 m2_6151_79# m2_7791_79# 0.00114f
C36 a_6520_n37# a_5042_407# 0.00483f
C37 a_2861_391# a_2419_63# 0.0163f
C38 a_6520_n37# a_7083_63# 0.00272f
C39 w_n310_281# m2_6151_79# 0.44301f
C40 a_9609_407# m2_9431_79# 0.49779f
C41 a_10363_63# a_9609_407# 0.01306f
C42 a_2419_63# a_6721_407# 0.01825f
C43 a_510_63# m2_24_342# 0.13025f
C44 m2_1295_79# a_705_407# 0.30816f
C45 m2_1295_79# m2_9431_79# 0.0078f
C46 m2_1295_79# a_10363_63# 0.00179f
C47 a_9408_n37# a_9050_63# 0.00935f
C48 a_9609_407# a_7083_63# 0.0285f
C49 a_8361_407# m2_5700_324# 0.05956f
C50 a_2861_391# w_n310_281# 0.03535f
C51 a_3940_63# a_2861_3# 0
C52 w_n310_281# a_6721_407# 0.72579f
C53 a_4290_63# a_2861_3# 0
C54 a_2419_63# m2_24_342# 0.00234f
C55 m2_1295_79# a_5042_407# 0.03487f
C56 a_5768_63# a_6128_n37# 0.00935f
C57 m2_1295_79# a_7083_63# 0.01071f
C58 a_8723_63# a_7410_63# 0.01398f
C59 m2_24_342# a_378_271# 0.56715f
C60 a_4290_63# a_3940_63# 0.28903f
C61 a_6721_407# m2_6151_79# 0.4935f
C62 a_1845_466# a_705_407# 0.0126f
C63 a_9408_n37# m2_7791_79# 0
C64 w_n310_281# m2_24_342# 0.66878f
C65 a_8919_367# m2_9431_79# 0.03216f
C66 a_8919_367# a_10363_63# 0
C67 a_5768_63# a_5042_407# 0.22596f
C68 a_2419_63# a_10906_466# 0.00833f
C69 a_5768_63# a_7083_63# 0.01494f
C70 m2_1295_79# a_11922_3# 0
C71 a_8919_367# a_7083_63# 0.01057f
C72 a_11480_63# m2_9431_79# 0
C73 a_10363_63# a_11480_63# 0
C74 a_5042_n37# m2_6151_79# 0
C75 a_3498_3# m2_9431_79# 0
C76 m2_1295_79# a_2861_3# 0.15381f
C77 w_n310_281# a_10906_466# 0.44509f
C78 m2_1295_79# a_7410_63# 0.07614f
C79 a_8723_63# a_9609_407# 0.0593f
C80 a_3498_3# a_5042_407# 0.02015f
C81 a_11922_391# a_2419_63# 0.00754f
C82 m2_1295_79# a_3940_63# 0.46061f
C83 a_3498_3# a_7083_63# 0.01356f
C84 a_4290_63# m2_1295_79# 0.13519f
C85 a_8361_407# a_9050_63# 0
C86 m2_1295_79# a_8723_63# 0.00803f
C87 m2_1295_79# a_1845_n37# 0.00942f
C88 w_n310_281# a_11922_391# 0.03535f
C89 a_8361_407# a_2419_63# 0
C90 a_8160_n37# m2_9431_79# 0
C91 a_1845_466# a_2861_3# 0
C92 a_5768_63# a_3940_63# 0
C93 a_8919_367# a_7410_63# 0
C94 a_5768_63# a_4290_63# 0.01093f
C95 a_160_63# a_705_407# 0.06737f
C96 a_11480_63# a_11922_3# 0.04054f
C97 a_8361_407# m2_7791_79# 0.49779f
C98 m2_1295_79# a_9609_407# 0.0093f
C99 a_8160_n37# a_7083_63# 0.00507f
C100 a_10906_n37# a_4158_271# 0.00824f
C101 a_3940_63# a_1845_466# 0
C102 a_10363_63# a_4158_271# 0.02222f
C103 a_8919_367# a_8723_63# 0.12587f
C104 a_4158_271# m2_9431_79# 0.05572f
C105 a_3498_3# a_2861_3# 0.09846f
C106 w_n310_281# a_8361_407# 0.75753f
C107 a_5768_63# a_6520_n37# 0.01329f
C108 a_3498_3# a_7410_63# 0.11774f
C109 a_1845_n37# a_1845_466# 0.01333f
C110 a_4158_271# a_5042_407# 0.63867f
C111 m2_5700_324# a_5042_407# 0.06917f
C112 a_4158_271# a_7083_63# 1.09132f
C113 m2_5700_324# a_7083_63# 0.12051f
C114 a_3498_3# a_3940_63# 0.04602f
C115 a_3498_3# a_4290_63# 0.00876f
C116 a_5243_407# a_5042_407# 0.29512f
C117 a_3498_3# a_8723_63# 0.00575f
C118 a_8919_367# a_9609_407# 0.02942f
C119 a_5768_63# m2_1295_79# 0.00766f
C120 m2_1295_79# a_8919_367# 0.01372f
C121 a_8160_n37# a_7410_63# 0.01329f
C122 m2_1295_79# a_1845_466# 0.09644f
C123 a_4158_271# a_11922_3# 0.0013f
C124 a_11480_63# a_9609_407# 0
C125 a_510_63# a_705_407# 0.13828f
C126 m2_1295_79# a_11480_63# 0.00126f
C127 a_7410_63# a_4158_271# 0
C128 m2_5700_324# a_7410_63# 0.14432f
C129 a_3498_3# m2_1295_79# 0.3391f
C130 a_9800_n37# m2_9431_79# 0.0074f
C131 a_5243_407# a_2861_3# 0
C132 a_9050_63# m2_9431_79# 0.328f
C133 a_10363_63# a_9050_63# 0.01385f
C134 a_3940_63# a_4158_271# 0.16366f
C135 a_3940_63# m2_5700_324# 0.00132f
C136 a_4290_63# a_4158_271# 0.11363f
C137 a_4290_63# m2_5700_324# 0.01531f
C138 m2_5700_324# a_8723_63# 0
C139 a_8723_63# a_4158_271# 0
C140 a_2419_63# a_705_407# 0
C141 a_9800_n37# a_7083_63# 0.00527f
C142 a_3940_63# a_5243_407# 0.06737f
C143 a_4290_63# a_5243_407# 0.14023f
C144 a_2419_63# m2_9431_79# 0.00832f
C145 a_10363_63# a_2419_63# 0.00126f
C146 a_9050_63# a_7083_63# 0.21474f
C147 a_5768_63# a_3498_3# 0
C148 a_6520_n37# a_4158_271# 0.00406f
C149 a_378_271# a_705_407# 0.02817f
C150 a_7768_n37# m2_7791_79# 0.01733f
C151 a_12559_3# a_2419_63# 0
C152 a_2419_63# a_5042_407# 0.08051f
C153 m2_9431_79# m2_7791_79# 0.01571f
C154 w_n310_281# a_705_407# 0.79414f
C155 a_3498_3# a_1845_466# 0.00105f
C156 a_2419_63# a_7083_63# 0.01345f
C157 w_n310_281# a_10906_n37# 0
C158 w_n310_281# a_10363_63# 0.15741f
C159 w_n310_281# m2_9431_79# 0.46254f
C160 a_9609_407# a_4158_271# 0
C161 a_5042_407# m2_7791_79# 0.00555f
C162 m2_1295_79# a_160_63# 0.09339f
C163 a_12559_3# w_n310_281# 0.08598f
C164 a_6128_n37# m2_6151_79# 0.01733f
C165 a_7083_63# m2_7791_79# 0.14708f
C166 m2_1295_79# a_870_n37# 0.00639f
C167 w_n310_281# a_5042_407# 0.29911f
C168 m2_1295_79# a_4158_271# 0.16058f
C169 m2_1295_79# m2_5700_324# 0.07849f
C170 w_n310_281# a_7083_63# 0.31663f
C171 m2_1295_79# a_5243_407# 0.10989f
C172 a_2419_63# a_11922_3# 0.16984f
C173 a_6128_n37# a_6721_407# 0
C174 m2_6151_79# a_5042_407# 0.20459f
C175 a_2861_391# a_705_407# 0
C176 a_2419_63# a_2861_3# 0.21478f
C177 m2_6151_79# a_7083_63# 0.08089f
C178 a_5768_63# a_4158_271# 0.00573f
C179 a_5768_63# m2_5700_324# 0.16447f
C180 a_8723_63# a_9050_63# 0.53121f
C181 a_1845_n37# a_510_63# 0.0011f
C182 a_2419_63# a_7410_63# 0.00801f
C183 a_8919_367# a_4158_271# 0.001f
C184 a_1262_n37# a_705_407# 0
C185 a_160_63# a_1845_466# 0
C186 a_5768_63# a_5243_407# 0.00722f
C187 a_8919_367# m2_5700_324# 0
C188 a_870_n37# a_1845_466# 0
C189 w_n310_281# a_11922_3# 0.46598f
C190 a_3940_63# a_2419_63# 0.00879f
C191 a_4290_63# a_2419_63# 0.00652f
C192 a_6721_407# a_5042_407# 0.03265f
C193 w_n310_281# a_2861_3# 0.4655f
C194 a_8723_63# a_2419_63# 0.00661f
C195 a_7410_63# m2_7791_79# 0.36168f
C196 m2_24_342# a_705_407# 0.10607f
C197 a_6721_407# a_7083_63# 0.01268f
C198 a_4650_n37# a_5042_407# 0.00712f
C199 w_n310_281# a_7410_63# 0.31086f
C200 a_11480_63# a_4158_271# 0.00295f
C201 a_3498_3# a_4158_271# 0.00829f
C202 a_3498_3# m2_5700_324# 0.55174f
C203 a_8723_63# m2_7791_79# 0.08396f
C204 a_9609_407# a_9050_63# 0.1261f
C205 a_9408_n37# m2_9431_79# 0.01733f
C206 w_n310_281# a_3940_63# 0.30087f
C207 a_4290_63# w_n310_281# 0.2819f
C208 w_n310_281# a_8723_63# 0.33584f
C209 m2_1295_79# a_510_63# 0.39896f
C210 a_3498_3# a_5243_407# 0.16427f
C211 a_5042_n37# a_5042_407# 0.01726f
C212 m2_1295_79# a_9050_63# 0.00716f
C213 a_7410_63# m2_6151_79# 0
C214 w_n310_281# a_1845_n37# 0
C215 a_2419_63# a_9609_407# 0
C216 a_9408_n37# a_7083_63# 0.00336f
C217 a_10906_n37# a_10906_466# 0.01333f
C218 a_10906_466# m2_9431_79# 0.00167f
C219 a_10363_63# a_10906_466# 0.02047f
C220 a_4290_63# m2_6151_79# 0
C221 a_2861_391# a_2861_3# 0.01616f
C222 m2_1295_79# a_2419_63# 0.32461f
C223 a_12559_3# a_10906_466# 0
C224 a_9609_407# m2_7791_79# 0
C225 w_n310_281# a_9609_407# 0.7653f
C226 a_10906_466# a_7083_63# 0
C227 a_6520_n37# m2_6151_79# 0.00766f
C228 m2_1295_79# a_378_271# 0.02669f
C229 m2_1295_79# m2_7791_79# 0.05731f
C230 a_510_63# a_1845_466# 0.01433f
C231 a_8919_367# a_9050_63# 0.10006f
C232 a_160_63# a_870_n37# 0.00441f
C233 w_n310_281# m2_1295_79# 2.3522f
C234 a_3940_63# a_4650_n37# 0.00441f
C235 a_5768_63# a_2419_63# 0.07749f
C236 m2_5700_324# a_4158_271# 0.00861f
C237 a_4290_63# a_4650_n37# 0.01502f
C238 a_8919_367# a_2419_63# 0.01445f
C239 a_5243_407# a_4158_271# 0.02964f
C240 m2_5700_324# a_5243_407# 0.01927f
C241 a_2419_63# a_1845_466# 0.10509f
C242 a_5768_63# m2_7791_79# 0
C243 a_7768_n37# a_8361_407# 0
C244 m2_1295_79# m2_6151_79# 0.00667f
C245 a_10906_466# a_11922_3# 0
C246 a_4290_63# a_5042_n37# 0.00898f
C247 a_5768_63# w_n310_281# 0.31314f
C248 a_8361_407# m2_9431_79# 0
C249 a_8919_367# m2_7791_79# 0.02774f
C250 a_1845_466# a_378_271# 0.01278f
C251 a_2419_63# a_11480_63# 0.0769f
C252 w_n310_281# a_8919_367# 0.49838f
C253 a_3498_3# a_2419_63# 0.01177f
C254 w_n310_281# a_1845_466# 0.44517f
C255 a_2861_391# m2_1295_79# 0.00841f
C256 a_8361_407# a_7083_63# 0.01453f
C257 m2_1295_79# a_6721_407# 0.00452f
C258 a_5768_63# m2_6151_79# 0.35511f
C259 a_3498_3# m2_7791_79# 0.0296f
C260 a_11922_391# a_11922_3# 0.01891f
C261 m2_1295_79# a_1262_n37# 0.01607f
C262 w_n310_281# a_11480_63# 0.37298f
C263 a_3498_3# w_n310_281# 1.03377f
C264 a_9408_n37# a_9609_407# 0
C265 m2_1295_79# m2_24_342# 0.04399f
C266 a_160_63# a_510_63# 0.28903f
C267 a_5768_63# a_6721_407# 0.14017f
C268 a_510_63# a_870_n37# 0.01502f
C269 a_4158_271# a_9800_n37# 0.00497f
C270 a_4158_271# a_9050_63# 0.00717f
C271 a_3498_3# m2_6151_79# 0
C272 a_9609_407# a_10906_466# 0
C273 a_8160_n37# m2_7791_79# 0.01048f
C274 a_8361_407# a_7410_63# 0.1423f
C275 a_1262_n37# a_1845_466# 0
C276 a_2419_63# a_4158_271# 0.14782f
C277 m2_5700_324# a_2419_63# 0.074f
C278 m2_1295_79# a_10906_466# 0.0692f
C279 a_2861_391# a_3498_3# 0.00454f
C280 a_3498_3# a_6721_407# 0
C281 a_160_63# a_378_271# 0.09182f
C282 a_2419_63# a_5243_407# 0
C283 m2_24_342# a_1845_466# 0.06999f
C284 a_8361_407# a_8723_63# 0.01268f
C285 a_4158_271# m2_7791_79# 0
C286 m2_5700_324# m2_7791_79# 0.05245f
C287 w_n310_281# a_160_63# 0.30515f
C288 w_n310_281# m2_5700_324# 1.65678f
C289 w_n310_281# a_4158_271# 0.66883f
C290 w_n310_281# a_5243_407# 0.78984f
C291 a_3498_3# m2_24_342# 0
C292 a_7768_n37# m2_9431_79# 0
C293 a_10906_n37# a_10363_63# 0
C294 a_4158_271# m2_6151_79# 0.04334f
C295 a_10363_63# m2_9431_79# 0.07766f
C296 m2_5700_324# m2_6151_79# 0.14941f
C297 a_6128_n37# a_5042_407# 0.00376f
C298 a_8361_407# a_9609_407# 0.00466f
C299 a_9050_63# a_9800_n37# 0.01329f
C300 a_7768_n37# a_7083_63# 0.0028f
C301 a_11480_63# a_10906_466# 0.1131f
C302 m2_1295_79# a_8361_407# 0.02509f
C303 a_4158_271# via_dev$5$2$1_9/VSUBS 2.63898f
C304 a_7083_63# via_dev$5$2$1_9/VSUBS 0.86585f
C305 a_8723_63# via_dev$5$2$1_9/VSUBS 0.41121f
C306 m2_9431_79# via_dev$5$2$1_9/VSUBS 0.75255f
C307 m2_7791_79# via_dev$5$2$1_9/VSUBS 0.74612f
C308 a_9609_407# via_dev$5$2$1_9/VSUBS 0.11967f
C309 a_8361_407# via_dev$5$2$1_9/VSUBS 0.05216f
C310 m2_6151_79# via_dev$5$2$1_9/VSUBS 0.72815f
C311 a_6721_407# via_dev$5$2$1_9/VSUBS 0.01698f
C312 a_5042_407# via_dev$5$2$1_9/VSUBS 0.88916f
C313 a_3940_63# via_dev$5$2$1_9/VSUBS 0.46864f
C314 m2_1295_79# via_dev$5$2$1_9/VSUBS 3.37184f
C315 a_160_63# via_dev$5$2$1_9/VSUBS 0.5921f
C316 a_5243_407# via_dev$5$2$1_9/VSUBS 0.01661f
C317 a_705_407# via_dev$5$2$1_9/VSUBS 0.13677f
C318 a_3498_3# via_dev$5$2$1_9/VSUBS 1.27724f
C319 a_10906_n37# via_dev$5$2$1_9/VSUBS 0.02232f
C320 a_9800_n37# via_dev$5$2$1_9/VSUBS 0.01742f
C321 a_9408_n37# via_dev$5$2$1_9/VSUBS 0.007f
C322 a_8160_n37# via_dev$5$2$1_9/VSUBS 0.01743f
C323 a_7768_n37# via_dev$5$2$1_9/VSUBS 0.007f
C324 a_6520_n37# via_dev$5$2$1_9/VSUBS 0.01743f
C325 a_6128_n37# via_dev$5$2$1_9/VSUBS 0.007f
C326 a_5042_n37# via_dev$5$2$1_9/VSUBS 0.00833f
C327 a_4650_n37# via_dev$5$2$1_9/VSUBS 0.01565f
C328 a_12559_3# via_dev$5$2$1_9/VSUBS 0.19481f
C329 a_11922_3# via_dev$5$2$1_9/VSUBS 0.64569f
C330 a_11922_391# via_dev$5$2$1_9/VSUBS 0.00119f
C331 a_10906_466# via_dev$5$2$1_9/VSUBS 0.59796f
C332 a_11480_63# via_dev$5$2$1_9/VSUBS 0.42359f
C333 a_10363_63# via_dev$5$2$1_9/VSUBS 0.13924f
C334 a_9050_63# via_dev$5$2$1_9/VSUBS 0.53264f
C335 a_8919_367# via_dev$5$2$1_9/VSUBS 0.51866f
C336 a_7410_63# via_dev$5$2$1_9/VSUBS 0.53731f
C337 a_5768_63# via_dev$5$2$1_9/VSUBS 0.54f
C338 a_1845_n37# via_dev$5$2$1_9/VSUBS 0.01974f
C339 a_1262_n37# via_dev$5$2$1_9/VSUBS 0.0069f
C340 a_870_n37# via_dev$5$2$1_9/VSUBS 0.01517f
C341 a_4290_63# via_dev$5$2$1_9/VSUBS 0.57048f
C342 a_2861_3# via_dev$5$2$1_9/VSUBS 0.62907f
C343 a_1845_466# via_dev$5$2$1_9/VSUBS 0.59853f
C344 a_2419_63# via_dev$5$2$1_9/VSUBS 6.64114f
C345 a_510_63# via_dev$5$2$1_9/VSUBS 0.55998f
C346 a_378_271# via_dev$5$2$1_9/VSUBS 1.37769f
C347 w_n310_281# via_dev$5$2$1_9/VSUBS 27.01716f
C348 m2_5700_324# via_dev$5$2$1_9/VSUBS 1.14834f
C349 m2_24_342# via_dev$5$2$1_9/VSUBS 1.98211f
.ends

.subckt AND4$1 w_237_91# a_992_79# a_372_n441# a_1200_79# a_1686_n317# a_784_79# a_704_n441#
+ a_576_79# a_912_n441# a_518_229# a_1120_n441#
X0 w_237_91# a_992_79# a_518_229# w_237_91# pfet_03v3 ad=0.38p pd=1.76u as=0.38p ps=1.76u w=1u l=0.28u
X1 a_518_229# a_784_79# w_237_91# w_237_91# pfet_03v3 ad=0.38p pd=1.76u as=0.38p ps=1.76u w=1u l=0.28u
X2 a_1686_n317# a_518_229# w_237_91# w_237_91# pfet_03v3 ad=0.65p pd=3.3u as=0.65p ps=3.3u w=1u l=0.28u
X3 a_912_n441# a_784_79# a_704_n441# a_372_n441# nfet_03v3 ad=0.76p pd=2.76u as=0.76p ps=2.76u w=2u l=0.28u
X4 w_237_91# a_576_79# a_518_229# w_237_91# pfet_03v3 ad=0.38p pd=1.76u as=0.65p ps=3.3u w=1u l=0.28u
X5 a_704_n441# a_576_79# a_372_n441# a_372_n441# nfet_03v3 ad=0.76p pd=2.76u as=1.34p ps=5.34u w=2u l=0.28u
X6 a_518_229# a_1200_79# a_1120_n441# a_372_n441# nfet_03v3 ad=1.14p pd=5.14u as=0.76p ps=2.76u w=2u l=0.28u
X7 a_1686_n317# a_518_229# a_372_n441# a_372_n441# nfet_03v3 ad=0.315p pd=2.26u as=0.295p ps=2.18u w=0.5u l=0.28u
X8 a_518_229# a_1200_79# w_237_91# w_237_91# pfet_03v3 ad=0.55p pd=3.1u as=0.38p ps=1.76u w=1u l=0.28u
X9 a_1120_n441# a_992_79# a_912_n441# a_372_n441# nfet_03v3 ad=0.76p pd=2.76u as=0.76p ps=2.76u w=2u l=0.28u
C0 a_518_229# a_992_79# 0.12168f
C1 a_576_79# a_518_229# 0.11544f
C2 a_912_n441# a_518_229# 0.01471f
C3 a_784_79# a_518_229# 0.11673f
C4 a_704_n441# a_784_79# 0.00663f
C5 a_1686_n317# w_237_91# 0.1612f
C6 a_1120_n441# a_518_229# 0.02253f
C7 w_237_91# a_1200_79# 0.15686f
C8 w_237_91# a_992_79# 0.1469f
C9 w_237_91# a_576_79# 0.16514f
C10 a_1200_79# a_992_79# 0.06396f
C11 a_704_n441# a_518_229# 0.01032f
C12 w_237_91# a_784_79# 0.14715f
C13 a_912_n441# a_992_79# 0.00663f
C14 a_784_79# a_992_79# 0.06396f
C15 a_576_79# a_784_79# 0.06396f
C16 a_1120_n441# a_1200_79# 0.00663f
C17 w_237_91# a_518_229# 1.12672f
C18 a_1686_n317# a_518_229# 0.12995f
C19 a_1200_79# a_518_229# 0.20239f
C20 a_1120_n441# a_372_n441# 0.02626f
C21 a_912_n441# a_372_n441# 0.02949f
C22 a_704_n441# a_372_n441# 0.03642f
C23 a_1686_n317# a_372_n441# 0.20646f
C24 a_518_229# a_372_n441# 0.81795f
C25 a_1200_79# a_372_n441# 0.2334f
C26 a_992_79# a_372_n441# 0.22559f
C27 a_784_79# a_372_n441# 0.22803f
C28 a_576_79# a_372_n441# 0.27946f
C29 w_237_91# a_372_n441# 2.88366f
.ends

.subckt MUX21$1 a_1472_63# a_157_63# a_25_271# a_909_n37# a_650_n277# a_517_n37# a_718_407#
+ m2_540_79# via_dev$11$1_4/VSUBS a_846_955# w_n310_281#
X0 a_1472_63# m2_540_79# via_dev$11$1_4/VSUBS via_dev$11$1_4/VSUBS nfet_03v3 ad=0.2625p pd=2.05u as=0.265p ps=2.06u w=0.5u l=0.28u
X1 a_157_63# a_25_271# w_n310_281# w_n310_281# pfet_03v3 ad=0.65p pd=3.3u as=0.635p ps=3.27u w=1u l=0.28u
X2 a_718_407# a_650_n277# m2_540_79# w_n310_281# pfet_03v3 ad=0.675p pd=2.675u as=0.725p ps=2.725u w=2u l=0.28u
X3 a_517_n37# a_25_271# via_dev$11$1_4/VSUBS via_dev$11$1_4/VSUBS nfet_03v3 ad=0.3625p pd=1.725u as=0.54p ps=3.08u w=1u l=0.28u
X4 via_dev$11$1_4/VSUBS a_157_63# a_909_n37# via_dev$11$1_4/VSUBS nfet_03v3 ad=0.65p pd=3.3u as=0.3625p ps=1.725u w=1u l=0.28u
X5 m2_540_79# a_25_271# a_718_407# w_n310_281# pfet_03v3 ad=0.725p pd=2.725u as=1.09p ps=5.09u w=2u l=0.28u
X6 a_157_63# a_25_271# via_dev$11$1_4/VSUBS via_dev$11$1_4/VSUBS nfet_03v3 ad=0.315p pd=2.26u as=0.3175p ps=2.27u w=0.5u l=0.28u
X7 a_718_407# a_157_63# w_n310_281# w_n310_281# pfet_03v3 ad=1.3p pd=5.3u as=0.725p ps=2.725u w=2u l=0.28u
X8 a_909_n37# a_846_955# m2_540_79# via_dev$11$1_4/VSUBS nfet_03v3 ad=0.3625p pd=1.725u as=0.3375p ps=1.675u w=1u l=0.28u
X9 w_n310_281# a_846_955# a_718_407# w_n310_281# pfet_03v3 ad=0.725p pd=2.725u as=0.675p ps=2.675u w=2u l=0.28u
X10 a_1472_63# m2_540_79# w_n310_281# w_n310_281# pfet_03v3 ad=0.545p pd=3.09u as=0.53p ps=3.06u w=1u l=0.28u
X11 m2_540_79# a_650_n277# a_517_n37# via_dev$11$1_4/VSUBS nfet_03v3 ad=0.3375p pd=1.675u as=0.3625p ps=1.725u w=1u l=0.28u
C0 a_157_63# a_1472_63# 0.0156f
C1 m2_540_79# w_n310_281# 0.45246f
C2 m2_540_79# a_718_407# 0.49779f
C3 m2_540_79# a_1472_63# 0.0785f
C4 a_718_407# w_n310_281# 0.7633f
C5 a_157_63# a_25_271# 0.11031f
C6 a_1472_63# w_n310_281# 0.08851f
C7 a_157_63# a_909_n37# 0.01329f
C8 a_157_63# a_846_955# 0.07151f
C9 a_718_407# a_1472_63# 0.01268f
C10 a_25_271# m2_540_79# 0.03352f
C11 a_909_n37# m2_540_79# 0.01048f
C12 a_25_271# w_n310_281# 0.47695f
C13 a_846_955# m2_540_79# 0.017f
C14 a_25_271# a_718_407# 0.03028f
C15 a_846_955# w_n310_281# 0.19275f
C16 a_25_271# a_1472_63# 0
C17 a_846_955# a_718_407# 0.01845f
C18 a_846_955# a_1472_63# 0
C19 a_157_63# a_650_n277# 0.02096f
C20 m2_540_79# a_650_n277# 0.03687f
C21 a_650_n277# w_n310_281# 0.11257f
C22 a_718_407# a_650_n277# 0.01687f
C23 a_1472_63# a_650_n277# 0
C24 a_517_n37# a_157_63# 0.00935f
C25 a_25_271# a_650_n277# 0.03814f
C26 a_517_n37# m2_540_79# 0.01733f
C27 a_846_955# a_650_n277# 0.04128f
C28 a_517_n37# a_718_407# 0
C29 a_157_63# m2_540_79# 0.36591f
C30 a_157_63# w_n310_281# 0.32876f
C31 a_157_63# a_718_407# 0.14486f
C32 m2_540_79# via_dev$11$1_4/VSUBS 0.94619f
C33 a_718_407# via_dev$11$1_4/VSUBS 0.15332f
C34 a_909_n37# via_dev$11$1_4/VSUBS 0.01743f
C35 a_517_n37# via_dev$11$1_4/VSUBS 0.007f
C36 a_1472_63# via_dev$11$1_4/VSUBS 0.17898f
C37 a_157_63# via_dev$11$1_4/VSUBS 0.63396f
C38 a_650_n277# via_dev$11$1_4/VSUBS 0.37069f
C39 a_25_271# via_dev$11$1_4/VSUBS 0.66513f
C40 a_846_955# via_dev$11$1_4/VSUBS 0.36058f
C41 w_n310_281# via_dev$11$1_4/VSUBS 4.18701f
.ends

.subckt x1bitblock$4 a_2861_3# a_8361_407# a_6520_n37# a_1262_n37# a_2861_391# a_1845_466#
+ a_10906_n37# a_510_63# a_870_n37# a_6721_407# a_9800_n37# a_11480_63# a_6128_n37#
+ a_5768_63# m2_6151_79# a_3498_3# a_11922_391# a_5042_n37# a_9408_n37# a_8918_357#
+ a_9609_407# a_5042_407# a_8160_n37# a_4158_271# a_11922_3# a_2419_63# m2_9431_79#
+ a_10906_466# a_4650_n37# a_9050_63# a_5243_407# a_7768_n37# a_3940_63# m2_7791_79#
+ a_10363_63# a_160_63# a_4290_63# a_7083_63# a_705_407# a_12559_3# a_7410_63# m2_5700_324#
+ a_1845_n37# via_dev$5$4_9/VSUBS m2_1295_79# a_8723_63# a_378_271# w_n310_281# m2_24_342#
X0 a_2419_63# a_1845_466# via_dev$5$4_9/VSUBS via_dev$5$4_9/VSUBS nfet_03v3 ad=0.315p pd=2.26u as=0.2425p ps=1.97u w=0.5u l=0.28u
X1 a_1845_466# m2_24_342# a_1845_n37# via_dev$5$4_9/VSUBS nfet_03v3 ad=0.65p pd=3.3u as=0.42p ps=1.84u w=1u l=0.28u
X2 a_3940_63# m2_1295_79# w_n310_281# w_n310_281# pfet_03v3 ad=0.63p pd=3.26u as=0.65p ps=3.3u w=1u l=0.28u
X3 via_dev$5$4_9/VSUBS a_510_63# a_1262_n37# via_dev$5$4_9/VSUBS nfet_03v3 ad=0.65p pd=3.3u as=0.3625p ps=1.725u w=1u l=0.28u
X4 a_5243_407# a_4290_63# a_5042_407# w_n310_281# pfet_03v3 ad=1.3p pd=5.3u as=0.725p ps=2.725u w=2u l=0.28u
X5 a_6721_407# a_2419_63# m2_6151_79# w_n310_281# pfet_03v3 ad=0.675p pd=2.675u as=0.725p ps=2.725u w=2u l=0.28u
X6 a_10906_466# a_4158_271# w_n310_281# w_n310_281# pfet_03v3 ad=0.42p pd=1.84u as=0.65p ps=3.3u w=1u l=0.28u
X7 a_4290_63# a_4158_271# via_dev$5$4_9/VSUBS via_dev$5$4_9/VSUBS nfet_03v3 ad=0.315p pd=2.26u as=0.28p ps=2.12u w=0.5u l=0.28u
X8 w_n310_281# a_378_271# a_705_407# w_n310_281# pfet_03v3 ad=0.725p pd=2.725u as=1.09p ps=5.09u w=2u l=0.28u
X9 a_2861_3# m2_1295_79# via_dev$5$4_9/VSUBS via_dev$5$4_9/VSUBS nfet_03v3 ad=0.18125p pd=1.225u as=0.325p ps=2.3u w=0.5u l=0.28u
X10 via_dev$5$4_9/VSUBS a_2419_63# a_2861_3# via_dev$5$4_9/VSUBS nfet_03v3 ad=0.315p pd=2.26u as=0.18125p ps=1.225u w=0.5u l=0.28u
X11 m2_7791_79# m2_1295_79# a_7768_n37# via_dev$5$4_9/VSUBS nfet_03v3 ad=0.3375p pd=1.675u as=0.3625p ps=1.725u w=1u l=0.28u
X12 a_10906_n37# a_4158_271# via_dev$5$4_9/VSUBS via_dev$5$4_9/VSUBS nfet_03v3 ad=0.42p pd=1.84u as=0.63p ps=3.26u w=1u l=0.28u
X13 a_9050_63# a_8918_357# via_dev$5$4_9/VSUBS via_dev$5$4_9/VSUBS nfet_03v3 ad=0.31p pd=2.24u as=0.24p ps=1.96u w=0.5u l=0.28u
X14 a_11922_3# a_11480_63# via_dev$5$4_9/VSUBS via_dev$5$4_9/VSUBS nfet_03v3 ad=0.18125p pd=1.225u as=0.325p ps=2.3u w=0.5u l=0.28u
X15 via_dev$5$4_9/VSUBS a_2419_63# a_11922_3# via_dev$5$4_9/VSUBS nfet_03v3 ad=0.315p pd=2.26u as=0.18125p ps=1.225u w=0.5u l=0.28u
X16 a_705_407# a_510_63# m2_1295_79# w_n310_281# pfet_03v3 ad=1.3p pd=5.3u as=0.725p ps=2.725u w=2u l=0.28u
X17 a_4650_n37# a_4158_271# via_dev$5$4_9/VSUBS via_dev$5$4_9/VSUBS nfet_03v3 ad=0.3625p pd=1.725u as=0.54p ps=3.08u w=1u l=0.28u
X18 a_2861_3# a_2419_63# a_2861_391# w_n310_281# pfet_03v3 ad=1.3p pd=5.3u as=0.725p ps=2.725u w=2u l=0.28u
X19 a_5768_63# m2_5700_324# via_dev$5$4_9/VSUBS via_dev$5$4_9/VSUBS nfet_03v3 ad=0.315p pd=2.26u as=0.3175p ps=2.27u w=0.5u l=0.28u
X20 via_dev$5$4_9/VSUBS a_9050_63# a_9800_n37# via_dev$5$4_9/VSUBS nfet_03v3 ad=0.65p pd=3.3u as=0.3625p ps=1.725u w=1u l=0.28u
X21 a_8361_407# m2_1295_79# m2_7791_79# w_n310_281# pfet_03v3 ad=0.675p pd=2.675u as=0.725p ps=2.725u w=2u l=0.28u
X22 a_9408_n37# a_8918_357# via_dev$5$4_9/VSUBS via_dev$5$4_9/VSUBS nfet_03v3 ad=0.3625p pd=1.725u as=0.54p ps=3.08u w=1u l=0.28u
X23 a_3498_3# a_2861_3# w_n310_281# w_n310_281# pfet_03v3 ad=0.65p pd=3.3u as=0.675p ps=3.35u w=1u l=0.28u
X24 a_7410_63# m2_5700_324# via_dev$5$4_9/VSUBS via_dev$5$4_9/VSUBS nfet_03v3 ad=0.31p pd=2.24u as=0.24p ps=1.96u w=0.5u l=0.28u
X25 via_dev$5$4_9/VSUBS a_7410_63# a_8160_n37# via_dev$5$4_9/VSUBS nfet_03v3 ad=0.65p pd=3.3u as=0.3625p ps=1.725u w=1u l=0.28u
X26 a_8723_63# m2_7791_79# via_dev$5$4_9/VSUBS via_dev$5$4_9/VSUBS nfet_03v3 ad=0.2625p pd=2.05u as=0.265p ps=2.06u w=0.5u l=0.28u
X27 w_n310_281# a_4158_271# a_5243_407# w_n310_281# pfet_03v3 ad=0.725p pd=2.725u as=1.09p ps=5.09u w=2u l=0.28u
X28 a_5768_63# m2_5700_324# w_n310_281# w_n310_281# pfet_03v3 ad=0.65p pd=3.3u as=0.635p ps=3.27u w=1u l=0.28u
X29 a_9050_63# a_8918_357# w_n310_281# w_n310_281# pfet_03v3 ad=0.64p pd=3.28u as=0.48p ps=2.96u w=1u l=0.28u
X30 a_11922_391# a_11480_63# w_n310_281# w_n310_281# pfet_03v3 ad=0.725p pd=2.725u as=1.3p ps=5.3u w=2u l=0.28u
X31 a_160_63# m2_24_342# via_dev$5$4_9/VSUBS via_dev$5$4_9/VSUBS nfet_03v3 ad=0.315p pd=2.26u as=0.325p ps=2.3u w=0.5u l=0.28u
X32 a_9609_407# a_9050_63# w_n310_281# w_n310_281# pfet_03v3 ad=1.3p pd=5.3u as=0.725p ps=2.725u w=2u l=0.28u
X33 a_6128_n37# m2_5700_324# via_dev$5$4_9/VSUBS via_dev$5$4_9/VSUBS nfet_03v3 ad=0.3625p pd=1.725u as=0.54p ps=3.08u w=1u l=0.28u
X34 via_dev$5$4_9/VSUBS a_5768_63# a_6520_n37# via_dev$5$4_9/VSUBS nfet_03v3 ad=0.65p pd=3.3u as=0.3625p ps=1.725u w=1u l=0.28u
X35 a_7410_63# m2_5700_324# w_n310_281# w_n310_281# pfet_03v3 ad=0.64p pd=3.28u as=0.48p ps=2.96u w=1u l=0.28u
X36 m2_9431_79# a_8918_357# a_9609_407# w_n310_281# pfet_03v3 ad=0.725p pd=2.725u as=1.09p ps=5.09u w=2u l=0.28u
X37 a_11480_63# a_10906_466# via_dev$5$4_9/VSUBS via_dev$5$4_9/VSUBS nfet_03v3 ad=0.315p pd=2.26u as=0.2425p ps=1.97u w=0.5u l=0.28u
X38 a_1845_466# a_378_271# w_n310_281# w_n310_281# pfet_03v3 ad=0.42p pd=1.84u as=0.65p ps=3.3u w=1u l=0.28u
X39 a_8361_407# a_7410_63# w_n310_281# w_n310_281# pfet_03v3 ad=1.3p pd=5.3u as=0.725p ps=2.725u w=2u l=0.28u
X40 w_n310_281# m2_1295_79# a_10906_466# w_n310_281# pfet_03v3 ad=0.735p pd=2.47u as=0.42p ps=1.84u w=1u l=0.28u
X41 a_7083_63# m2_6151_79# via_dev$5$4_9/VSUBS via_dev$5$4_9/VSUBS nfet_03v3 ad=0.2625p pd=2.05u as=0.265p ps=2.06u w=0.5u l=0.28u
X42 a_510_63# a_378_271# w_n310_281# w_n310_281# pfet_03v3 ad=0.65p pd=3.3u as=0.56p ps=3.12u w=1u l=0.28u
X43 a_10363_63# m2_9431_79# w_n310_281# w_n310_281# pfet_03v3 ad=0.715p pd=3.43u as=0.53p ps=3.06u w=1u l=0.28u
X44 a_510_63# a_378_271# via_dev$5$4_9/VSUBS via_dev$5$4_9/VSUBS nfet_03v3 ad=0.315p pd=2.26u as=0.28p ps=2.12u w=0.5u l=0.28u
X45 a_1262_n37# a_160_63# m2_1295_79# via_dev$5$4_9/VSUBS nfet_03v3 ad=0.3625p pd=1.725u as=0.3375p ps=1.675u w=1u l=0.28u
X46 a_1845_n37# a_378_271# via_dev$5$4_9/VSUBS via_dev$5$4_9/VSUBS nfet_03v3 ad=0.42p pd=1.84u as=0.63p ps=3.26u w=1u l=0.28u
X47 m2_6151_79# m2_5700_324# a_6721_407# w_n310_281# pfet_03v3 ad=0.725p pd=2.725u as=1.09p ps=5.09u w=2u l=0.28u
X48 a_6721_407# a_5768_63# w_n310_281# w_n310_281# pfet_03v3 ad=1.3p pd=5.3u as=0.725p ps=2.725u w=2u l=0.28u
X49 a_10363_63# m2_9431_79# via_dev$5$4_9/VSUBS via_dev$5$4_9/VSUBS nfet_03v3 ad=0.3575p pd=2.43u as=0.265p ps=2.06u w=0.5u l=0.28u
X50 a_10906_466# m2_1295_79# a_10906_n37# via_dev$5$4_9/VSUBS nfet_03v3 ad=0.65p pd=3.3u as=0.42p ps=1.84u w=1u l=0.28u
X51 a_8723_63# m2_7791_79# w_n310_281# w_n310_281# pfet_03v3 ad=0.545p pd=3.09u as=0.53p ps=3.06u w=1u l=0.28u
X52 a_11480_63# a_10906_466# w_n310_281# w_n310_281# pfet_03v3 ad=0.65p pd=3.3u as=0.735p ps=2.47u w=1u l=0.28u
X53 a_12559_3# a_11922_3# via_dev$5$4_9/VSUBS via_dev$5$4_9/VSUBS nfet_03v3 ad=0.315p pd=2.26u as=0.325p ps=2.3u w=0.5u l=0.28u
X54 a_7083_63# m2_6151_79# w_n310_281# w_n310_281# pfet_03v3 ad=0.545p pd=3.09u as=0.53p ps=3.06u w=1u l=0.28u
X55 a_7768_n37# m2_5700_324# via_dev$5$4_9/VSUBS via_dev$5$4_9/VSUBS nfet_03v3 ad=0.3625p pd=1.725u as=0.54p ps=3.08u w=1u l=0.28u
X56 a_160_63# m2_24_342# w_n310_281# w_n310_281# pfet_03v3 ad=0.63p pd=3.26u as=0.65p ps=3.3u w=1u l=0.28u
X57 m2_1295_79# a_160_63# a_705_407# w_n310_281# pfet_03v3 ad=0.725p pd=2.725u as=0.675p ps=2.675u w=2u l=0.28u
X58 a_5042_n37# a_3940_63# a_5042_407# via_dev$5$4_9/VSUBS nfet_03v3 ad=0.3625p pd=1.725u as=0.3375p ps=1.675u w=1u l=0.28u
X59 m2_1295_79# m2_24_342# a_870_n37# via_dev$5$4_9/VSUBS nfet_03v3 ad=0.3375p pd=1.675u as=0.3625p ps=1.725u w=1u l=0.28u
X60 a_11922_3# a_2419_63# a_11922_391# w_n310_281# pfet_03v3 ad=1.3p pd=5.3u as=0.725p ps=2.725u w=2u l=0.28u
X61 a_9800_n37# a_7083_63# m2_9431_79# via_dev$5$4_9/VSUBS nfet_03v3 ad=0.3625p pd=1.725u as=0.3375p ps=1.675u w=1u l=0.28u
X62 m2_7791_79# m2_5700_324# a_8361_407# w_n310_281# pfet_03v3 ad=0.725p pd=2.725u as=1.09p ps=5.09u w=2u l=0.28u
X63 a_5042_407# a_3940_63# a_5243_407# w_n310_281# pfet_03v3 ad=0.725p pd=2.725u as=0.675p ps=2.675u w=2u l=0.28u
X64 a_3940_63# m2_1295_79# via_dev$5$4_9/VSUBS via_dev$5$4_9/VSUBS nfet_03v3 ad=0.315p pd=2.26u as=0.325p ps=2.3u w=0.5u l=0.28u
X65 a_8160_n37# a_3498_3# m2_7791_79# via_dev$5$4_9/VSUBS nfet_03v3 ad=0.3625p pd=1.725u as=0.3375p ps=1.675u w=1u l=0.28u
X66 a_705_407# m2_24_342# w_n310_281# w_n310_281# pfet_03v3 ad=0.675p pd=2.675u as=0.725p ps=2.725u w=2u l=0.28u
X67 a_5042_407# m2_1295_79# a_4650_n37# via_dev$5$4_9/VSUBS nfet_03v3 ad=0.3375p pd=1.675u as=0.3625p ps=1.725u w=1u l=0.28u
X68 a_6520_n37# a_5042_407# m2_6151_79# via_dev$5$4_9/VSUBS nfet_03v3 ad=0.3625p pd=1.725u as=0.3375p ps=1.675u w=1u l=0.28u
X69 w_n310_281# a_7083_63# a_9609_407# w_n310_281# pfet_03v3 ad=0.725p pd=2.725u as=0.675p ps=2.675u w=2u l=0.28u
X70 a_2419_63# a_1845_466# w_n310_281# w_n310_281# pfet_03v3 ad=0.65p pd=3.3u as=0.735p ps=2.47u w=1u l=0.28u
X71 m2_9431_79# a_8723_63# a_9408_n37# via_dev$5$4_9/VSUBS nfet_03v3 ad=0.3375p pd=1.675u as=0.3625p ps=1.725u w=1u l=0.28u
X72 w_n310_281# a_3498_3# a_8361_407# w_n310_281# pfet_03v3 ad=0.725p pd=2.725u as=0.675p ps=2.675u w=2u l=0.28u
X73 a_2861_391# m2_1295_79# w_n310_281# w_n310_281# pfet_03v3 ad=0.725p pd=2.725u as=1.3p ps=5.3u w=2u l=0.28u
X74 a_4290_63# a_4158_271# w_n310_281# w_n310_281# pfet_03v3 ad=0.65p pd=3.3u as=0.56p ps=3.12u w=1u l=0.28u
X75 a_5243_407# m2_1295_79# w_n310_281# w_n310_281# pfet_03v3 ad=0.675p pd=2.675u as=0.725p ps=2.725u w=2u l=0.28u
X76 w_n310_281# a_5042_407# a_6721_407# w_n310_281# pfet_03v3 ad=0.725p pd=2.725u as=0.675p ps=2.675u w=2u l=0.28u
X77 a_3498_3# a_2861_3# via_dev$5$4_9/VSUBS via_dev$5$4_9/VSUBS nfet_03v3 ad=0.315p pd=2.26u as=0.325p ps=2.3u w=0.5u l=0.28u
X78 a_9609_407# a_8723_63# m2_9431_79# w_n310_281# pfet_03v3 ad=0.675p pd=2.675u as=0.725p ps=2.725u w=2u l=0.28u
X79 via_dev$5$4_9/VSUBS a_4290_63# a_5042_n37# via_dev$5$4_9/VSUBS nfet_03v3 ad=0.65p pd=3.3u as=0.3625p ps=1.725u w=1u l=0.28u
X80 m2_6151_79# a_2419_63# a_6128_n37# via_dev$5$4_9/VSUBS nfet_03v3 ad=0.3375p pd=1.675u as=0.3625p ps=1.725u w=1u l=0.28u
X81 w_n310_281# m2_24_342# a_1845_466# w_n310_281# pfet_03v3 ad=0.735p pd=2.47u as=0.42p ps=1.84u w=1u l=0.28u
X82 a_870_n37# a_378_271# via_dev$5$4_9/VSUBS via_dev$5$4_9/VSUBS nfet_03v3 ad=0.3625p pd=1.725u as=0.54p ps=3.08u w=1u l=0.28u
X83 a_12559_3# a_11922_3# w_n310_281# w_n310_281# pfet_03v3 ad=0.65p pd=3.3u as=0.675p ps=3.35u w=1u l=0.28u
C0 m2_7791_79# a_5768_63# 0
C1 a_705_407# m2_24_342# 0.10607f
C2 m2_5700_324# a_7410_63# 0.14432f
C3 a_11922_3# a_11922_391# 0.01891f
C4 m2_5700_324# a_8918_357# 0
C5 a_2419_63# a_8361_407# 0
C6 m2_5700_324# a_4158_271# 0.00861f
C7 a_378_271# a_1845_466# 0.01278f
C8 m2_5700_324# a_5042_407# 0.06917f
C9 a_12559_3# w_n310_281# 0.08598f
C10 w_n310_281# a_1845_466# 0.44517f
C11 a_5243_407# a_2861_3# 0
C12 a_3940_63# a_2419_63# 0.00879f
C13 a_510_63# m2_24_342# 0.13025f
C14 a_9050_63# a_2419_63# 0.00801f
C15 a_3498_3# m2_24_342# 0
C16 a_2419_63# a_4290_63# 0.00652f
C17 m2_1295_79# a_1845_466# 0.09644f
C18 w_n310_281# a_7083_63# 0.31663f
C19 a_3498_3# m2_6151_79# 0
C20 w_n310_281# a_10906_n37# 0
C21 w_n310_281# a_2861_391# 0.03535f
C22 a_8918_357# a_7410_63# 0
C23 m2_6151_79# a_6721_407# 0.4935f
C24 m2_1295_79# a_7083_63# 0.01071f
C25 a_3940_63# a_5768_63# 0
C26 a_7410_63# a_4158_271# 0
C27 m2_1295_79# a_2861_391# 0.00841f
C28 a_7768_n37# m2_9431_79# 0
C29 a_5768_63# a_4290_63# 0.01093f
C30 a_8918_357# a_4158_271# 0.00101f
C31 a_10906_466# w_n310_281# 0.44509f
C32 a_5042_407# a_7410_63# 0
C33 w_n310_281# a_9609_407# 0.7653f
C34 a_1262_n37# m2_1295_79# 0.01607f
C35 a_10906_466# m2_1295_79# 0.0692f
C36 m2_5700_324# m2_7791_79# 0.05245f
C37 m2_1295_79# a_9609_407# 0.0093f
C38 a_5042_407# a_4158_271# 0.63867f
C39 a_6128_n37# a_5768_63# 0.00935f
C40 a_705_407# a_378_271# 0.02817f
C41 a_705_407# w_n310_281# 0.79414f
C42 a_705_407# m2_1295_79# 0.30816f
C43 a_2419_63# a_11922_391# 0.00754f
C44 a_5243_407# a_2419_63# 0
C45 a_510_63# a_378_271# 0.14298f
C46 m2_7791_79# a_7410_63# 0.36168f
C47 a_11480_63# a_4158_271# 0.00295f
C48 a_510_63# w_n310_281# 0.28255f
C49 m2_5700_324# a_8361_407# 0.05956f
C50 a_3498_3# w_n310_281# 1.03377f
C51 a_8918_357# m2_7791_79# 0.02763f
C52 a_9800_n37# m2_9431_79# 0.0074f
C53 a_6520_n37# a_5768_63# 0.01329f
C54 m2_7791_79# a_4158_271# 0
C55 a_10906_466# a_12559_3# 0
C56 a_1262_n37# a_1845_466# 0
C57 a_5243_407# a_5768_63# 0.00722f
C58 a_6721_407# w_n310_281# 0.72579f
C59 a_510_63# m2_1295_79# 0.39896f
C60 a_3498_3# m2_1295_79# 0.3391f
C61 m2_5700_324# a_3940_63# 0.00132f
C62 m2_7791_79# a_5042_407# 0.00555f
C63 a_11922_3# w_n310_281# 0.46598f
C64 m2_5700_324# a_4290_63# 0.01531f
C65 a_6721_407# m2_1295_79# 0.00452f
C66 a_10906_466# a_7083_63# 0
C67 a_9609_407# a_7083_63# 0.0285f
C68 a_10906_466# a_10906_n37# 0.01333f
C69 a_2419_63# m2_24_342# 0.00234f
C70 a_11922_3# m2_1295_79# 0
C71 a_705_407# a_1845_466# 0.0126f
C72 a_8361_407# a_7410_63# 0.1423f
C73 w_n310_281# a_2861_3# 0.4655f
C74 m2_6151_79# a_2419_63# 0.05852f
C75 a_8918_357# a_8361_407# 0
C76 a_10906_466# a_9609_407# 0
C77 a_8723_63# w_n310_281# 0.33516f
C78 a_705_407# a_2861_391# 0
C79 m2_1295_79# a_2861_3# 0.15381f
C80 w_n310_281# m2_9431_79# 0.46253f
C81 a_8723_63# m2_1295_79# 0.00796f
C82 a_8918_357# a_9050_63# 0.09973f
C83 a_3940_63# a_4158_271# 0.16366f
C84 a_1262_n37# a_705_407# 0
C85 a_510_63# a_1845_466# 0.01433f
C86 w_n310_281# a_10363_63# 0.15741f
C87 a_3498_3# a_1845_466# 0.00105f
C88 m2_6151_79# a_5768_63# 0.35511f
C89 a_9050_63# a_4158_271# 0.00717f
C90 m2_1295_79# m2_9431_79# 0.0078f
C91 a_4290_63# a_4158_271# 0.11363f
C92 a_3940_63# a_5042_407# 0.0941f
C93 m2_1295_79# a_10363_63# 0.00179f
C94 a_9408_n37# a_7083_63# 0.00336f
C95 a_5042_407# a_4290_63# 0.38112f
C96 a_3498_3# a_7083_63# 0.01356f
C97 a_11922_3# a_12559_3# 0.0899f
C98 a_3498_3# a_2861_391# 0.00454f
C99 a_5243_407# m2_5700_324# 0.01927f
C100 a_6721_407# a_7083_63# 0.01268f
C101 a_1262_n37# a_510_63# 0.00898f
C102 a_6128_n37# a_5042_407# 0.00376f
C103 a_9408_n37# a_9609_407# 0
C104 a_870_n37# a_160_63# 0.00441f
C105 a_2861_3# a_1845_466# 0
C106 m2_7791_79# a_8361_407# 0.49779f
C107 a_2419_63# w_n310_281# 0.75124f
C108 a_11922_3# a_10906_466# 0
C109 a_8160_n37# a_7083_63# 0.00507f
C110 a_510_63# a_705_407# 0.13828f
C111 a_9050_63# m2_7791_79# 0.00127f
C112 a_2861_3# a_2861_391# 0.01616f
C113 a_2419_63# m2_1295_79# 0.3246f
C114 a_8723_63# a_7083_63# 0.15796f
C115 a_6520_n37# a_4158_271# 0.00406f
C116 w_n310_281# a_1845_n37# 0
C117 a_7083_63# m2_9431_79# 0.19293f
C118 a_5243_407# a_4158_271# 0.02964f
C119 a_7768_n37# a_7410_63# 0.00935f
C120 w_n310_281# a_5768_63# 0.31314f
C121 a_5042_n37# a_4158_271# 0
C122 m2_5700_324# m2_6151_79# 0.14941f
C123 a_7083_63# a_10363_63# 0.00582f
C124 a_6520_n37# a_5042_407# 0.00483f
C125 a_5243_407# a_5042_407# 0.29512f
C126 m2_1295_79# a_1845_n37# 0.00942f
C127 a_10906_n37# a_10363_63# 0
C128 a_5042_n37# a_5042_407# 0.01726f
C129 a_8723_63# a_9609_407# 0.0593f
C130 m2_1295_79# a_5768_63# 0.00766f
C131 a_10906_466# m2_9431_79# 0.00167f
C132 a_9609_407# m2_9431_79# 0.49779f
C133 a_3498_3# a_6721_407# 0
C134 a_705_407# a_2861_3# 0
C135 a_10906_466# a_10363_63# 0.02047f
C136 a_9609_407# a_10363_63# 0.01306f
C137 a_9050_63# a_8361_407# 0
C138 a_2419_63# a_12559_3# 0
C139 a_2419_63# a_1845_466# 0.10509f
C140 m2_6151_79# a_7410_63# 0
C141 a_11480_63# a_11922_391# 0.00152f
C142 a_3940_63# a_4290_63# 0.28903f
C143 a_2419_63# a_7083_63# 0.01345f
C144 m2_6151_79# a_4158_271# 0.04334f
C145 a_3498_3# a_2861_3# 0.09846f
C146 a_2419_63# a_2861_391# 0.0163f
C147 a_1845_n37# a_1845_466# 0.01333f
C148 m2_6151_79# a_5042_407# 0.20459f
C149 a_3498_3# a_8723_63# 0.00575f
C150 a_7768_n37# m2_7791_79# 0.01733f
C151 a_9408_n37# m2_9431_79# 0.01733f
C152 a_9800_n37# a_4158_271# 0.00497f
C153 a_3498_3# m2_9431_79# 0
C154 a_10906_466# a_2419_63# 0.00833f
C155 a_2419_63# a_9609_407# 0
C156 m2_5700_324# w_n310_281# 1.65678f
C157 a_5768_63# a_7083_63# 0.01494f
C158 m2_5700_324# m2_1295_79# 0.07849f
C159 a_705_407# a_2419_63# 0
C160 a_5243_407# a_3940_63# 0.06737f
C161 a_7768_n37# a_8361_407# 0
C162 m2_6151_79# m2_7791_79# 0.00114f
C163 a_8160_n37# m2_9431_79# 0
C164 w_n310_281# a_7410_63# 0.31086f
C165 a_5243_407# a_4290_63# 0.14023f
C166 a_8918_357# w_n310_281# 0.49453f
C167 a_8723_63# m2_9431_79# 0.13485f
C168 a_5042_n37# a_4290_63# 0.00898f
C169 m2_1295_79# a_7410_63# 0.07614f
C170 w_n310_281# a_4158_271# 0.66883f
C171 a_8723_63# a_10363_63# 0
C172 a_3498_3# a_2419_63# 0.01177f
C173 a_8918_357# m2_1295_79# 0.01371f
C174 a_4650_n37# a_4158_271# 0.00383f
C175 w_n310_281# a_5042_407# 0.29911f
C176 a_10363_63# m2_9431_79# 0.07766f
C177 a_6721_407# a_2419_63# 0.01825f
C178 m2_1295_79# a_4158_271# 0.16058f
C179 m2_24_342# a_160_63# 0.42316f
C180 a_4650_n37# a_5042_407# 0.00712f
C181 m2_1295_79# a_5042_407# 0.03487f
C182 a_11922_3# a_2419_63# 0.16984f
C183 a_510_63# a_1845_n37# 0.0011f
C184 a_3498_3# a_5768_63# 0
C185 m2_5700_324# a_7083_63# 0.12051f
C186 a_6721_407# a_5768_63# 0.14017f
C187 a_2419_63# a_2861_3# 0.21478f
C188 m2_6151_79# a_4290_63# 0
C189 a_11480_63# w_n310_281# 0.37298f
C190 a_8723_63# a_2419_63# 0.00649f
C191 m2_7791_79# w_n310_281# 0.45143f
C192 a_11480_63# m2_1295_79# 0.00126f
C193 a_2419_63# m2_9431_79# 0.00832f
C194 a_5243_407# a_5042_n37# 0
C195 a_9800_n37# a_9050_63# 0.01329f
C196 m2_6151_79# a_6128_n37# 0.01733f
C197 a_7083_63# a_7410_63# 0.07718f
C198 a_2419_63# a_10363_63# 0.00126f
C199 a_870_n37# m2_1295_79# 0.00639f
C200 m2_7791_79# m2_1295_79# 0.05731f
C201 a_8918_357# a_7083_63# 0.01057f
C202 a_7083_63# a_4158_271# 1.09133f
C203 a_10906_n37# a_4158_271# 0.00824f
C204 a_5042_407# a_7083_63# 0.02611f
C205 a_160_63# a_378_271# 0.09182f
C206 a_8918_357# a_9609_407# 0.02942f
C207 a_10906_466# a_4158_271# 0.03873f
C208 w_n310_281# a_160_63# 0.30515f
C209 w_n310_281# a_8361_407# 0.75753f
C210 a_9609_407# a_4158_271# 0
C211 m2_5700_324# a_3498_3# 0.55174f
C212 m2_1295_79# a_160_63# 0.09339f
C213 m2_5700_324# a_6721_407# 0.50857f
C214 m2_1295_79# a_8361_407# 0.02509f
C215 a_6520_n37# m2_6151_79# 0.00766f
C216 a_3940_63# w_n310_281# 0.30087f
C217 a_9050_63# w_n310_281# 0.28931f
C218 m2_6151_79# a_5042_n37# 0
C219 w_n310_281# a_4290_63# 0.2819f
C220 a_3940_63# a_4650_n37# 0.00441f
C221 a_870_n37# a_1845_466# 0
C222 a_3940_63# m2_1295_79# 0.46061f
C223 a_4650_n37# a_4290_63# 0.01502f
C224 a_9050_63# m2_1295_79# 0.00716f
C225 m2_1295_79# a_4290_63# 0.13519f
C226 m2_7791_79# a_7083_63# 0.14708f
C227 a_2419_63# a_5768_63# 0.07749f
C228 a_3498_3# a_7410_63# 0.11774f
C229 a_11480_63# a_10906_466# 0.1131f
C230 a_11480_63# a_9609_407# 0
C231 m2_5700_324# a_8723_63# 0
C232 a_3498_3# a_4158_271# 0.00829f
C233 m2_7791_79# a_9609_407# 0
C234 a_3498_3# a_5042_407# 0.02015f
C235 a_160_63# a_1845_466# 0
C236 a_6721_407# a_5042_407# 0.03265f
C237 a_11922_3# a_4158_271# 0.0013f
C238 a_8361_407# a_7083_63# 0.01453f
C239 a_3940_63# a_1845_466# 0
C240 a_8160_n37# a_7410_63# 0.01329f
C241 w_n310_281# a_11922_391# 0.03535f
C242 a_5243_407# w_n310_281# 0.78984f
C243 a_8723_63# a_7410_63# 0.01398f
C244 a_9050_63# a_7083_63# 0.21474f
C245 a_8918_357# a_8723_63# 0.1249f
C246 a_5243_407# m2_1295_79# 0.10989f
C247 m2_9431_79# a_7410_63# 0.00105f
C248 a_8361_407# a_9609_407# 0.00466f
C249 a_8723_63# a_4158_271# 0
C250 a_2861_3# a_5042_407# 0
C251 a_8918_357# m2_9431_79# 0.03217f
C252 a_870_n37# a_510_63# 0.01502f
C253 a_9408_n37# m2_7791_79# 0
C254 m2_9431_79# a_4158_271# 0.05572f
C255 a_3498_3# m2_7791_79# 0.0296f
C256 a_8918_357# a_10363_63# 0
C257 m2_5700_324# a_2419_63# 0.074f
C258 a_9050_63# a_9609_407# 0.1261f
C259 a_10363_63# a_4158_271# 0.02222f
C260 a_705_407# a_160_63# 0.06737f
C261 a_11480_63# a_11922_3# 0.04054f
C262 m2_24_342# a_378_271# 0.56715f
C263 w_n310_281# m2_24_342# 0.66878f
C264 m2_1295_79# m2_24_342# 0.04399f
C265 m2_5700_324# a_5768_63# 0.16447f
C266 m2_6151_79# w_n310_281# 0.44301f
C267 a_510_63# a_160_63# 0.28903f
C268 a_8160_n37# m2_7791_79# 0.01048f
C269 m2_6151_79# m2_1295_79# 0.00667f
C270 a_2419_63# a_7410_63# 0.00801f
C271 a_3498_3# a_8361_407# 0.12093f
C272 a_8723_63# m2_7791_79# 0.08381f
C273 a_11480_63# m2_9431_79# 0
C274 a_8918_357# a_2419_63# 0.01449f
C275 a_6520_n37# a_7083_63# 0.00272f
C276 a_11480_63# a_10363_63# 0
C277 a_2419_63# a_4158_271# 0.14782f
C278 a_3498_3# a_3940_63# 0.04602f
C279 a_9408_n37# a_9050_63# 0.00935f
C280 m2_7791_79# m2_9431_79# 0.01571f
C281 a_3498_3# a_4290_63# 0.00876f
C282 a_2419_63# a_5042_407# 0.08051f
C283 a_7768_n37# a_7083_63# 0.0028f
C284 a_5768_63# a_4158_271# 0.00573f
C285 m2_24_342# a_1845_466# 0.06999f
C286 a_6128_n37# a_6721_407# 0
C287 a_5042_407# a_5768_63# 0.22596f
C288 a_8723_63# a_8361_407# 0.01268f
C289 a_3940_63# a_2861_3# 0
C290 w_n310_281# a_378_271# 0.63374f
C291 a_8361_407# m2_9431_79# 0
C292 a_2861_3# a_4290_63# 0
C293 a_11480_63# a_2419_63# 0.0769f
C294 a_9050_63# a_8723_63# 0.5277f
C295 m2_6151_79# a_7083_63# 0.08089f
C296 m2_1295_79# a_378_271# 0.02669f
C297 a_2419_63# m2_7791_79# 0.00843f
C298 m2_1295_79# w_n310_281# 2.35223f
C299 a_9050_63# m2_9431_79# 0.328f
C300 a_9050_63# a_10363_63# 0.01385f
C301 a_9800_n37# a_7083_63# 0.00527f
C302 a_5243_407# a_3498_3# 0.16427f
C303 a_4158_271# via_dev$5$4_9/VSUBS 2.6385f
C304 a_7083_63# via_dev$5$4_9/VSUBS 0.86585f
C305 a_8723_63# via_dev$5$4_9/VSUBS 0.40969f
C306 m2_9431_79# via_dev$5$4_9/VSUBS 0.75255f
C307 m2_7791_79# via_dev$5$4_9/VSUBS 0.74612f
C308 a_8361_407# via_dev$5$4_9/VSUBS 0.05216f
C309 m2_6151_79# via_dev$5$4_9/VSUBS 0.72815f
C310 a_6721_407# via_dev$5$4_9/VSUBS 0.01698f
C311 a_5042_407# via_dev$5$4_9/VSUBS 0.88916f
C312 a_3940_63# via_dev$5$4_9/VSUBS 0.46864f
C313 m2_1295_79# via_dev$5$4_9/VSUBS 3.34416f
C314 a_160_63# via_dev$5$4_9/VSUBS 0.5921f
C315 a_5243_407# via_dev$5$4_9/VSUBS 0.01661f
C316 a_705_407# via_dev$5$4_9/VSUBS 0.13677f
C317 a_3498_3# via_dev$5$4_9/VSUBS 1.27724f
C318 a_10906_n37# via_dev$5$4_9/VSUBS 0.02232f
C319 a_9800_n37# via_dev$5$4_9/VSUBS 0.01742f
C320 a_9408_n37# via_dev$5$4_9/VSUBS 0.007f
C321 a_8160_n37# via_dev$5$4_9/VSUBS 0.01743f
C322 a_7768_n37# via_dev$5$4_9/VSUBS 0.007f
C323 a_6520_n37# via_dev$5$4_9/VSUBS 0.01743f
C324 a_6128_n37# via_dev$5$4_9/VSUBS 0.007f
C325 a_5042_n37# via_dev$5$4_9/VSUBS 0.00833f
C326 a_4650_n37# via_dev$5$4_9/VSUBS 0.01565f
C327 a_12559_3# via_dev$5$4_9/VSUBS 0.19481f
C328 a_11922_3# via_dev$5$4_9/VSUBS 0.64569f
C329 a_11922_391# via_dev$5$4_9/VSUBS 0.00119f
C330 a_10906_466# via_dev$5$4_9/VSUBS 0.59796f
C331 a_11480_63# via_dev$5$4_9/VSUBS 0.42359f
C332 a_10363_63# via_dev$5$4_9/VSUBS 0.13924f
C333 a_9050_63# via_dev$5$4_9/VSUBS 0.53264f
C334 a_8918_357# via_dev$5$4_9/VSUBS 0.52045f
C335 a_7410_63# via_dev$5$4_9/VSUBS 0.53731f
C336 a_5768_63# via_dev$5$4_9/VSUBS 0.54f
C337 a_1845_n37# via_dev$5$4_9/VSUBS 0.01974f
C338 a_1262_n37# via_dev$5$4_9/VSUBS 0.0069f
C339 a_870_n37# via_dev$5$4_9/VSUBS 0.01517f
C340 a_4290_63# via_dev$5$4_9/VSUBS 0.57048f
C341 a_2861_3# via_dev$5$4_9/VSUBS 0.62907f
C342 a_1845_466# via_dev$5$4_9/VSUBS 0.59853f
C343 a_2419_63# via_dev$5$4_9/VSUBS 6.64114f
C344 a_510_63# via_dev$5$4_9/VSUBS 0.55998f
C345 a_378_271# via_dev$5$4_9/VSUBS 1.37769f
C346 w_n310_281# via_dev$5$4_9/VSUBS 27.06926f
C347 a_9609_407# via_dev$5$4_9/VSUBS 0.11967f
C348 m2_5700_324# via_dev$5$4_9/VSUBS 1.14834f
C349 m2_24_342# via_dev$5$4_9/VSUBS 1.98211f
.ends

.subckt x1bitblock$1$1 a_2861_3# a_8361_407# a_6520_n37# a_1262_n37# a_2861_391# a_1845_466#
+ a_10906_n37# a_510_63# a_870_n37# a_6721_407# a_9800_n37# m2_24_342# a_11480_63#
+ a_6128_n37# a_5768_63# m2_6151_79# a_11922_391# a_5042_n37# a_9408_n37# a_9609_407#
+ a_5042_407# a_8160_n37# a_4158_271# a_3498_3# a_11922_3# a_2419_63# m2_9431_79#
+ a_10906_466# a_4650_n37# a_9050_63# a_5243_407# a_7768_n37# a_160_63# a_3940_63#
+ a_8919_370# m2_7791_79# a_10363_63# a_4290_63# a_7083_63# a_705_407# a_12559_3#
+ a_7410_63# a_1845_n37# via_dev$5$1$1_9/VSUBS m2_5700_324# m2_1295_79# a_8723_63#
+ a_378_271# w_n310_281#
X0 a_2419_63# a_1845_466# via_dev$5$1$1_9/VSUBS via_dev$5$1$1_9/VSUBS nfet_03v3 ad=0.315p pd=2.26u as=0.2425p ps=1.97u w=0.5u l=0.28u
X1 a_1845_466# m2_24_342# a_1845_n37# via_dev$5$1$1_9/VSUBS nfet_03v3 ad=0.65p pd=3.3u as=0.42p ps=1.84u w=1u l=0.28u
X2 a_3940_63# m2_1295_79# w_n310_281# w_n310_281# pfet_03v3 ad=0.63p pd=3.26u as=0.65p ps=3.3u w=1u l=0.28u
X3 via_dev$5$1$1_9/VSUBS a_510_63# a_1262_n37# via_dev$5$1$1_9/VSUBS nfet_03v3 ad=0.65p pd=3.3u as=0.3625p ps=1.725u w=1u l=0.28u
X4 a_5243_407# a_4290_63# a_5042_407# w_n310_281# pfet_03v3 ad=1.3p pd=5.3u as=0.725p ps=2.725u w=2u l=0.28u
X5 a_6721_407# a_2419_63# m2_6151_79# w_n310_281# pfet_03v3 ad=0.675p pd=2.675u as=0.725p ps=2.725u w=2u l=0.28u
X6 a_10906_466# a_4158_271# w_n310_281# w_n310_281# pfet_03v3 ad=0.42p pd=1.84u as=0.65p ps=3.3u w=1u l=0.28u
X7 a_4290_63# a_4158_271# via_dev$5$1$1_9/VSUBS via_dev$5$1$1_9/VSUBS nfet_03v3 ad=0.315p pd=2.26u as=0.28p ps=2.12u w=0.5u l=0.28u
X8 w_n310_281# a_378_271# a_705_407# w_n310_281# pfet_03v3 ad=0.725p pd=2.725u as=1.09p ps=5.09u w=2u l=0.28u
X9 a_2861_3# m2_1295_79# via_dev$5$1$1_9/VSUBS via_dev$5$1$1_9/VSUBS nfet_03v3 ad=0.18125p pd=1.225u as=0.325p ps=2.3u w=0.5u l=0.28u
X10 via_dev$5$1$1_9/VSUBS a_2419_63# a_2861_3# via_dev$5$1$1_9/VSUBS nfet_03v3 ad=0.315p pd=2.26u as=0.18125p ps=1.225u w=0.5u l=0.28u
X11 m2_7791_79# m2_1295_79# a_7768_n37# via_dev$5$1$1_9/VSUBS nfet_03v3 ad=0.3375p pd=1.675u as=0.3625p ps=1.725u w=1u l=0.28u
X12 a_10906_n37# a_4158_271# via_dev$5$1$1_9/VSUBS via_dev$5$1$1_9/VSUBS nfet_03v3 ad=0.42p pd=1.84u as=0.63p ps=3.26u w=1u l=0.28u
X13 a_9050_63# a_8919_370# via_dev$5$1$1_9/VSUBS via_dev$5$1$1_9/VSUBS nfet_03v3 ad=0.31p pd=2.24u as=0.24p ps=1.96u w=0.5u l=0.28u
X14 a_11922_3# a_11480_63# via_dev$5$1$1_9/VSUBS via_dev$5$1$1_9/VSUBS nfet_03v3 ad=0.18125p pd=1.225u as=0.325p ps=2.3u w=0.5u l=0.28u
X15 via_dev$5$1$1_9/VSUBS a_2419_63# a_11922_3# via_dev$5$1$1_9/VSUBS nfet_03v3 ad=0.315p pd=2.26u as=0.18125p ps=1.225u w=0.5u l=0.28u
X16 a_705_407# a_510_63# m2_1295_79# w_n310_281# pfet_03v3 ad=1.3p pd=5.3u as=0.725p ps=2.725u w=2u l=0.28u
X17 a_4650_n37# a_4158_271# via_dev$5$1$1_9/VSUBS via_dev$5$1$1_9/VSUBS nfet_03v3 ad=0.3625p pd=1.725u as=0.54p ps=3.08u w=1u l=0.28u
X18 a_2861_3# a_2419_63# a_2861_391# w_n310_281# pfet_03v3 ad=1.3p pd=5.3u as=0.725p ps=2.725u w=2u l=0.28u
X19 a_5768_63# m2_5700_324# via_dev$5$1$1_9/VSUBS via_dev$5$1$1_9/VSUBS nfet_03v3 ad=0.315p pd=2.26u as=0.3175p ps=2.27u w=0.5u l=0.28u
X20 via_dev$5$1$1_9/VSUBS a_9050_63# a_9800_n37# via_dev$5$1$1_9/VSUBS nfet_03v3 ad=0.65p pd=3.3u as=0.3625p ps=1.725u w=1u l=0.28u
X21 a_8361_407# m2_1295_79# m2_7791_79# w_n310_281# pfet_03v3 ad=0.675p pd=2.675u as=0.725p ps=2.725u w=2u l=0.28u
X22 a_9408_n37# a_8919_370# via_dev$5$1$1_9/VSUBS via_dev$5$1$1_9/VSUBS nfet_03v3 ad=0.3625p pd=1.725u as=0.54p ps=3.08u w=1u l=0.28u
X23 a_3498_3# a_2861_3# w_n310_281# w_n310_281# pfet_03v3 ad=0.65p pd=3.3u as=0.675p ps=3.35u w=1u l=0.28u
X24 a_7410_63# m2_5700_324# via_dev$5$1$1_9/VSUBS via_dev$5$1$1_9/VSUBS nfet_03v3 ad=0.31p pd=2.24u as=0.24p ps=1.96u w=0.5u l=0.28u
X25 via_dev$5$1$1_9/VSUBS a_7410_63# a_8160_n37# via_dev$5$1$1_9/VSUBS nfet_03v3 ad=0.65p pd=3.3u as=0.3625p ps=1.725u w=1u l=0.28u
X26 a_8723_63# m2_7791_79# via_dev$5$1$1_9/VSUBS via_dev$5$1$1_9/VSUBS nfet_03v3 ad=0.2625p pd=2.05u as=0.265p ps=2.06u w=0.5u l=0.28u
X27 w_n310_281# a_4158_271# a_5243_407# w_n310_281# pfet_03v3 ad=0.725p pd=2.725u as=1.09p ps=5.09u w=2u l=0.28u
X28 a_5768_63# m2_5700_324# w_n310_281# w_n310_281# pfet_03v3 ad=0.65p pd=3.3u as=0.635p ps=3.27u w=1u l=0.28u
X29 a_9050_63# a_8919_370# w_n310_281# w_n310_281# pfet_03v3 ad=0.64p pd=3.28u as=0.48p ps=2.96u w=1u l=0.28u
X30 a_11922_391# a_11480_63# w_n310_281# w_n310_281# pfet_03v3 ad=0.725p pd=2.725u as=1.3p ps=5.3u w=2u l=0.28u
X31 a_160_63# m2_24_342# via_dev$5$1$1_9/VSUBS via_dev$5$1$1_9/VSUBS nfet_03v3 ad=0.315p pd=2.26u as=0.325p ps=2.3u w=0.5u l=0.28u
X32 a_9609_407# a_9050_63# w_n310_281# w_n310_281# pfet_03v3 ad=1.3p pd=5.3u as=0.725p ps=2.725u w=2u l=0.28u
X33 a_6128_n37# m2_5700_324# via_dev$5$1$1_9/VSUBS via_dev$5$1$1_9/VSUBS nfet_03v3 ad=0.3625p pd=1.725u as=0.54p ps=3.08u w=1u l=0.28u
X34 via_dev$5$1$1_9/VSUBS a_5768_63# a_6520_n37# via_dev$5$1$1_9/VSUBS nfet_03v3 ad=0.65p pd=3.3u as=0.3625p ps=1.725u w=1u l=0.28u
X35 a_7410_63# m2_5700_324# w_n310_281# w_n310_281# pfet_03v3 ad=0.64p pd=3.28u as=0.48p ps=2.96u w=1u l=0.28u
X36 m2_9431_79# a_8919_370# a_9609_407# w_n310_281# pfet_03v3 ad=0.725p pd=2.725u as=1.09p ps=5.09u w=2u l=0.28u
X37 a_11480_63# a_10906_466# via_dev$5$1$1_9/VSUBS via_dev$5$1$1_9/VSUBS nfet_03v3 ad=0.315p pd=2.26u as=0.2425p ps=1.97u w=0.5u l=0.28u
X38 a_1845_466# a_378_271# w_n310_281# w_n310_281# pfet_03v3 ad=0.42p pd=1.84u as=0.65p ps=3.3u w=1u l=0.28u
X39 a_8361_407# a_7410_63# w_n310_281# w_n310_281# pfet_03v3 ad=1.3p pd=5.3u as=0.725p ps=2.725u w=2u l=0.28u
X40 w_n310_281# m2_1295_79# a_10906_466# w_n310_281# pfet_03v3 ad=0.735p pd=2.47u as=0.42p ps=1.84u w=1u l=0.28u
X41 a_7083_63# m2_6151_79# via_dev$5$1$1_9/VSUBS via_dev$5$1$1_9/VSUBS nfet_03v3 ad=0.2625p pd=2.05u as=0.265p ps=2.06u w=0.5u l=0.28u
X42 a_510_63# a_378_271# w_n310_281# w_n310_281# pfet_03v3 ad=0.65p pd=3.3u as=0.56p ps=3.12u w=1u l=0.28u
X43 a_10363_63# m2_9431_79# w_n310_281# w_n310_281# pfet_03v3 ad=0.715p pd=3.43u as=0.53p ps=3.06u w=1u l=0.28u
X44 a_510_63# a_378_271# via_dev$5$1$1_9/VSUBS via_dev$5$1$1_9/VSUBS nfet_03v3 ad=0.315p pd=2.26u as=0.28p ps=2.12u w=0.5u l=0.28u
X45 a_1262_n37# a_160_63# m2_1295_79# via_dev$5$1$1_9/VSUBS nfet_03v3 ad=0.3625p pd=1.725u as=0.3375p ps=1.675u w=1u l=0.28u
X46 a_1845_n37# a_378_271# via_dev$5$1$1_9/VSUBS via_dev$5$1$1_9/VSUBS nfet_03v3 ad=0.42p pd=1.84u as=0.63p ps=3.26u w=1u l=0.28u
X47 m2_6151_79# m2_5700_324# a_6721_407# w_n310_281# pfet_03v3 ad=0.725p pd=2.725u as=1.09p ps=5.09u w=2u l=0.28u
X48 a_6721_407# a_5768_63# w_n310_281# w_n310_281# pfet_03v3 ad=1.3p pd=5.3u as=0.725p ps=2.725u w=2u l=0.28u
X49 a_10363_63# m2_9431_79# via_dev$5$1$1_9/VSUBS via_dev$5$1$1_9/VSUBS nfet_03v3 ad=0.3575p pd=2.43u as=0.265p ps=2.06u w=0.5u l=0.28u
X50 a_10906_466# m2_1295_79# a_10906_n37# via_dev$5$1$1_9/VSUBS nfet_03v3 ad=0.65p pd=3.3u as=0.42p ps=1.84u w=1u l=0.28u
X51 a_8723_63# m2_7791_79# w_n310_281# w_n310_281# pfet_03v3 ad=0.545p pd=3.09u as=0.53p ps=3.06u w=1u l=0.28u
X52 a_11480_63# a_10906_466# w_n310_281# w_n310_281# pfet_03v3 ad=0.65p pd=3.3u as=0.735p ps=2.47u w=1u l=0.28u
X53 a_12559_3# a_11922_3# via_dev$5$1$1_9/VSUBS via_dev$5$1$1_9/VSUBS nfet_03v3 ad=0.315p pd=2.26u as=0.325p ps=2.3u w=0.5u l=0.28u
X54 a_7083_63# m2_6151_79# w_n310_281# w_n310_281# pfet_03v3 ad=0.545p pd=3.09u as=0.53p ps=3.06u w=1u l=0.28u
X55 a_7768_n37# m2_5700_324# via_dev$5$1$1_9/VSUBS via_dev$5$1$1_9/VSUBS nfet_03v3 ad=0.3625p pd=1.725u as=0.54p ps=3.08u w=1u l=0.28u
X56 a_160_63# m2_24_342# w_n310_281# w_n310_281# pfet_03v3 ad=0.63p pd=3.26u as=0.65p ps=3.3u w=1u l=0.28u
X57 m2_1295_79# a_160_63# a_705_407# w_n310_281# pfet_03v3 ad=0.725p pd=2.725u as=0.675p ps=2.675u w=2u l=0.28u
X58 a_5042_n37# a_3940_63# a_5042_407# via_dev$5$1$1_9/VSUBS nfet_03v3 ad=0.3625p pd=1.725u as=0.3375p ps=1.675u w=1u l=0.28u
X59 m2_1295_79# m2_24_342# a_870_n37# via_dev$5$1$1_9/VSUBS nfet_03v3 ad=0.3375p pd=1.675u as=0.3625p ps=1.725u w=1u l=0.28u
X60 a_11922_3# a_2419_63# a_11922_391# w_n310_281# pfet_03v3 ad=1.3p pd=5.3u as=0.725p ps=2.725u w=2u l=0.28u
X61 a_9800_n37# a_7083_63# m2_9431_79# via_dev$5$1$1_9/VSUBS nfet_03v3 ad=0.3625p pd=1.725u as=0.3375p ps=1.675u w=1u l=0.28u
X62 m2_7791_79# m2_5700_324# a_8361_407# w_n310_281# pfet_03v3 ad=0.725p pd=2.725u as=1.09p ps=5.09u w=2u l=0.28u
X63 a_5042_407# a_3940_63# a_5243_407# w_n310_281# pfet_03v3 ad=0.725p pd=2.725u as=0.675p ps=2.675u w=2u l=0.28u
X64 a_3940_63# m2_1295_79# via_dev$5$1$1_9/VSUBS via_dev$5$1$1_9/VSUBS nfet_03v3 ad=0.315p pd=2.26u as=0.325p ps=2.3u w=0.5u l=0.28u
X65 a_8160_n37# a_3498_3# m2_7791_79# via_dev$5$1$1_9/VSUBS nfet_03v3 ad=0.3625p pd=1.725u as=0.3375p ps=1.675u w=1u l=0.28u
X66 a_705_407# m2_24_342# w_n310_281# w_n310_281# pfet_03v3 ad=0.675p pd=2.675u as=0.725p ps=2.725u w=2u l=0.28u
X67 a_5042_407# m2_1295_79# a_4650_n37# via_dev$5$1$1_9/VSUBS nfet_03v3 ad=0.3375p pd=1.675u as=0.3625p ps=1.725u w=1u l=0.28u
X68 a_6520_n37# a_5042_407# m2_6151_79# via_dev$5$1$1_9/VSUBS nfet_03v3 ad=0.3625p pd=1.725u as=0.3375p ps=1.675u w=1u l=0.28u
X69 w_n310_281# a_7083_63# a_9609_407# w_n310_281# pfet_03v3 ad=0.725p pd=2.725u as=0.675p ps=2.675u w=2u l=0.28u
X70 a_2419_63# a_1845_466# w_n310_281# w_n310_281# pfet_03v3 ad=0.65p pd=3.3u as=0.735p ps=2.47u w=1u l=0.28u
X71 m2_9431_79# a_8723_63# a_9408_n37# via_dev$5$1$1_9/VSUBS nfet_03v3 ad=0.3375p pd=1.675u as=0.3625p ps=1.725u w=1u l=0.28u
X72 w_n310_281# a_3498_3# a_8361_407# w_n310_281# pfet_03v3 ad=0.725p pd=2.725u as=0.675p ps=2.675u w=2u l=0.28u
X73 a_2861_391# m2_1295_79# w_n310_281# w_n310_281# pfet_03v3 ad=0.725p pd=2.725u as=1.3p ps=5.3u w=2u l=0.28u
X74 a_4290_63# a_4158_271# w_n310_281# w_n310_281# pfet_03v3 ad=0.65p pd=3.3u as=0.56p ps=3.12u w=1u l=0.28u
X75 a_5243_407# m2_1295_79# w_n310_281# w_n310_281# pfet_03v3 ad=0.675p pd=2.675u as=0.725p ps=2.725u w=2u l=0.28u
X76 w_n310_281# a_5042_407# a_6721_407# w_n310_281# pfet_03v3 ad=0.725p pd=2.725u as=0.675p ps=2.675u w=2u l=0.28u
X77 a_3498_3# a_2861_3# via_dev$5$1$1_9/VSUBS via_dev$5$1$1_9/VSUBS nfet_03v3 ad=0.315p pd=2.26u as=0.325p ps=2.3u w=0.5u l=0.28u
X78 a_9609_407# a_8723_63# m2_9431_79# w_n310_281# pfet_03v3 ad=0.675p pd=2.675u as=0.725p ps=2.725u w=2u l=0.28u
X79 via_dev$5$1$1_9/VSUBS a_4290_63# a_5042_n37# via_dev$5$1$1_9/VSUBS nfet_03v3 ad=0.65p pd=3.3u as=0.3625p ps=1.725u w=1u l=0.28u
X80 m2_6151_79# a_2419_63# a_6128_n37# via_dev$5$1$1_9/VSUBS nfet_03v3 ad=0.3375p pd=1.675u as=0.3625p ps=1.725u w=1u l=0.28u
X81 w_n310_281# m2_24_342# a_1845_466# w_n310_281# pfet_03v3 ad=0.735p pd=2.47u as=0.42p ps=1.84u w=1u l=0.28u
X82 a_870_n37# a_378_271# via_dev$5$1$1_9/VSUBS via_dev$5$1$1_9/VSUBS nfet_03v3 ad=0.3625p pd=1.725u as=0.54p ps=3.08u w=1u l=0.28u
X83 a_12559_3# a_11922_3# w_n310_281# w_n310_281# pfet_03v3 ad=0.65p pd=3.3u as=0.675p ps=3.35u w=1u l=0.28u
C0 w_n310_281# a_12559_3# 0.08598f
C1 m2_1295_79# a_5768_63# 0.00766f
C2 m2_1295_79# a_1845_n37# 0.00942f
C3 a_9050_63# m2_7791_79# 0.00127f
C4 a_2861_391# m2_1295_79# 0.00841f
C5 a_7410_63# a_7083_63# 0.07718f
C6 a_378_271# m2_24_342# 0.56715f
C7 a_4158_271# a_11480_63# 0.00295f
C8 a_10363_63# a_8723_63# 0
C9 w_n310_281# a_705_407# 0.79414f
C10 m2_1295_79# a_510_63# 0.39896f
C11 a_4290_63# a_5768_63# 0.01093f
C12 m2_6151_79# a_7083_63# 0.08089f
C13 w_n310_281# a_10906_n37# 0
C14 m2_9431_79# a_9609_407# 0.49779f
C15 a_2419_63# m2_9431_79# 0.00832f
C16 m2_1295_79# a_5243_407# 0.10989f
C17 m2_9431_79# a_3498_3# 0
C18 a_9408_n37# m2_7791_79# 0
C19 a_7083_63# a_8160_n37# 0.00507f
C20 a_8723_63# a_8361_407# 0.01268f
C21 w_n310_281# a_8919_370# 0.50001f
C22 a_12559_3# a_11922_3# 0.0899f
C23 m2_5700_324# a_8723_63# 0
C24 a_10363_63# a_9609_407# 0.01306f
C25 a_2419_63# a_10363_63# 0.00126f
C26 a_4290_63# a_5243_407# 0.14023f
C27 a_8723_63# m2_7791_79# 0.08396f
C28 a_870_n37# a_1845_466# 0
C29 a_5042_407# a_5768_63# 0.22596f
C30 a_9800_n37# a_7083_63# 0.00527f
C31 a_7083_63# m2_9431_79# 0.19293f
C32 a_4158_271# a_3940_63# 0.16366f
C33 a_2419_63# a_2861_3# 0.21478f
C34 a_2861_3# a_3498_3# 0.09846f
C35 w_n310_281# a_10906_466# 0.44509f
C36 w_n310_281# m2_1295_79# 2.35219f
C37 a_9609_407# a_8361_407# 0.00466f
C38 a_2419_63# a_8361_407# 0
C39 a_8361_407# a_3498_3# 0.12093f
C40 a_10363_63# a_7083_63# 0.00582f
C41 a_2419_63# m2_5700_324# 0.074f
C42 m2_1295_79# a_6721_407# 0.00452f
C43 m2_5700_324# a_3498_3# 0.55174f
C44 m2_7791_79# a_9609_407# 0
C45 a_2419_63# m2_7791_79# 0.00843f
C46 a_6520_n37# m2_6151_79# 0.00766f
C47 a_5042_407# a_5243_407# 0.29512f
C48 m2_7791_79# a_3498_3# 0.0296f
C49 a_1845_466# a_3940_63# 0
C50 w_n310_281# a_4290_63# 0.2819f
C51 a_6128_n37# m2_6151_79# 0.01733f
C52 a_4290_63# a_4650_n37# 0.01502f
C53 a_7083_63# a_8361_407# 0.01453f
C54 m2_5700_324# a_7083_63# 0.12051f
C55 a_160_63# m2_24_342# 0.42316f
C56 a_7083_63# m2_7791_79# 0.14708f
C57 a_11922_3# a_10906_466# 0
C58 m2_1295_79# a_11922_3# 0
C59 a_12559_3# a_10906_466# 0
C60 w_n310_281# a_5042_407# 0.29911f
C61 a_4650_n37# a_5042_407# 0.00712f
C62 w_n310_281# a_9050_63# 0.28931f
C63 a_11480_63# m2_9431_79# 0
C64 a_5042_407# a_6721_407# 0.03265f
C65 a_5042_n37# a_5243_407# 0
C66 m2_1295_79# a_705_407# 0.30816f
C67 a_2419_63# a_5768_63# 0.07749f
C68 a_5768_63# a_3498_3# 0
C69 a_10906_n37# a_10906_466# 0.01333f
C70 a_2419_63# a_2861_391# 0.0163f
C71 a_2861_391# a_3498_3# 0.00454f
C72 a_1262_n37# a_510_63# 0.00898f
C73 a_10363_63# a_11480_63# 0
C74 a_510_63# m2_24_342# 0.13025f
C75 a_8919_370# m2_1295_79# 0.01372f
C76 a_2419_63# a_5243_407# 0
C77 a_5243_407# a_3498_3# 0.16427f
C78 a_7083_63# a_5768_63# 0.01494f
C79 w_n310_281# a_8723_63# 0.33581f
C80 a_7410_63# a_4158_271# 0
C81 m2_1295_79# a_10906_466# 0.0692f
C82 m2_6151_79# a_4158_271# 0.04334f
C83 w_n310_281# m2_24_342# 0.66878f
C84 a_2419_63# a_11922_391# 0.00754f
C85 w_n310_281# a_9609_407# 0.7653f
C86 w_n310_281# a_2419_63# 0.75141f
C87 a_4290_63# m2_1295_79# 0.13519f
C88 w_n310_281# a_3498_3# 1.03377f
C89 a_2419_63# a_6721_407# 0.01825f
C90 a_6721_407# a_3498_3# 0
C91 a_2861_3# a_3940_63# 0
C92 a_8919_370# a_9050_63# 0.10006f
C93 a_6520_n37# a_5768_63# 0.01329f
C94 a_9800_n37# a_4158_271# 0.00497f
C95 a_4158_271# m2_9431_79# 0.05572f
C96 m2_5700_324# a_3940_63# 0.00132f
C97 a_870_n37# a_160_63# 0.00441f
C98 w_n310_281# a_7083_63# 0.31663f
C99 a_378_271# a_1845_466# 0.01278f
C100 m2_1295_79# a_5042_407# 0.03487f
C101 a_6128_n37# a_5768_63# 0.00935f
C102 a_7083_63# a_6721_407# 0.01268f
C103 a_10363_63# a_4158_271# 0.02222f
C104 a_2419_63# a_11922_3# 0.16984f
C105 a_9050_63# m2_1295_79# 0.00716f
C106 a_2419_63# a_12559_3# 0
C107 a_4290_63# a_5042_407# 0.38112f
C108 a_1262_n37# a_705_407# 0
C109 a_7410_63# m2_6151_79# 0
C110 a_8919_370# a_8723_63# 0.12581f
C111 a_705_407# m2_24_342# 0.10607f
C112 a_2419_63# a_705_407# 0
C113 a_870_n37# a_510_63# 0.01502f
C114 m2_5700_324# a_4158_271# 0.00861f
C115 a_7410_63# a_8160_n37# 0.01329f
C116 a_4158_271# m2_7791_79# 0
C117 a_7768_n37# a_7083_63# 0.0028f
C118 a_3940_63# a_5768_63# 0
C119 a_2861_3# a_1845_466# 0
C120 m2_1295_79# a_8723_63# 0.00803f
C121 a_8919_370# a_9609_407# 0.02942f
C122 a_8919_370# a_2419_63# 0.01445f
C123 a_7410_63# m2_9431_79# 0.00105f
C124 a_11922_391# a_11480_63# 0.00152f
C125 w_n310_281# a_11480_63# 0.37298f
C126 a_4290_63# a_5042_n37# 0.00898f
C127 a_5243_407# a_3940_63# 0.06737f
C128 a_1262_n37# m2_1295_79# 0.01607f
C129 a_6128_n37# a_6721_407# 0
C130 m2_1295_79# m2_24_342# 0.04399f
C131 a_10906_466# a_9609_407# 0
C132 m2_1295_79# a_9609_407# 0.0093f
C133 a_2419_63# a_10906_466# 0.00833f
C134 a_8160_n37# m2_9431_79# 0
C135 a_2419_63# m2_1295_79# 0.32461f
C136 a_8919_370# a_7083_63# 0.01057f
C137 m2_1295_79# a_3498_3# 0.3391f
C138 a_1845_466# a_160_63# 0
C139 a_4158_271# a_5768_63# 0.00573f
C140 a_9050_63# a_9408_n37# 0.00935f
C141 a_2419_63# a_4290_63# 0.00652f
C142 a_7410_63# a_8361_407# 0.1423f
C143 a_5042_407# a_5042_n37# 0.01726f
C144 a_9800_n37# m2_9431_79# 0.0074f
C145 a_4290_63# a_3498_3# 0.00876f
C146 m2_5700_324# a_7410_63# 0.14432f
C147 a_7410_63# m2_7791_79# 0.36168f
C148 a_11922_3# a_11480_63# 0.04054f
C149 a_7083_63# a_10906_466# 0
C150 m2_1295_79# a_7083_63# 0.01071f
C151 a_9050_63# a_8723_63# 0.53121f
C152 w_n310_281# a_3940_63# 0.30087f
C153 m2_5700_324# m2_6151_79# 0.14941f
C154 a_1845_n37# a_1845_466# 0.01333f
C155 a_5243_407# a_4158_271# 0.02964f
C156 a_4650_n37# a_3940_63# 0.00441f
C157 m2_6151_79# m2_7791_79# 0.00114f
C158 a_10363_63# m2_9431_79# 0.07766f
C159 a_2419_63# a_5042_407# 0.08051f
C160 a_8160_n37# m2_7791_79# 0.01048f
C161 a_510_63# a_1845_466# 0.01433f
C162 a_5042_407# a_3498_3# 0.02015f
C163 a_9050_63# a_9609_407# 0.1261f
C164 a_2419_63# a_9050_63# 0.00801f
C165 m2_9431_79# a_8361_407# 0
C166 m2_9431_79# m2_7791_79# 0.01571f
C167 w_n310_281# a_4158_271# 0.66883f
C168 a_5042_407# a_7083_63# 0.02611f
C169 a_9408_n37# a_9609_407# 0
C170 a_4650_n37# a_4158_271# 0.00383f
C171 a_378_271# a_160_63# 0.09182f
C172 a_9050_63# a_7083_63# 0.21474f
C173 m2_6151_79# a_5768_63# 0.35511f
C174 m2_1295_79# a_11480_63# 0.00126f
C175 a_11480_63# a_10906_466# 0.1131f
C176 a_8723_63# a_9609_407# 0.0593f
C177 w_n310_281# a_1845_466# 0.44517f
C178 a_2419_63# a_8723_63# 0.00661f
C179 a_8723_63# a_3498_3# 0.00575f
C180 m2_5700_324# a_8361_407# 0.05956f
C181 a_870_n37# m2_1295_79# 0.00639f
C182 a_9408_n37# a_7083_63# 0.00336f
C183 m2_7791_79# a_8361_407# 0.49779f
C184 a_4158_271# a_11922_3# 0.0013f
C185 m2_5700_324# m2_7791_79# 0.05245f
C186 a_2419_63# m2_24_342# 0.00234f
C187 a_378_271# a_510_63# 0.14298f
C188 a_7083_63# a_8723_63# 0.15796f
C189 a_2419_63# a_9609_407# 0
C190 m2_24_342# a_3498_3# 0
C191 a_2419_63# a_3498_3# 0.01177f
C192 a_6520_n37# a_5042_407# 0.00483f
C193 m2_1295_79# a_3940_63# 0.46061f
C194 a_4158_271# a_10906_n37# 0.00824f
C195 w_n310_281# a_7410_63# 0.31086f
C196 a_6128_n37# a_5042_407# 0.00376f
C197 a_7083_63# a_9609_407# 0.0285f
C198 a_2419_63# a_7083_63# 0.01345f
C199 w_n310_281# m2_6151_79# 0.44301f
C200 a_7083_63# a_3498_3# 0.01356f
C201 a_4290_63# a_3940_63# 0.28903f
C202 a_1845_466# a_705_407# 0.0126f
C203 a_8919_370# a_4158_271# 0.001f
C204 m2_6151_79# a_6721_407# 0.4935f
C205 a_2861_391# a_2861_3# 0.01616f
C206 m2_5700_324# a_5768_63# 0.16447f
C207 w_n310_281# a_378_271# 0.6337f
C208 a_5768_63# m2_7791_79# 0
C209 a_4158_271# a_10906_466# 0.03873f
C210 a_2861_3# a_5243_407# 0
C211 m2_1295_79# a_4158_271# 0.16058f
C212 w_n310_281# m2_9431_79# 0.46254f
C213 a_5042_407# a_3940_63# 0.0941f
C214 a_7410_63# a_7768_n37# 0.00935f
C215 m2_5700_324# a_5243_407# 0.01927f
C216 a_4290_63# a_4158_271# 0.11363f
C217 w_n310_281# a_10363_63# 0.15741f
C218 m2_1295_79# a_1845_466# 0.09644f
C219 a_510_63# a_160_63# 0.28903f
C220 a_11480_63# a_9609_407# 0
C221 a_2419_63# a_11480_63# 0.0769f
C222 w_n310_281# a_2861_3# 0.4655f
C223 w_n310_281# a_8361_407# 0.75753f
C224 a_8919_370# a_7410_63# 0
C225 w_n310_281# m2_5700_324# 1.65678f
C226 a_378_271# a_705_407# 0.02817f
C227 a_5042_407# a_4158_271# 0.63867f
C228 a_7768_n37# m2_9431_79# 0
C229 a_6520_n37# a_7083_63# 0.00272f
C230 w_n310_281# m2_7791_79# 0.45139f
C231 m2_5700_324# a_6721_407# 0.50857f
C232 a_9050_63# a_4158_271# 0.00717f
C233 a_510_63# a_1845_n37# 0.0011f
C234 a_5243_407# a_5768_63# 0.00722f
C235 a_7410_63# m2_1295_79# 0.07614f
C236 w_n310_281# a_160_63# 0.30515f
C237 m2_1295_79# m2_6151_79# 0.00667f
C238 a_2419_63# a_3940_63# 0.00879f
C239 a_3940_63# a_3498_3# 0.04602f
C240 a_8919_370# m2_9431_79# 0.03216f
C241 a_10363_63# a_10906_n37# 0
C242 a_7768_n37# a_8361_407# 0
C243 a_378_271# m2_1295_79# 0.02669f
C244 a_4290_63# m2_6151_79# 0
C245 a_5042_n37# a_4158_271# 0
C246 a_7768_n37# m2_7791_79# 0.01733f
C247 a_4158_271# a_8723_63# 0
C248 a_2861_3# a_705_407# 0
C249 a_8919_370# a_10363_63# 0
C250 w_n310_281# a_5768_63# 0.31314f
C251 w_n310_281# a_1845_n37# 0
C252 w_n310_281# a_2861_391# 0.03535f
C253 a_10906_466# m2_9431_79# 0.00167f
C254 m2_1295_79# m2_9431_79# 0.0078f
C255 a_6721_407# a_5768_63# 0.14017f
C256 a_7410_63# a_5042_407# 0
C257 w_n310_281# a_510_63# 0.28255f
C258 a_4158_271# a_9609_407# 0
C259 a_2419_63# a_4158_271# 0.14782f
C260 a_8919_370# a_8361_407# 0
C261 a_5042_407# m2_6151_79# 0.20459f
C262 w_n310_281# a_5243_407# 0.78984f
C263 a_10363_63# m2_1295_79# 0.00179f
C264 a_10363_63# a_10906_466# 0.02047f
C265 a_4158_271# a_3498_3# 0.00829f
C266 a_8919_370# m2_5700_324# 0
C267 a_8919_370# m2_7791_79# 0.02774f
C268 a_160_63# a_705_407# 0.06737f
C269 a_1262_n37# a_1845_466# 0
C270 a_1845_466# m2_24_342# 0.06999f
C271 a_2861_3# m2_1295_79# 0.15381f
C272 a_2419_63# a_1845_466# 0.10509f
C273 a_1845_466# a_3498_3# 0.00105f
C274 m2_1295_79# a_8361_407# 0.02509f
C275 a_4158_271# a_7083_63# 1.09133f
C276 m2_5700_324# m2_1295_79# 0.07849f
C277 m2_1295_79# m2_7791_79# 0.05731f
C278 a_7410_63# a_8723_63# 0.01398f
C279 w_n310_281# a_11922_391# 0.03535f
C280 a_4290_63# a_2861_3# 0
C281 a_9050_63# a_9800_n37# 0.01329f
C282 a_9050_63# m2_9431_79# 0.328f
C283 a_2861_391# a_705_407# 0
C284 a_4290_63# m2_5700_324# 0.01531f
C285 w_n310_281# a_6721_407# 0.72579f
C286 a_5042_n37# m2_6151_79# 0
C287 a_510_63# a_705_407# 0.13828f
C288 a_10363_63# a_9050_63# 0.01385f
C289 m2_1295_79# a_160_63# 0.09339f
C290 a_9408_n37# m2_9431_79# 0.01733f
C291 a_2419_63# a_7410_63# 0.00801f
C292 a_7410_63# a_3498_3# 0.11774f
C293 a_2861_3# a_5042_407# 0
C294 a_11922_391# a_11922_3# 0.01891f
C295 m2_5700_324# a_5042_407# 0.06917f
C296 a_2419_63# m2_6151_79# 0.05852f
C297 w_n310_281# a_11922_3# 0.46598f
C298 a_6520_n37# a_4158_271# 0.00406f
C299 m2_6151_79# a_3498_3# 0
C300 a_5042_407# m2_7791_79# 0.00555f
C301 a_9050_63# a_8361_407# 0
C302 m2_9431_79# a_8723_63# 0.13485f
C303 a_4158_271# via_dev$5$1$1_9/VSUBS 2.63898f
C304 a_7083_63# via_dev$5$1$1_9/VSUBS 0.86585f
C305 a_8723_63# via_dev$5$1$1_9/VSUBS 0.41121f
C306 m2_9431_79# via_dev$5$1$1_9/VSUBS 0.75255f
C307 m2_7791_79# via_dev$5$1$1_9/VSUBS 0.74612f
C308 a_9609_407# via_dev$5$1$1_9/VSUBS 0.11967f
C309 a_8361_407# via_dev$5$1$1_9/VSUBS 0.05216f
C310 m2_6151_79# via_dev$5$1$1_9/VSUBS 0.72815f
C311 a_6721_407# via_dev$5$1$1_9/VSUBS 0.01698f
C312 a_5042_407# via_dev$5$1$1_9/VSUBS 0.88916f
C313 a_3940_63# via_dev$5$1$1_9/VSUBS 0.46864f
C314 m2_1295_79# via_dev$5$1$1_9/VSUBS 3.37184f
C315 a_160_63# via_dev$5$1$1_9/VSUBS 0.5921f
C316 a_5243_407# via_dev$5$1$1_9/VSUBS 0.01661f
C317 a_705_407# via_dev$5$1$1_9/VSUBS 0.13677f
C318 a_3498_3# via_dev$5$1$1_9/VSUBS 1.27724f
C319 a_10906_n37# via_dev$5$1$1_9/VSUBS 0.02232f
C320 a_9800_n37# via_dev$5$1$1_9/VSUBS 0.01742f
C321 a_9408_n37# via_dev$5$1$1_9/VSUBS 0.007f
C322 a_8160_n37# via_dev$5$1$1_9/VSUBS 0.01743f
C323 a_7768_n37# via_dev$5$1$1_9/VSUBS 0.007f
C324 a_6520_n37# via_dev$5$1$1_9/VSUBS 0.01743f
C325 a_6128_n37# via_dev$5$1$1_9/VSUBS 0.007f
C326 a_5042_n37# via_dev$5$1$1_9/VSUBS 0.00833f
C327 a_4650_n37# via_dev$5$1$1_9/VSUBS 0.01565f
C328 a_12559_3# via_dev$5$1$1_9/VSUBS 0.19481f
C329 a_11922_3# via_dev$5$1$1_9/VSUBS 0.64569f
C330 a_11922_391# via_dev$5$1$1_9/VSUBS 0.00119f
C331 a_10906_466# via_dev$5$1$1_9/VSUBS 0.59796f
C332 a_11480_63# via_dev$5$1$1_9/VSUBS 0.42359f
C333 a_10363_63# via_dev$5$1$1_9/VSUBS 0.13924f
C334 a_9050_63# via_dev$5$1$1_9/VSUBS 0.53264f
C335 a_8919_370# via_dev$5$1$1_9/VSUBS 0.51824f
C336 a_7410_63# via_dev$5$1$1_9/VSUBS 0.53731f
C337 a_5768_63# via_dev$5$1$1_9/VSUBS 0.54f
C338 a_1845_n37# via_dev$5$1$1_9/VSUBS 0.01974f
C339 a_1262_n37# via_dev$5$1$1_9/VSUBS 0.0069f
C340 a_870_n37# via_dev$5$1$1_9/VSUBS 0.01517f
C341 a_4290_63# via_dev$5$1$1_9/VSUBS 0.57048f
C342 a_2861_3# via_dev$5$1$1_9/VSUBS 0.62907f
C343 a_1845_466# via_dev$5$1$1_9/VSUBS 0.59853f
C344 a_2419_63# via_dev$5$1$1_9/VSUBS 6.64124f
C345 a_510_63# via_dev$5$1$1_9/VSUBS 0.55998f
C346 a_378_271# via_dev$5$1$1_9/VSUBS 1.37769f
C347 w_n310_281# via_dev$5$1$1_9/VSUBS 27.06296f
C348 m2_24_342# via_dev$5$1$1_9/VSUBS 1.98211f
C349 m2_5700_324# via_dev$5$1$1_9/VSUBS 1.14834f
.ends

.subckt x1bitblock$3$1 a_2861_3# a_8361_407# a_6520_n37# a_1262_n37# a_2861_391# a_1845_466#
+ a_10906_n37# a_510_63# a_870_n37# a_6721_407# a_9800_n37# a_11480_63# a_6128_n37#
+ a_5768_63# m2_6151_79# a_11922_391# a_5042_n37# a_9408_n37# a_9609_407# a_5042_407#
+ a_8160_n37# a_4158_271# a_11922_3# a_8918_358# a_2419_63# m2_9431_79# a_10906_466#
+ a_4650_n37# a_9050_63# a_5243_407# a_7768_n37# a_3940_63# a_3498_3# m2_7791_79#
+ a_10363_63# a_160_63# a_4290_63# a_7083_63# a_705_407# a_12559_3# a_7410_63# a_1845_n37#
+ m2_5700_324# via_dev$5$3$1_9/VSUBS m2_1295_79# a_8723_63# a_378_271# w_n310_281#
+ m2_24_342#
X0 a_2419_63# a_1845_466# via_dev$5$3$1_9/VSUBS via_dev$5$3$1_9/VSUBS nfet_03v3 ad=0.315p pd=2.26u as=0.2425p ps=1.97u w=0.5u l=0.28u
X1 a_1845_466# m2_24_342# a_1845_n37# via_dev$5$3$1_9/VSUBS nfet_03v3 ad=0.65p pd=3.3u as=0.42p ps=1.84u w=1u l=0.28u
X2 a_3940_63# m2_1295_79# w_n310_281# w_n310_281# pfet_03v3 ad=0.63p pd=3.26u as=0.65p ps=3.3u w=1u l=0.28u
X3 via_dev$5$3$1_9/VSUBS a_510_63# a_1262_n37# via_dev$5$3$1_9/VSUBS nfet_03v3 ad=0.65p pd=3.3u as=0.3625p ps=1.725u w=1u l=0.28u
X4 a_5243_407# a_4290_63# a_5042_407# w_n310_281# pfet_03v3 ad=1.3p pd=5.3u as=0.725p ps=2.725u w=2u l=0.28u
X5 a_6721_407# a_2419_63# m2_6151_79# w_n310_281# pfet_03v3 ad=0.675p pd=2.675u as=0.725p ps=2.725u w=2u l=0.28u
X6 a_10906_466# a_4158_271# w_n310_281# w_n310_281# pfet_03v3 ad=0.42p pd=1.84u as=0.65p ps=3.3u w=1u l=0.28u
X7 a_4290_63# a_4158_271# via_dev$5$3$1_9/VSUBS via_dev$5$3$1_9/VSUBS nfet_03v3 ad=0.315p pd=2.26u as=0.28p ps=2.12u w=0.5u l=0.28u
X8 w_n310_281# a_378_271# a_705_407# w_n310_281# pfet_03v3 ad=0.725p pd=2.725u as=1.09p ps=5.09u w=2u l=0.28u
X9 a_2861_3# m2_1295_79# via_dev$5$3$1_9/VSUBS via_dev$5$3$1_9/VSUBS nfet_03v3 ad=0.18125p pd=1.225u as=0.325p ps=2.3u w=0.5u l=0.28u
X10 via_dev$5$3$1_9/VSUBS a_2419_63# a_2861_3# via_dev$5$3$1_9/VSUBS nfet_03v3 ad=0.315p pd=2.26u as=0.18125p ps=1.225u w=0.5u l=0.28u
X11 m2_7791_79# m2_1295_79# a_7768_n37# via_dev$5$3$1_9/VSUBS nfet_03v3 ad=0.3375p pd=1.675u as=0.3625p ps=1.725u w=1u l=0.28u
X12 a_10906_n37# a_4158_271# via_dev$5$3$1_9/VSUBS via_dev$5$3$1_9/VSUBS nfet_03v3 ad=0.42p pd=1.84u as=0.63p ps=3.26u w=1u l=0.28u
X13 a_9050_63# a_8918_358# via_dev$5$3$1_9/VSUBS via_dev$5$3$1_9/VSUBS nfet_03v3 ad=0.31p pd=2.24u as=0.24p ps=1.96u w=0.5u l=0.28u
X14 a_11922_3# a_11480_63# via_dev$5$3$1_9/VSUBS via_dev$5$3$1_9/VSUBS nfet_03v3 ad=0.18125p pd=1.225u as=0.325p ps=2.3u w=0.5u l=0.28u
X15 via_dev$5$3$1_9/VSUBS a_2419_63# a_11922_3# via_dev$5$3$1_9/VSUBS nfet_03v3 ad=0.315p pd=2.26u as=0.18125p ps=1.225u w=0.5u l=0.28u
X16 a_705_407# a_510_63# m2_1295_79# w_n310_281# pfet_03v3 ad=1.3p pd=5.3u as=0.725p ps=2.725u w=2u l=0.28u
X17 a_4650_n37# a_4158_271# via_dev$5$3$1_9/VSUBS via_dev$5$3$1_9/VSUBS nfet_03v3 ad=0.3625p pd=1.725u as=0.54p ps=3.08u w=1u l=0.28u
X18 a_2861_3# a_2419_63# a_2861_391# w_n310_281# pfet_03v3 ad=1.3p pd=5.3u as=0.725p ps=2.725u w=2u l=0.28u
X19 a_5768_63# m2_5700_324# via_dev$5$3$1_9/VSUBS via_dev$5$3$1_9/VSUBS nfet_03v3 ad=0.315p pd=2.26u as=0.3175p ps=2.27u w=0.5u l=0.28u
X20 via_dev$5$3$1_9/VSUBS a_9050_63# a_9800_n37# via_dev$5$3$1_9/VSUBS nfet_03v3 ad=0.65p pd=3.3u as=0.3625p ps=1.725u w=1u l=0.28u
X21 a_8361_407# m2_1295_79# m2_7791_79# w_n310_281# pfet_03v3 ad=0.675p pd=2.675u as=0.725p ps=2.725u w=2u l=0.28u
X22 a_9408_n37# a_8918_358# via_dev$5$3$1_9/VSUBS via_dev$5$3$1_9/VSUBS nfet_03v3 ad=0.3625p pd=1.725u as=0.54p ps=3.08u w=1u l=0.28u
X23 a_3498_3# a_2861_3# w_n310_281# w_n310_281# pfet_03v3 ad=0.65p pd=3.3u as=0.675p ps=3.35u w=1u l=0.28u
X24 a_7410_63# m2_5700_324# via_dev$5$3$1_9/VSUBS via_dev$5$3$1_9/VSUBS nfet_03v3 ad=0.31p pd=2.24u as=0.24p ps=1.96u w=0.5u l=0.28u
X25 via_dev$5$3$1_9/VSUBS a_7410_63# a_8160_n37# via_dev$5$3$1_9/VSUBS nfet_03v3 ad=0.65p pd=3.3u as=0.3625p ps=1.725u w=1u l=0.28u
X26 a_8723_63# m2_7791_79# via_dev$5$3$1_9/VSUBS via_dev$5$3$1_9/VSUBS nfet_03v3 ad=0.2625p pd=2.05u as=0.265p ps=2.06u w=0.5u l=0.28u
X27 w_n310_281# a_4158_271# a_5243_407# w_n310_281# pfet_03v3 ad=0.725p pd=2.725u as=1.09p ps=5.09u w=2u l=0.28u
X28 a_5768_63# m2_5700_324# w_n310_281# w_n310_281# pfet_03v3 ad=0.65p pd=3.3u as=0.635p ps=3.27u w=1u l=0.28u
X29 a_9050_63# a_8918_358# w_n310_281# w_n310_281# pfet_03v3 ad=0.64p pd=3.28u as=0.48p ps=2.96u w=1u l=0.28u
X30 a_11922_391# a_11480_63# w_n310_281# w_n310_281# pfet_03v3 ad=0.725p pd=2.725u as=1.3p ps=5.3u w=2u l=0.28u
X31 a_160_63# m2_24_342# via_dev$5$3$1_9/VSUBS via_dev$5$3$1_9/VSUBS nfet_03v3 ad=0.315p pd=2.26u as=0.325p ps=2.3u w=0.5u l=0.28u
X32 a_9609_407# a_9050_63# w_n310_281# w_n310_281# pfet_03v3 ad=1.3p pd=5.3u as=0.725p ps=2.725u w=2u l=0.28u
X33 a_6128_n37# m2_5700_324# via_dev$5$3$1_9/VSUBS via_dev$5$3$1_9/VSUBS nfet_03v3 ad=0.3625p pd=1.725u as=0.54p ps=3.08u w=1u l=0.28u
X34 via_dev$5$3$1_9/VSUBS a_5768_63# a_6520_n37# via_dev$5$3$1_9/VSUBS nfet_03v3 ad=0.65p pd=3.3u as=0.3625p ps=1.725u w=1u l=0.28u
X35 a_7410_63# m2_5700_324# w_n310_281# w_n310_281# pfet_03v3 ad=0.64p pd=3.28u as=0.48p ps=2.96u w=1u l=0.28u
X36 m2_9431_79# a_8918_358# a_9609_407# w_n310_281# pfet_03v3 ad=0.725p pd=2.725u as=1.09p ps=5.09u w=2u l=0.28u
X37 a_11480_63# a_10906_466# via_dev$5$3$1_9/VSUBS via_dev$5$3$1_9/VSUBS nfet_03v3 ad=0.315p pd=2.26u as=0.2425p ps=1.97u w=0.5u l=0.28u
X38 a_1845_466# a_378_271# w_n310_281# w_n310_281# pfet_03v3 ad=0.42p pd=1.84u as=0.65p ps=3.3u w=1u l=0.28u
X39 a_8361_407# a_7410_63# w_n310_281# w_n310_281# pfet_03v3 ad=1.3p pd=5.3u as=0.725p ps=2.725u w=2u l=0.28u
X40 w_n310_281# m2_1295_79# a_10906_466# w_n310_281# pfet_03v3 ad=0.735p pd=2.47u as=0.42p ps=1.84u w=1u l=0.28u
X41 a_7083_63# m2_6151_79# via_dev$5$3$1_9/VSUBS via_dev$5$3$1_9/VSUBS nfet_03v3 ad=0.2625p pd=2.05u as=0.265p ps=2.06u w=0.5u l=0.28u
X42 a_510_63# a_378_271# w_n310_281# w_n310_281# pfet_03v3 ad=0.65p pd=3.3u as=0.56p ps=3.12u w=1u l=0.28u
X43 a_10363_63# m2_9431_79# w_n310_281# w_n310_281# pfet_03v3 ad=0.715p pd=3.43u as=0.53p ps=3.06u w=1u l=0.28u
X44 a_510_63# a_378_271# via_dev$5$3$1_9/VSUBS via_dev$5$3$1_9/VSUBS nfet_03v3 ad=0.315p pd=2.26u as=0.28p ps=2.12u w=0.5u l=0.28u
X45 a_1262_n37# a_160_63# m2_1295_79# via_dev$5$3$1_9/VSUBS nfet_03v3 ad=0.3625p pd=1.725u as=0.3375p ps=1.675u w=1u l=0.28u
X46 a_1845_n37# a_378_271# via_dev$5$3$1_9/VSUBS via_dev$5$3$1_9/VSUBS nfet_03v3 ad=0.42p pd=1.84u as=0.63p ps=3.26u w=1u l=0.28u
X47 m2_6151_79# m2_5700_324# a_6721_407# w_n310_281# pfet_03v3 ad=0.725p pd=2.725u as=1.09p ps=5.09u w=2u l=0.28u
X48 a_6721_407# a_5768_63# w_n310_281# w_n310_281# pfet_03v3 ad=1.3p pd=5.3u as=0.725p ps=2.725u w=2u l=0.28u
X49 a_10363_63# m2_9431_79# via_dev$5$3$1_9/VSUBS via_dev$5$3$1_9/VSUBS nfet_03v3 ad=0.3575p pd=2.43u as=0.265p ps=2.06u w=0.5u l=0.28u
X50 a_10906_466# m2_1295_79# a_10906_n37# via_dev$5$3$1_9/VSUBS nfet_03v3 ad=0.65p pd=3.3u as=0.42p ps=1.84u w=1u l=0.28u
X51 a_8723_63# m2_7791_79# w_n310_281# w_n310_281# pfet_03v3 ad=0.545p pd=3.09u as=0.53p ps=3.06u w=1u l=0.28u
X52 a_11480_63# a_10906_466# w_n310_281# w_n310_281# pfet_03v3 ad=0.65p pd=3.3u as=0.735p ps=2.47u w=1u l=0.28u
X53 a_12559_3# a_11922_3# via_dev$5$3$1_9/VSUBS via_dev$5$3$1_9/VSUBS nfet_03v3 ad=0.315p pd=2.26u as=0.325p ps=2.3u w=0.5u l=0.28u
X54 a_7083_63# m2_6151_79# w_n310_281# w_n310_281# pfet_03v3 ad=0.545p pd=3.09u as=0.53p ps=3.06u w=1u l=0.28u
X55 a_7768_n37# m2_5700_324# via_dev$5$3$1_9/VSUBS via_dev$5$3$1_9/VSUBS nfet_03v3 ad=0.3625p pd=1.725u as=0.54p ps=3.08u w=1u l=0.28u
X56 a_160_63# m2_24_342# w_n310_281# w_n310_281# pfet_03v3 ad=0.63p pd=3.26u as=0.65p ps=3.3u w=1u l=0.28u
X57 m2_1295_79# a_160_63# a_705_407# w_n310_281# pfet_03v3 ad=0.725p pd=2.725u as=0.675p ps=2.675u w=2u l=0.28u
X58 a_5042_n37# a_3940_63# a_5042_407# via_dev$5$3$1_9/VSUBS nfet_03v3 ad=0.3625p pd=1.725u as=0.3375p ps=1.675u w=1u l=0.28u
X59 m2_1295_79# m2_24_342# a_870_n37# via_dev$5$3$1_9/VSUBS nfet_03v3 ad=0.3375p pd=1.675u as=0.3625p ps=1.725u w=1u l=0.28u
X60 a_11922_3# a_2419_63# a_11922_391# w_n310_281# pfet_03v3 ad=1.3p pd=5.3u as=0.725p ps=2.725u w=2u l=0.28u
X61 a_9800_n37# a_7083_63# m2_9431_79# via_dev$5$3$1_9/VSUBS nfet_03v3 ad=0.3625p pd=1.725u as=0.3375p ps=1.675u w=1u l=0.28u
X62 m2_7791_79# m2_5700_324# a_8361_407# w_n310_281# pfet_03v3 ad=0.725p pd=2.725u as=1.09p ps=5.09u w=2u l=0.28u
X63 a_5042_407# a_3940_63# a_5243_407# w_n310_281# pfet_03v3 ad=0.725p pd=2.725u as=0.675p ps=2.675u w=2u l=0.28u
X64 a_3940_63# m2_1295_79# via_dev$5$3$1_9/VSUBS via_dev$5$3$1_9/VSUBS nfet_03v3 ad=0.315p pd=2.26u as=0.325p ps=2.3u w=0.5u l=0.28u
X65 a_8160_n37# a_3498_3# m2_7791_79# via_dev$5$3$1_9/VSUBS nfet_03v3 ad=0.3625p pd=1.725u as=0.3375p ps=1.675u w=1u l=0.28u
X66 a_705_407# m2_24_342# w_n310_281# w_n310_281# pfet_03v3 ad=0.675p pd=2.675u as=0.725p ps=2.725u w=2u l=0.28u
X67 a_5042_407# m2_1295_79# a_4650_n37# via_dev$5$3$1_9/VSUBS nfet_03v3 ad=0.3375p pd=1.675u as=0.3625p ps=1.725u w=1u l=0.28u
X68 a_6520_n37# a_5042_407# m2_6151_79# via_dev$5$3$1_9/VSUBS nfet_03v3 ad=0.3625p pd=1.725u as=0.3375p ps=1.675u w=1u l=0.28u
X69 w_n310_281# a_7083_63# a_9609_407# w_n310_281# pfet_03v3 ad=0.725p pd=2.725u as=0.675p ps=2.675u w=2u l=0.28u
X70 a_2419_63# a_1845_466# w_n310_281# w_n310_281# pfet_03v3 ad=0.65p pd=3.3u as=0.735p ps=2.47u w=1u l=0.28u
X71 m2_9431_79# a_8723_63# a_9408_n37# via_dev$5$3$1_9/VSUBS nfet_03v3 ad=0.3375p pd=1.675u as=0.3625p ps=1.725u w=1u l=0.28u
X72 w_n310_281# a_3498_3# a_8361_407# w_n310_281# pfet_03v3 ad=0.725p pd=2.725u as=0.675p ps=2.675u w=2u l=0.28u
X73 a_2861_391# m2_1295_79# w_n310_281# w_n310_281# pfet_03v3 ad=0.725p pd=2.725u as=1.3p ps=5.3u w=2u l=0.28u
X74 a_4290_63# a_4158_271# w_n310_281# w_n310_281# pfet_03v3 ad=0.65p pd=3.3u as=0.56p ps=3.12u w=1u l=0.28u
X75 a_5243_407# m2_1295_79# w_n310_281# w_n310_281# pfet_03v3 ad=0.675p pd=2.675u as=0.725p ps=2.725u w=2u l=0.28u
X76 w_n310_281# a_5042_407# a_6721_407# w_n310_281# pfet_03v3 ad=0.725p pd=2.725u as=0.675p ps=2.675u w=2u l=0.28u
X77 a_3498_3# a_2861_3# via_dev$5$3$1_9/VSUBS via_dev$5$3$1_9/VSUBS nfet_03v3 ad=0.315p pd=2.26u as=0.325p ps=2.3u w=0.5u l=0.28u
X78 a_9609_407# a_8723_63# m2_9431_79# w_n310_281# pfet_03v3 ad=0.675p pd=2.675u as=0.725p ps=2.725u w=2u l=0.28u
X79 via_dev$5$3$1_9/VSUBS a_4290_63# a_5042_n37# via_dev$5$3$1_9/VSUBS nfet_03v3 ad=0.65p pd=3.3u as=0.3625p ps=1.725u w=1u l=0.28u
X80 m2_6151_79# a_2419_63# a_6128_n37# via_dev$5$3$1_9/VSUBS nfet_03v3 ad=0.3375p pd=1.675u as=0.3625p ps=1.725u w=1u l=0.28u
X81 w_n310_281# m2_24_342# a_1845_466# w_n310_281# pfet_03v3 ad=0.735p pd=2.47u as=0.42p ps=1.84u w=1u l=0.28u
X82 a_870_n37# a_378_271# via_dev$5$3$1_9/VSUBS via_dev$5$3$1_9/VSUBS nfet_03v3 ad=0.3625p pd=1.725u as=0.54p ps=3.08u w=1u l=0.28u
X83 a_12559_3# a_11922_3# w_n310_281# w_n310_281# pfet_03v3 ad=0.65p pd=3.3u as=0.675p ps=3.35u w=1u l=0.28u
C0 a_10906_466# m2_9431_79# 0.00167f
C1 m2_24_342# a_160_63# 0.42316f
C2 a_10906_466# a_10363_63# 0.02047f
C3 m2_24_342# m2_1295_79# 0.04399f
C4 a_3940_63# m2_5700_324# 0.00132f
C5 m2_5700_324# a_5042_407# 0.06917f
C6 a_8918_358# a_7083_63# 0.01057f
C7 a_4158_271# a_9609_407# 0
C8 m2_5700_324# a_5243_407# 0.01927f
C9 m2_7791_79# a_9609_407# 0
C10 w_n310_281# a_9050_63# 0.28931f
C11 a_8361_407# m2_1295_79# 0.02509f
C12 a_8160_n37# a_7083_63# 0.00507f
C13 a_4290_63# m2_6151_79# 0
C14 a_6721_407# a_5042_407# 0.03265f
C15 a_11480_63# a_9609_407# 0
C16 a_7083_63# a_5768_63# 0.01494f
C17 a_9408_n37# a_9609_407# 0
C18 a_12559_3# a_11922_3# 0.0899f
C19 m2_6151_79# a_5768_63# 0.35511f
C20 a_1845_466# a_2861_3# 0
C21 m2_1295_79# a_9609_407# 0.0093f
C22 a_2419_63# a_4158_271# 0.14782f
C23 a_2419_63# m2_7791_79# 0.00843f
C24 a_7083_63# a_5042_407# 0.02611f
C25 a_705_407# a_2419_63# 0
C26 a_2419_63# a_11480_63# 0.0769f
C27 m2_6151_79# a_5042_407# 0.20459f
C28 a_1845_466# a_3498_3# 0.00105f
C29 a_5042_n37# m2_6151_79# 0
C30 a_8918_358# a_4158_271# 0.00101f
C31 a_8918_358# m2_7791_79# 0.02764f
C32 a_1845_n37# a_510_63# 0.0011f
C33 a_4158_271# a_4290_63# 0.11363f
C34 a_6128_n37# a_6721_407# 0
C35 a_2419_63# m2_1295_79# 0.3246f
C36 a_7083_63# a_9050_63# 0.21474f
C37 w_n310_281# a_11922_391# 0.03535f
C38 a_8160_n37# m2_7791_79# 0.01048f
C39 a_4158_271# a_5768_63# 0.00573f
C40 a_10906_466# a_12559_3# 0
C41 m2_7791_79# a_5768_63# 0
C42 a_8918_358# m2_1295_79# 0.01371f
C43 w_n310_281# a_11922_3# 0.46598f
C44 a_870_n37# a_160_63# 0.00441f
C45 w_n310_281# a_2861_3# 0.4655f
C46 m2_1295_79# a_870_n37# 0.00639f
C47 m2_1295_79# a_4290_63# 0.13519f
C48 w_n310_281# a_8723_63# 0.33519f
C49 a_6128_n37# m2_6151_79# 0.01733f
C50 a_3940_63# a_4158_271# 0.16366f
C51 a_4158_271# a_5042_407# 0.63867f
C52 a_2861_391# a_2419_63# 0.0163f
C53 a_7410_63# a_8723_63# 0.01398f
C54 m2_1295_79# a_5768_63# 0.00766f
C55 m2_7791_79# a_5042_407# 0.00555f
C56 a_4158_271# a_5042_n37# 0
C57 a_4158_271# a_5243_407# 0.02964f
C58 a_510_63# a_705_407# 0.13828f
C59 a_8723_63# m2_5700_324# 0
C60 a_705_407# a_1262_n37# 0
C61 w_n310_281# m2_9431_79# 0.46253f
C62 w_n310_281# a_3498_3# 1.03377f
C63 w_n310_281# a_10363_63# 0.15741f
C64 a_7410_63# m2_9431_79# 0.00105f
C65 a_7410_63# a_3498_3# 0.11774f
C66 a_8361_407# a_9609_407# 0.00466f
C67 a_510_63# a_160_63# 0.28903f
C68 a_4158_271# a_9050_63# 0.00717f
C69 a_510_63# m2_1295_79# 0.39896f
C70 m2_7791_79# a_9050_63# 0.00127f
C71 m2_5700_324# a_3498_3# 0.55174f
C72 m2_1295_79# a_1262_n37# 0.01607f
C73 m2_1295_79# a_3940_63# 0.46061f
C74 m2_1295_79# a_5042_407# 0.03487f
C75 m2_1295_79# a_5243_407# 0.10989f
C76 a_10906_466# w_n310_281# 0.44509f
C77 a_2419_63# m2_24_342# 0.00234f
C78 a_9800_n37# a_9050_63# 0.01329f
C79 a_3498_3# a_6721_407# 0
C80 a_9408_n37# a_9050_63# 0.00935f
C81 m2_1295_79# a_9050_63# 0.00716f
C82 a_4650_n37# a_4290_63# 0.01502f
C83 a_8361_407# a_2419_63# 0
C84 a_8723_63# a_7083_63# 0.15796f
C85 a_7083_63# m2_9431_79# 0.19293f
C86 a_2419_63# a_9609_407# 0
C87 a_3498_3# a_7083_63# 0.01356f
C88 a_10363_63# a_7083_63# 0.00582f
C89 a_8918_358# a_8361_407# 0
C90 m2_9431_79# a_7768_n37# 0
C91 a_3498_3# m2_6151_79# 0
C92 a_378_271# a_1845_466# 0.01278f
C93 a_3940_63# a_4650_n37# 0.00441f
C94 a_4650_n37# a_5042_407# 0.00712f
C95 a_8918_358# a_9609_407# 0.02942f
C96 a_12559_3# w_n310_281# 0.08598f
C97 a_10906_466# a_7083_63# 0
C98 a_1845_466# w_n310_281# 0.44517f
C99 a_11480_63# a_11922_391# 0.00152f
C100 a_510_63# m2_24_342# 0.13025f
C101 a_4158_271# a_11922_3# 0.0013f
C102 a_8723_63# a_4158_271# 0
C103 a_705_407# a_2861_3# 0
C104 a_8723_63# m2_7791_79# 0.08381f
C105 a_11480_63# a_11922_3# 0.04054f
C106 a_8918_358# a_2419_63# 0.01449f
C107 a_4158_271# a_3498_3# 0.00829f
C108 a_4158_271# m2_9431_79# 0.05572f
C109 a_10363_63# a_4158_271# 0.02222f
C110 m2_1295_79# a_11922_3# 0
C111 m2_7791_79# m2_9431_79# 0.01571f
C112 a_3498_3# m2_7791_79# 0.0296f
C113 m2_1295_79# a_2861_3# 0.15381f
C114 a_2419_63# a_4290_63# 0.00652f
C115 a_8361_407# a_9050_63# 0
C116 m2_1295_79# a_8723_63# 0.00796f
C117 a_378_271# w_n310_281# 0.63374f
C118 a_11480_63# m2_9431_79# 0
C119 a_2419_63# a_5768_63# 0.07749f
C120 a_11480_63# a_10363_63# 0
C121 a_9800_n37# m2_9431_79# 0.0074f
C122 a_9408_n37# m2_9431_79# 0.01733f
C123 a_10906_466# a_4158_271# 0.03873f
C124 m2_1295_79# a_3498_3# 0.3391f
C125 m2_1295_79# m2_9431_79# 0.0078f
C126 a_9609_407# a_9050_63# 0.1261f
C127 m2_1295_79# a_10363_63# 0.00179f
C128 a_7410_63# w_n310_281# 0.31086f
C129 a_10906_466# a_11480_63# 0.1131f
C130 a_6520_n37# a_7083_63# 0.00272f
C131 w_n310_281# m2_5700_324# 1.65678f
C132 a_2419_63# a_3940_63# 0.00879f
C133 a_2419_63# a_5042_407# 0.08051f
C134 a_2861_391# a_2861_3# 0.01616f
C135 a_10906_n37# a_10363_63# 0
C136 a_4290_63# a_5768_63# 0.01093f
C137 a_2419_63# a_5243_407# 0
C138 a_7410_63# m2_5700_324# 0.14432f
C139 a_6520_n37# m2_6151_79# 0.00766f
C140 a_1845_n37# a_1845_466# 0.01333f
C141 a_10906_466# m2_1295_79# 0.0692f
C142 w_n310_281# a_6721_407# 0.72579f
C143 a_510_63# a_870_n37# 0.01502f
C144 a_2419_63# a_9050_63# 0.00801f
C145 a_10906_466# a_10906_n37# 0.01333f
C146 a_2861_391# a_3498_3# 0.00454f
C147 a_3940_63# a_4290_63# 0.28903f
C148 a_4290_63# a_5042_407# 0.38112f
C149 m2_5700_324# a_6721_407# 0.50857f
C150 a_5042_n37# a_4290_63# 0.00898f
C151 a_4290_63# a_5243_407# 0.14023f
C152 a_3940_63# a_5768_63# 0
C153 a_5768_63# a_5042_407# 0.22596f
C154 a_5768_63# a_5243_407# 0.00722f
C155 w_n310_281# a_7083_63# 0.31663f
C156 a_8918_358# a_9050_63# 0.09973f
C157 a_7410_63# a_7083_63# 0.07718f
C158 w_n310_281# m2_6151_79# 0.44301f
C159 a_1845_466# a_705_407# 0.0126f
C160 a_6520_n37# a_4158_271# 0.00406f
C161 a_7410_63# a_7768_n37# 0.00935f
C162 m2_5700_324# a_7083_63# 0.12051f
C163 a_7410_63# m2_6151_79# 0
C164 a_510_63# a_1262_n37# 0.00898f
C165 a_8361_407# a_8723_63# 0.01268f
C166 m2_24_342# a_3498_3# 0
C167 a_3940_63# a_5042_407# 0.0941f
C168 m2_5700_324# m2_6151_79# 0.14941f
C169 a_1845_n37# w_n310_281# 0
C170 a_1845_466# a_160_63# 0
C171 a_5042_n37# a_5042_407# 0.01726f
C172 a_3940_63# a_5243_407# 0.06737f
C173 a_5042_407# a_5243_407# 0.29512f
C174 a_1845_466# m2_1295_79# 0.09644f
C175 a_5042_n37# a_5243_407# 0
C176 a_7083_63# a_6721_407# 0.01268f
C177 a_8361_407# m2_9431_79# 0
C178 a_8361_407# a_3498_3# 0.12093f
C179 a_8723_63# a_9609_407# 0.0593f
C180 a_2419_63# a_11922_391# 0.00754f
C181 m2_6151_79# a_6721_407# 0.4935f
C182 a_6128_n37# a_5768_63# 0.00935f
C183 a_9609_407# m2_9431_79# 0.49779f
C184 a_10363_63# a_9609_407# 0.01306f
C185 a_378_271# a_705_407# 0.02817f
C186 w_n310_281# a_4158_271# 0.66883f
C187 a_2419_63# a_11922_3# 0.16984f
C188 a_2419_63# a_2861_3# 0.21478f
C189 w_n310_281# m2_7791_79# 0.45142f
C190 a_7410_63# a_4158_271# 0
C191 a_7083_63# a_7768_n37# 0.0028f
C192 a_7410_63# m2_7791_79# 0.36168f
C193 m2_6151_79# a_7083_63# 0.08089f
C194 a_6128_n37# a_5042_407# 0.00376f
C195 a_2419_63# a_8723_63# 0.00649f
C196 a_705_407# w_n310_281# 0.79414f
C197 a_378_271# a_160_63# 0.09182f
C198 m2_5700_324# a_4158_271# 0.00861f
C199 a_378_271# m2_1295_79# 0.02669f
C200 w_n310_281# a_11480_63# 0.37298f
C201 m2_5700_324# m2_7791_79# 0.05245f
C202 a_10906_466# a_9609_407# 0
C203 a_2419_63# m2_9431_79# 0.00832f
C204 w_n310_281# a_160_63# 0.30515f
C205 a_2419_63# a_3498_3# 0.01177f
C206 a_2419_63# a_10363_63# 0.00126f
C207 w_n310_281# m2_1295_79# 2.35222f
C208 a_2861_3# a_4290_63# 0
C209 a_8918_358# a_8723_63# 0.12497f
C210 a_7410_63# m2_1295_79# 0.07614f
C211 m2_1295_79# m2_5700_324# 0.07849f
C212 w_n310_281# a_10906_n37# 0
C213 a_1845_466# m2_24_342# 0.06999f
C214 a_8918_358# m2_9431_79# 0.03217f
C215 a_8918_358# a_10363_63# 0
C216 a_10906_466# a_2419_63# 0.00833f
C217 a_3498_3# a_4290_63# 0.00876f
C218 a_4158_271# a_7083_63# 1.09133f
C219 m2_1295_79# a_6721_407# 0.00452f
C220 m2_7791_79# a_7083_63# 0.14708f
C221 a_8160_n37# m2_9431_79# 0
C222 a_3498_3# a_5768_63# 0
C223 a_2861_391# w_n310_281# 0.03535f
C224 a_2861_3# a_3940_63# 0
C225 a_2861_3# a_5042_407# 0
C226 a_4158_271# m2_6151_79# 0.04334f
C227 m2_7791_79# a_7768_n37# 0.01733f
C228 m2_7791_79# m2_6151_79# 0.00114f
C229 a_2861_3# a_5243_407# 0
C230 a_9800_n37# a_7083_63# 0.00527f
C231 a_9408_n37# a_7083_63# 0.00336f
C232 m2_1295_79# a_7083_63# 0.01071f
C233 a_378_271# m2_24_342# 0.56715f
C234 a_3940_63# a_3498_3# 0.04602f
C235 a_3498_3# a_5042_407# 0.02015f
C236 a_3498_3# a_5243_407# 0.16427f
C237 m2_1295_79# m2_6151_79# 0.00667f
C238 a_8723_63# a_9050_63# 0.52788f
C239 m2_24_342# w_n310_281# 0.66878f
C240 a_12559_3# a_2419_63# 0
C241 a_1845_466# a_2419_63# 0.10509f
C242 a_1845_n37# m2_1295_79# 0.00942f
C243 m2_9431_79# a_9050_63# 0.328f
C244 a_10363_63# a_9050_63# 0.01385f
C245 a_8361_407# w_n310_281# 0.75753f
C246 a_4158_271# m2_7791_79# 0
C247 a_7410_63# a_8361_407# 0.1423f
C248 a_11480_63# a_4158_271# 0.00295f
C249 a_8361_407# m2_5700_324# 0.05956f
C250 a_1845_466# a_870_n37# 0
C251 a_9800_n37# a_4158_271# 0.00497f
C252 w_n310_281# a_9609_407# 0.7653f
C253 m2_7791_79# a_9408_n37# 0
C254 m2_1295_79# a_4158_271# 0.16058f
C255 m2_1295_79# m2_7791_79# 0.05731f
C256 a_11922_391# a_11922_3# 0.01891f
C257 a_705_407# a_160_63# 0.06737f
C258 a_705_407# m2_1295_79# 0.30816f
C259 a_10906_n37# a_4158_271# 0.00824f
C260 m2_1295_79# a_11480_63# 0.00126f
C261 a_6520_n37# a_5768_63# 0.01329f
C262 a_2419_63# w_n310_281# 0.75125f
C263 a_510_63# a_1845_466# 0.01433f
C264 m2_1295_79# a_160_63# 0.09339f
C265 a_7410_63# a_2419_63# 0.00801f
C266 a_1845_466# a_1262_n37# 0
C267 a_1845_466# a_3940_63# 0
C268 a_8361_407# a_7083_63# 0.01453f
C269 a_2419_63# m2_5700_324# 0.074f
C270 a_8361_407# a_7768_n37# 0
C271 a_6520_n37# a_5042_407# 0.00483f
C272 a_8918_358# w_n310_281# 0.49498f
C273 a_9609_407# a_7083_63# 0.0285f
C274 a_705_407# a_2861_391# 0
C275 a_2861_3# a_3498_3# 0.09846f
C276 w_n310_281# a_4290_63# 0.2819f
C277 a_7410_63# a_8918_358# 0
C278 a_2419_63# a_6721_407# 0.01825f
C279 a_8723_63# a_3498_3# 0.00575f
C280 a_8723_63# m2_9431_79# 0.13485f
C281 a_8918_358# m2_5700_324# 0
C282 a_4158_271# a_4650_n37# 0.00383f
C283 a_8723_63# a_10363_63# 0
C284 w_n310_281# a_5768_63# 0.31314f
C285 a_8160_n37# a_7410_63# 0.01329f
C286 m2_5700_324# a_4290_63# 0.01531f
C287 a_2861_391# m2_1295_79# 0.00841f
C288 a_378_271# a_510_63# 0.14298f
C289 a_10906_466# a_11922_3# 0
C290 a_3498_3# m2_9431_79# 0
C291 a_10363_63# m2_9431_79# 0.07766f
C292 m2_5700_324# a_5768_63# 0.16447f
C293 a_2419_63# a_7083_63# 0.01345f
C294 a_510_63# w_n310_281# 0.28255f
C295 a_705_407# m2_24_342# 0.10607f
C296 w_n310_281# a_3940_63# 0.30087f
C297 w_n310_281# a_5042_407# 0.29911f
C298 a_2419_63# m2_6151_79# 0.05852f
C299 a_8361_407# m2_7791_79# 0.49779f
C300 w_n310_281# a_5243_407# 0.78984f
C301 a_7410_63# a_5042_407# 0
C302 a_5768_63# a_6721_407# 0.14017f
C303 a_4158_271# via_dev$5$3$1_9/VSUBS 2.63856f
C304 a_7083_63# via_dev$5$3$1_9/VSUBS 0.86585f
C305 a_8723_63# via_dev$5$3$1_9/VSUBS 0.40977f
C306 m2_9431_79# via_dev$5$3$1_9/VSUBS 0.75255f
C307 m2_7791_79# via_dev$5$3$1_9/VSUBS 0.74612f
C308 a_9609_407# via_dev$5$3$1_9/VSUBS 0.11967f
C309 a_8361_407# via_dev$5$3$1_9/VSUBS 0.05216f
C310 m2_6151_79# via_dev$5$3$1_9/VSUBS 0.72815f
C311 a_6721_407# via_dev$5$3$1_9/VSUBS 0.01698f
C312 a_5042_407# via_dev$5$3$1_9/VSUBS 0.88916f
C313 a_3940_63# via_dev$5$3$1_9/VSUBS 0.46864f
C314 m2_1295_79# via_dev$5$3$1_9/VSUBS 3.34703f
C315 a_160_63# via_dev$5$3$1_9/VSUBS 0.5921f
C316 a_5243_407# via_dev$5$3$1_9/VSUBS 0.01661f
C317 a_705_407# via_dev$5$3$1_9/VSUBS 0.13677f
C318 a_3498_3# via_dev$5$3$1_9/VSUBS 1.27724f
C319 a_10906_n37# via_dev$5$3$1_9/VSUBS 0.02232f
C320 a_9800_n37# via_dev$5$3$1_9/VSUBS 0.01742f
C321 a_9408_n37# via_dev$5$3$1_9/VSUBS 0.007f
C322 a_8160_n37# via_dev$5$3$1_9/VSUBS 0.01743f
C323 a_7768_n37# via_dev$5$3$1_9/VSUBS 0.007f
C324 a_6520_n37# via_dev$5$3$1_9/VSUBS 0.01743f
C325 a_6128_n37# via_dev$5$3$1_9/VSUBS 0.007f
C326 a_5042_n37# via_dev$5$3$1_9/VSUBS 0.00833f
C327 a_4650_n37# via_dev$5$3$1_9/VSUBS 0.01565f
C328 a_12559_3# via_dev$5$3$1_9/VSUBS 0.19481f
C329 a_11922_3# via_dev$5$3$1_9/VSUBS 0.64569f
C330 a_11922_391# via_dev$5$3$1_9/VSUBS 0.00119f
C331 a_10906_466# via_dev$5$3$1_9/VSUBS 0.59796f
C332 a_11480_63# via_dev$5$3$1_9/VSUBS 0.42359f
C333 a_10363_63# via_dev$5$3$1_9/VSUBS 0.13924f
C334 a_9050_63# via_dev$5$3$1_9/VSUBS 0.53264f
C335 a_8918_358# via_dev$5$3$1_9/VSUBS 0.5203f
C336 a_7410_63# via_dev$5$3$1_9/VSUBS 0.53731f
C337 a_5768_63# via_dev$5$3$1_9/VSUBS 0.54f
C338 a_1845_n37# via_dev$5$3$1_9/VSUBS 0.01974f
C339 a_1262_n37# via_dev$5$3$1_9/VSUBS 0.0069f
C340 a_870_n37# via_dev$5$3$1_9/VSUBS 0.01517f
C341 a_4290_63# via_dev$5$3$1_9/VSUBS 0.57048f
C342 a_2861_3# via_dev$5$3$1_9/VSUBS 0.62907f
C343 a_1845_466# via_dev$5$3$1_9/VSUBS 0.59853f
C344 a_2419_63# via_dev$5$3$1_9/VSUBS 6.64114f
C345 a_510_63# via_dev$5$3$1_9/VSUBS 0.55998f
C346 a_378_271# via_dev$5$3$1_9/VSUBS 1.37769f
C347 w_n310_281# via_dev$5$3$1_9/VSUBS 27.06676f
C348 m2_24_342# via_dev$5$3$1_9/VSUBS 1.98211f
C349 m2_5700_324# via_dev$5$3$1_9/VSUBS 1.14834f
.ends

.subckt x4bitblock$1 1bitblock$4_0/a_10363_63# 1bitblock$1$1_0/a_9609_407# 1bitblock$1$1_0/a_5042_407#
+ 1bitblock$1$1_0/a_8160_n37# 1bitblock$2$1_0/a_2419_63# 1bitblock$1$1_0/a_4290_63#
+ 1bitblock$2$1_0/m2_7791_79# 1bitblock$1$1_0/m2_9431_79# 1bitblock$2$1_0/a_10363_63#
+ 1bitblock$1$1_0/a_4650_n37# 1bitblock$3$1_0/a_5768_63# 1bitblock$1$1_0/a_7410_63#
+ 1bitblock$3$1_0/a_2861_3# 1bitblock$4_0/a_510_63# MUX21$1_0/a_1472_63# 1bitblock$1$1_0/a_5243_407#
+ 1bitblock$1$1_0/m2_24_342# 1bitblock$4_0/a_870_n37# 1bitblock$1$1_0/a_7768_n37#
+ 1bitblock$4_0/a_5768_63# 1bitblock$2$1_0/a_3940_63# 1bitblock$1$1_0/m2_7791_79#
+ 1bitblock$1$1_0/a_8723_63# 1bitblock$1$1_0/a_10363_63# 1bitblock$1$1_0/a_378_271#
+ 1bitblock$3$1_0/a_11922_3# 1bitblock$3$1_0/a_8361_407# 1bitblock$3$1_0/a_510_63#
+ 1bitblock$1$1_0/a_7083_63# 1bitblock$3$1_0/a_2419_63# 1bitblock$2$1_0/a_4290_63#
+ 1bitblock$3$1_0/a_10906_466# MUX21$1_0/a_909_n37# m2_14516_n651# 1bitblock$4_0/a_11922_3#
+ 1bitblock$2$1_0/a_7410_63# 1bitblock$3$1_0/a_9050_63# 1bitblock$3$1_0/a_1845_466#
+ 1bitblock$4_0/a_2419_63# 1bitblock$4_0/a_8361_407# m2_10721_n3315# 1bitblock$3$1_0/a_6721_407#
+ 1bitblock$3$1_0/a_11480_63# 1bitblock$3$1_0/a_3498_3# 1bitblock$3$1_0/a_3940_63#
+ 1bitblock$4_0/a_9050_63# 1bitblock$2$1_0/a_8361_407# MUX21$1_0/a_517_n37# 1bitblock$4_0/a_1845_466#
+ 1bitblock$2$1_0/m2_24_342# MUX21$1_0/a_718_407# 1bitblock$4_0/a_160_63# 1bitblock$3$1_0/m2_6151_79#
+ 1bitblock$2$1_0/a_8723_63# 1bitblock$2$1_0/a_378_271# MUX21$1_0/m2_540_79# 1bitblock$4_0/a_3940_63#
+ 1bitblock$4_0/a_6721_407# m1_15541_n412# 1bitblock$1$1_0/a_5768_63# 1bitblock$4_0/a_11480_63#
+ 1bitblock$3$1_0/a_7083_63# 1bitblock$3$1_0/a_4290_63# m1_n563_n5091# 1bitblock$4_0/m2_24_342#
+ MUX21$1_0/a_157_63# 1bitblock$3$1_0/a_705_407# 1bitblock$3$1_0/a_5042_n37# m1_12484_n953#
+ 1bitblock$3$1_0/a_7410_63# 1bitblock$3$1_0/a_9609_407# 1bitblock$4_0/m2_6151_79#
+ 1bitblock$1$1_0/a_8361_407# 1bitblock$3$1_0/a_8160_n37# 1bitblock$3$1_0/a_5042_407#
+ 1bitblock$4_0/a_4290_63# m1_8729_n3942# 1bitblock$3$1_0/m2_9431_79# 1bitblock$3$1_0/a_160_63#
+ 1bitblock$4_0/a_705_407# 1bitblock$3$1_0/a_4650_n37# m2_2396_n2595# 1bitblock$4_0/a_10906_466#
+ 1bitblock$2$1_0/m2_6151_79# 1bitblock$1$1_0/a_3498_3# m2_5443_n3913# 1bitblock$4_0/a_5042_n37#
+ 1bitblock$4_0/a_7410_63# 1bitblock$1$1_0/a_2419_63# 1bitblock$3$1_0/a_5243_407#
+ 1bitblock$4_0/a_9609_407# m1_12480_n3815# 1bitblock$4_0/a_8160_n37# 1bitblock$4_0/a_5042_407#
+ AND4$1_0/a_518_229# 1bitblock$3$1_0/a_7768_n37# 1bitblock$2$1_0/a_5042_n37# 1bitblock$3$1_0/a_8723_63#
+ 1bitblock$4_0/m2_9431_79# 1bitblock$3$1_0/a_378_271# 1bitblock$4_0/a_4650_n37# 1bitblock$2$1_0/a_9609_407#
+ 1bitblock$2$1_0/a_5768_63# 1bitblock$2$1_0/a_5042_407# 1bitblock$2$1_0/a_8160_n37#
+ 1bitblock$3$1_0/m2_24_342# 1bitblock$3$1_0/m2_7791_79# 1bitblock$2$1_0/a_3498_3#
+ 1bitblock$2$1_0/m2_9431_79# 1bitblock$4_0/a_8723_63# 1bitblock$4_0/a_7083_63# 1bitblock$2$1_0/a_7083_63#
+ 1bitblock$2$1_0/a_4650_n37# 1bitblock$4_0/a_5243_407# 1bitblock$3$1_0/a_10363_63#
+ m2_1701_n784# 1bitblock$4_0/a_378_271# 1bitblock$1$1_0/m2_6151_79# m1_13543_n1146#
+ 1bitblock$4_0/a_7768_n37# 1bitblock$1$1_0/a_3940_63# 1bitblock$4_0/a_2861_3# m1_12486_242#
+ 1bitblock$2$1_0/a_5243_407# 1bitblock$4_0/a_3498_3# 1bitblock$4_0/m2_7791_79# m1_14167_n1145#
+ 1bitblock$2$1_0/a_7768_n37# 1bitblock$1$1_0/a_5042_n37# VSUBS
X1bitblock$2$1_0 1bitblock$2$1_0/a_2861_3# 1bitblock$2$1_0/a_8361_407# 1bitblock$2$1_0/a_6520_n37#
+ 1bitblock$2$1_0/a_1262_n37# 1bitblock$2$1_0/a_2861_391# 1bitblock$2$1_0/a_1845_466#
+ 1bitblock$2$1_0/a_10906_n37# 1bitblock$2$1_0/a_510_63# 1bitblock$2$1_0/a_870_n37#
+ 1bitblock$2$1_0/a_6721_407# 1bitblock$2$1_0/a_9800_n37# 1bitblock$2$1_0/a_11480_63#
+ 1bitblock$2$1_0/a_6128_n37# 1bitblock$2$1_0/a_5768_63# m1_8729_n3942# 1bitblock$2$1_0/m2_6151_79#
+ 1bitblock$2$1_0/a_11922_391# 1bitblock$2$1_0/a_5042_n37# 1bitblock$2$1_0/a_9408_n37#
+ 1bitblock$2$1_0/a_9609_407# 1bitblock$2$1_0/a_5042_407# 1bitblock$2$1_0/a_8160_n37#
+ m1_12484_n953# 1bitblock$2$1_0/a_11922_3# 1bitblock$2$1_0/a_2419_63# 1bitblock$2$1_0/m2_9431_79#
+ 1bitblock$2$1_0/a_10906_466# 1bitblock$2$1_0/a_4650_n37# 1bitblock$2$1_0/a_9050_63#
+ 1bitblock$2$1_0/a_5243_407# 1bitblock$2$1_0/a_7768_n37# 1bitblock$2$1_0/a_3940_63#
+ 1bitblock$2$1_0/m2_7791_79# 1bitblock$2$1_0/a_10363_63# 1bitblock$2$1_0/a_160_63#
+ 1bitblock$2$1_0/a_4290_63# 1bitblock$2$1_0/a_7083_63# 1bitblock$2$1_0/a_705_407#
+ m2_10721_n3315# 1bitblock$2$1_0/a_7410_63# 1bitblock$2$1_0/a_1845_n37# VSUBS m2_2396_n2595#
+ 1bitblock$2$1_0/a_8723_63# 1bitblock$2$1_0/a_378_271# 1bitblock$2$1_0/a_3498_3#
+ m1_n563_n5091# m2_5443_n3913# 1bitblock$2$1_0/m2_24_342# x1bitblock$2$1
XAND4$1_0 m1_n563_n5091# m2_2396_n2595# VSUBS m1_13543_n1146# m2_14516_n651# m2_1701_n784#
+ AND4$1_0/a_704_n441# m1_14167_n1145# AND4$1_0/a_912_n441# AND4$1_0/a_518_229# AND4$1_0/a_1120_n441#
+ AND4$1
XMUX21$1_0 MUX21$1_0/a_1472_63# MUX21$1_0/a_157_63# m2_14516_n651# MUX21$1_0/a_909_n37#
+ m1_15541_n412# MUX21$1_0/a_517_n37# MUX21$1_0/a_718_407# MUX21$1_0/m2_540_79# VSUBS
+ m1_12480_n3815# m1_n563_n5091# MUX21$1
X1bitblock$4_0 1bitblock$4_0/a_2861_3# 1bitblock$4_0/a_8361_407# 1bitblock$4_0/a_6520_n37#
+ 1bitblock$4_0/a_1262_n37# 1bitblock$4_0/a_2861_391# 1bitblock$4_0/a_1845_466# 1bitblock$4_0/a_10906_n37#
+ 1bitblock$4_0/a_510_63# 1bitblock$4_0/a_870_n37# 1bitblock$4_0/a_6721_407# 1bitblock$4_0/a_9800_n37#
+ 1bitblock$4_0/a_11480_63# 1bitblock$4_0/a_6128_n37# 1bitblock$4_0/a_5768_63# 1bitblock$4_0/m2_6151_79#
+ 1bitblock$4_0/a_3498_3# 1bitblock$4_0/a_11922_391# 1bitblock$4_0/a_5042_n37# 1bitblock$4_0/a_9408_n37#
+ m1_8729_n3942# 1bitblock$4_0/a_9609_407# 1bitblock$4_0/a_5042_407# 1bitblock$4_0/a_8160_n37#
+ m1_15541_n412# 1bitblock$4_0/a_11922_3# 1bitblock$4_0/a_2419_63# 1bitblock$4_0/m2_9431_79#
+ 1bitblock$4_0/a_10906_466# 1bitblock$4_0/a_4650_n37# 1bitblock$4_0/a_9050_63# 1bitblock$4_0/a_5243_407#
+ 1bitblock$4_0/a_7768_n37# 1bitblock$4_0/a_3940_63# 1bitblock$4_0/m2_7791_79# 1bitblock$4_0/a_10363_63#
+ 1bitblock$4_0/a_160_63# 1bitblock$4_0/a_4290_63# 1bitblock$4_0/a_7083_63# 1bitblock$4_0/a_705_407#
+ m1_12486_242# 1bitblock$4_0/a_7410_63# m2_5443_n3913# 1bitblock$4_0/a_1845_n37#
+ VSUBS m1_14167_n1145# 1bitblock$4_0/a_8723_63# 1bitblock$4_0/a_378_271# m1_n563_n5091#
+ 1bitblock$4_0/m2_24_342# x1bitblock$4
X1bitblock$1$1_0 1bitblock$1$1_0/a_2861_3# 1bitblock$1$1_0/a_8361_407# 1bitblock$1$1_0/a_6520_n37#
+ 1bitblock$1$1_0/a_1262_n37# 1bitblock$1$1_0/a_2861_391# 1bitblock$1$1_0/a_1845_466#
+ 1bitblock$1$1_0/a_10906_n37# 1bitblock$1$1_0/a_510_63# 1bitblock$1$1_0/a_870_n37#
+ 1bitblock$1$1_0/a_6721_407# 1bitblock$1$1_0/a_9800_n37# 1bitblock$1$1_0/m2_24_342#
+ 1bitblock$1$1_0/a_11480_63# 1bitblock$1$1_0/a_6128_n37# 1bitblock$1$1_0/a_5768_63#
+ 1bitblock$1$1_0/m2_6151_79# 1bitblock$1$1_0/a_11922_391# 1bitblock$1$1_0/a_5042_n37#
+ 1bitblock$1$1_0/a_9408_n37# 1bitblock$1$1_0/a_9609_407# 1bitblock$1$1_0/a_5042_407#
+ 1bitblock$1$1_0/a_8160_n37# m1_12486_242# 1bitblock$1$1_0/a_3498_3# 1bitblock$1$1_0/a_11922_3#
+ 1bitblock$1$1_0/a_2419_63# 1bitblock$1$1_0/m2_9431_79# 1bitblock$1$1_0/a_10906_466#
+ 1bitblock$1$1_0/a_4650_n37# 1bitblock$1$1_0/a_9050_63# 1bitblock$1$1_0/a_5243_407#
+ 1bitblock$1$1_0/a_7768_n37# 1bitblock$1$1_0/a_160_63# 1bitblock$1$1_0/a_3940_63#
+ m1_8729_n3942# 1bitblock$1$1_0/m2_7791_79# 1bitblock$1$1_0/a_10363_63# 1bitblock$1$1_0/a_4290_63#
+ 1bitblock$1$1_0/a_7083_63# 1bitblock$1$1_0/a_705_407# m1_12484_n953# 1bitblock$1$1_0/a_7410_63#
+ 1bitblock$1$1_0/a_1845_n37# VSUBS m2_5443_n3913# m2_1701_n784# 1bitblock$1$1_0/a_8723_63#
+ 1bitblock$1$1_0/a_378_271# m1_n563_n5091# x1bitblock$1$1
X1bitblock$3$1_0 1bitblock$3$1_0/a_2861_3# 1bitblock$3$1_0/a_8361_407# 1bitblock$3$1_0/a_6520_n37#
+ 1bitblock$3$1_0/a_1262_n37# 1bitblock$3$1_0/a_2861_391# 1bitblock$3$1_0/a_1845_466#
+ 1bitblock$3$1_0/a_10906_n37# 1bitblock$3$1_0/a_510_63# 1bitblock$3$1_0/a_870_n37#
+ 1bitblock$3$1_0/a_6721_407# 1bitblock$3$1_0/a_9800_n37# 1bitblock$3$1_0/a_11480_63#
+ 1bitblock$3$1_0/a_6128_n37# 1bitblock$3$1_0/a_5768_63# 1bitblock$3$1_0/m2_6151_79#
+ 1bitblock$3$1_0/a_11922_391# 1bitblock$3$1_0/a_5042_n37# 1bitblock$3$1_0/a_9408_n37#
+ 1bitblock$3$1_0/a_9609_407# 1bitblock$3$1_0/a_5042_407# 1bitblock$3$1_0/a_8160_n37#
+ m2_10721_n3315# 1bitblock$3$1_0/a_11922_3# m1_8729_n3942# 1bitblock$3$1_0/a_2419_63#
+ 1bitblock$3$1_0/m2_9431_79# 1bitblock$3$1_0/a_10906_466# 1bitblock$3$1_0/a_4650_n37#
+ 1bitblock$3$1_0/a_9050_63# 1bitblock$3$1_0/a_5243_407# 1bitblock$3$1_0/a_7768_n37#
+ 1bitblock$3$1_0/a_3940_63# 1bitblock$3$1_0/a_3498_3# 1bitblock$3$1_0/m2_7791_79#
+ 1bitblock$3$1_0/a_10363_63# 1bitblock$3$1_0/a_160_63# 1bitblock$3$1_0/a_4290_63#
+ 1bitblock$3$1_0/a_7083_63# 1bitblock$3$1_0/a_705_407# m1_12480_n3815# 1bitblock$3$1_0/a_7410_63#
+ 1bitblock$3$1_0/a_1845_n37# m2_5443_n3913# VSUBS m1_13543_n1146# 1bitblock$3$1_0/a_8723_63#
+ 1bitblock$3$1_0/a_378_271# m1_n563_n5091# 1bitblock$3$1_0/m2_24_342# x1bitblock$3$1
C0 1bitblock$1$1_0/a_1262_n37# m2_1701_n784# 0
C1 1bitblock$1$1_0/m2_24_342# m1_n563_n5091# 0.03103f
C2 1bitblock$4_0/a_7410_63# 1bitblock$4_0/m2_9431_79# -0
C3 m2_2396_n2595# 1bitblock$1$1_0/a_2861_391# 0.00705f
C4 m2_5443_n3913# m1_12484_n953# 0.05387f
C5 1bitblock$4_0/a_510_63# 1bitblock$1$1_0/a_160_63# 0
C6 1bitblock$2$1_0/a_5042_407# m1_n563_n5091# 0
C7 1bitblock$2$1_0/a_378_271# m2_1701_n784# 0
C8 1bitblock$2$1_0/a_8361_407# m1_8729_n3942# 0.00891f
C9 1bitblock$2$1_0/a_2419_63# 1bitblock$2$1_0/a_3498_3# -0
C10 m1_12484_n953# m1_n563_n5091# 0.32612f
C11 1bitblock$3$1_0/a_378_271# m1_13543_n1146# 0.00199f
C12 1bitblock$1$1_0/m2_24_342# 1bitblock$4_0/a_705_407# 0
C13 1bitblock$3$1_0/a_9050_63# m1_13543_n1146# 0.00508f
C14 1bitblock$2$1_0/a_160_63# 1bitblock$3$1_0/a_870_n37# 0.00135f
C15 1bitblock$1$1_0/a_9408_n37# m1_8729_n3942# 0
C16 1bitblock$2$1_0/a_1845_466# 1bitblock$3$1_0/a_1845_466# 0.00184f
C17 m2_2396_n2595# m1_15541_n412# 0
C18 1bitblock$2$1_0/a_1845_466# m1_13543_n1146# 0.00178f
C19 AND4$1_0/a_518_229# m1_n563_n5091# 0.0239f
C20 m2_5443_n3913# 1bitblock$3$1_0/a_4290_63# 0.00473f
C21 m2_14516_n651# m1_n563_n5091# 0.16195f
C22 1bitblock$2$1_0/m2_7791_79# 1bitblock$2$1_0/m2_9431_79# -0.00474f
C23 m1_12484_n953# 1bitblock$1$1_0/a_2419_63# 0.00245f
C24 m1_12484_n953# m1_8729_n3942# 0.05077f
C25 1bitblock$2$1_0/a_9609_407# m1_8729_n3942# 0.01866f
C26 1bitblock$2$1_0/a_11922_3# m1_n563_n5091# 0.00103f
C27 1bitblock$4_0/a_8160_n37# m1_8729_n3942# 0.00164f
C28 1bitblock$4_0/a_9050_63# 1bitblock$4_0/m2_7791_79# -0
C29 1bitblock$4_0/a_378_271# m2_1701_n784# 0.00257f
C30 1bitblock$2$1_0/a_3498_3# m2_2396_n2595# 1.47227f
C31 AND4$1_0/a_518_229# 1bitblock$1$1_0/a_2419_63# 0.00114f
C32 1bitblock$2$1_0/a_705_407# m2_1701_n784# 0.00123f
C33 m2_5443_n3913# 1bitblock$1$1_0/a_5768_63# 0.01876f
C34 m2_14516_n651# 1bitblock$1$1_0/a_2419_63# 0.00162f
C35 1bitblock$2$1_0/a_705_407# 1bitblock$3$1_0/a_510_63# 0
C36 m2_2396_n2595# m1_14167_n1145# 0.00193f
C37 m2_5443_n3913# 1bitblock$3$1_0/a_5042_n37# 0
C38 1bitblock$4_0/m2_24_342# m1_14167_n1145# 0.0031f
C39 m2_5443_n3913# 1bitblock$1$1_0/a_5243_407# 0.01246f
C40 1bitblock$2$1_0/a_9050_63# 1bitblock$2$1_0/m2_7791_79# -0
C41 m1_12484_n953# 1bitblock$1$1_0/a_11480_63# 0.00279f
C42 m2_5443_n3913# 1bitblock$2$1_0/a_5042_n37# 0
C43 1bitblock$1$1_0/a_5768_63# m1_n563_n5091# 0
C44 1bitblock$1$1_0/m2_7791_79# m1_n563_n5091# -0
C45 1bitblock$2$1_0/a_510_63# m2_2396_n2595# 0.00105f
C46 m1_15541_n412# m1_13543_n1146# 0
C47 1bitblock$2$1_0/a_10906_466# 1bitblock$1$1_0/a_10906_466# 0.00145f
C48 1bitblock$2$1_0/a_11480_63# m2_2396_n2595# 0.00938f
C49 1bitblock$2$1_0/a_2861_3# 1bitblock$3$1_0/a_2419_63# 0
C50 1bitblock$3$1_0/a_7410_63# m1_8729_n3942# 0.00461f
C51 m2_5443_n3913# m1_12486_242# 0.0535f
C52 m2_14516_n651# 1bitblock$1$1_0/a_11480_63# 0
C53 1bitblock$2$1_0/a_7768_n37# m1_8729_n3942# 0
C54 1bitblock$2$1_0/m2_24_342# 1bitblock$1$1_0/a_378_271# 0
C55 1bitblock$1$1_0/m2_7791_79# m1_8729_n3942# 0.02398f
C56 1bitblock$2$1_0/a_3498_3# m1_13543_n1146# 0
C57 1bitblock$1$1_0/a_9800_n37# m1_8729_n3942# 0.0014f
C58 1bitblock$2$1_0/a_9800_n37# m1_8729_n3942# 0.0014f
C59 m1_12486_242# m1_n563_n5091# 0.12729f
C60 1bitblock$4_0/a_9050_63# m1_14167_n1145# 0.0052f
C61 m2_5443_n3913# 1bitblock$1$1_0/a_7083_63# 0.00187f
C62 1bitblock$1$1_0/m2_7791_79# 1bitblock$1$1_0/m2_9431_79# -0.00474f
C63 MUX21$1_0/m2_540_79# MUX21$1_0/a_157_63# 0
C64 m2_5443_n3913# m2_1701_n784# 0.03676f
C65 1bitblock$2$1_0/a_7410_63# m2_2396_n2595# 0.00156f
C66 1bitblock$1$1_0/a_11922_3# m1_n563_n5091# 0.00267f
C67 1bitblock$2$1_0/a_510_63# m1_13543_n1146# 0
C68 1bitblock$1$1_0/a_9609_407# m1_8729_n3942# 0.01871f
C69 1bitblock$1$1_0/a_7083_63# m1_n563_n5091# 0
C70 1bitblock$4_0/a_1262_n37# m2_1701_n784# 0
C71 1bitblock$1$1_0/a_2419_63# m1_12486_242# -0.00165f
C72 m1_12486_242# m1_8729_n3942# 0.05039f
C73 m1_14167_n1145# 1bitblock$1$1_0/a_1845_n37# 0
C74 1bitblock$2$1_0/a_8723_63# m2_2396_n2595# 0.02885f
C75 m2_2396_n2595# 1bitblock$3$1_0/a_1845_n37# 0.00179f
C76 1bitblock$1$1_0/a_1845_466# m1_n563_n5091# 0.00107f
C77 m2_1701_n784# m1_n563_n5091# 0.08054f
C78 1bitblock$4_0/a_510_63# m1_14167_n1145# 0.00107f
C79 1bitblock$1$1_0/a_10363_63# m1_8729_n3942# 0.00192f
C80 m2_1701_n784# 1bitblock$1$1_0/m2_6151_79# 0
C81 1bitblock$1$1_0/a_10906_n37# m1_12486_242# 0.00484f
C82 1bitblock$1$1_0/a_8361_407# m1_8729_n3942# 0.00891f
C83 1bitblock$1$1_0/a_8723_63# m1_n563_n5091# -0.00527f
C84 1bitblock$2$1_0/a_3940_63# 1bitblock$3$1_0/a_2419_63# 0
C85 1bitblock$1$1_0/a_3498_3# m2_1701_n784# -0.0052f
C86 1bitblock$1$1_0/a_7083_63# m1_8729_n3942# 0.05469f
C87 1bitblock$1$1_0/m2_24_342# m1_14167_n1145# 0.00373f
C88 m2_14516_n651# MUX21$1_0/a_517_n37# 0
C89 m2_5443_n3913# 1bitblock$4_0/a_3498_3# 0
C90 1bitblock$1$1_0/a_2419_63# m2_1701_n784# 0.4677f
C91 1bitblock$1$1_0/a_160_63# m2_1701_n784# 0
C92 m2_1701_n784# m1_8729_n3942# 0.03255f
C93 1bitblock$1$1_0/a_11480_63# m1_12486_242# 0.01269f
C94 AND4$1_0/a_518_229# m1_15541_n412# 0
C95 m2_2396_n2595# 1bitblock$1$1_0/a_378_271# 0
C96 m2_14516_n651# m1_15541_n412# 0.13525f
C97 1bitblock$4_0/a_705_407# m2_1701_n784# 0
C98 m2_2396_n2595# 1bitblock$1$1_0/a_9050_63# 0.00507f
C99 m2_5443_n3913# 1bitblock$4_0/m2_6151_79# 0.01043f
C100 1bitblock$1$1_0/a_10906_466# m1_n563_n5091# 0.00111f
C101 1bitblock$2$1_0/a_160_63# 1bitblock$3$1_0/m2_24_342# 0.00419f
C102 1bitblock$3$1_0/m2_24_342# 1bitblock$3$1_0/a_3498_3# -0
C103 1bitblock$1$1_0/m2_24_342# 1bitblock$2$1_0/a_510_63# 0
C104 m2_5443_n3913# 1bitblock$2$1_0/a_5243_407# 0.01246f
C105 1bitblock$2$1_0/a_2861_3# 1bitblock$2$1_0/a_705_407# -0
C106 1bitblock$1$1_0/a_8723_63# m1_8729_n3942# 0.09524f
C107 m2_1701_n784# 1bitblock$1$1_0/m2_9431_79# 0
C108 m2_5443_n3913# 1bitblock$2$1_0/a_4650_n37# 0.00119f
C109 1bitblock$4_0/a_3498_3# m1_n563_n5091# -0.00886f
C110 MUX21$1_0/a_718_407# m1_12480_n3815# 0.00296f
C111 m2_5443_n3913# 1bitblock$1$1_0/a_4650_n37# 0.00119f
C112 1bitblock$2$1_0/a_870_n37# 1bitblock$3$1_0/a_160_63# 0.00135f
C113 1bitblock$2$1_0/m2_24_342# m2_2396_n2595# 0.00302f
C114 1bitblock$1$1_0/m2_9431_79# 1bitblock$1$1_0/a_8723_63# -0
C115 1bitblock$4_0/a_5768_63# m2_5443_n3913# 0.01316f
C116 m2_1701_n784# 1bitblock$1$1_0/a_5042_407# 0.02321f
C117 1bitblock$2$1_0/a_705_407# 1bitblock$3$1_0/a_1262_n37# 0
C118 AND4$1_0/a_518_229# m1_14167_n1145# 0.01521f
C119 AND4$1_0/a_704_n441# m2_14516_n651# 0.00119f
C120 1bitblock$4_0/a_160_63# 1bitblock$1$1_0/a_705_407# 0
C121 m2_14516_n651# m1_14167_n1145# 0.09216f
C122 m2_5443_n3913# 1bitblock$2$1_0/a_6721_407# 0.01358f
C123 1bitblock$4_0/a_160_63# m1_n563_n5091# 0.02528f
C124 m1_12484_n953# 1bitblock$2$1_0/a_11480_63# 0.0167f
C125 1bitblock$2$1_0/a_378_271# 1bitblock$1$1_0/a_510_63# 0
C126 1bitblock$4_0/a_3498_3# m1_8729_n3942# 0.00142f
C127 1bitblock$2$1_0/a_3940_63# 1bitblock$3$1_0/a_3940_63# 0.01104f
C128 1bitblock$1$1_0/a_2861_3# m1_n563_n5091# 0.00101f
C129 m2_5443_n3913# 1bitblock$4_0/a_5042_407# 0.05822f
C130 1bitblock$2$1_0/a_2419_63# m2_2396_n2595# 0.07185f
C131 1bitblock$4_0/m2_9431_79# m1_n563_n5091# -0.00109f
C132 m2_1701_n784# 1bitblock$1$1_0/a_3940_63# 0.00175f
C133 1bitblock$2$1_0/a_1845_466# 1bitblock$1$1_0/a_1845_466# 0.00145f
C134 1bitblock$2$1_0/a_1845_466# m2_1701_n784# 0.0015f
C135 m2_5443_n3913# 1bitblock$1$1_0/a_4290_63# 0.00738f
C136 1bitblock$4_0/a_160_63# 1bitblock$1$1_0/a_160_63# 0.04611f
C137 1bitblock$2$1_0/a_2419_63# m2_10721_n3315# 0.04476f
C138 m2_5443_n3913# 1bitblock$4_0/a_3940_63# 0.00286f
C139 1bitblock$2$1_0/m2_24_342# m1_13543_n1146# 0.00392f
C140 1bitblock$2$1_0/m2_24_342# 1bitblock$3$1_0/a_1845_466# 0
C141 m1_15541_n412# m1_12486_242# 1.92011f
C142 1bitblock$2$1_0/a_160_63# 1bitblock$3$1_0/a_705_407# 0
C143 AND4$1_0/a_912_n441# m2_2396_n2595# 0.0044f
C144 1bitblock$4_0/m2_7791_79# m2_1701_n784# 0
C145 1bitblock$4_0/m2_9431_79# m1_8729_n3942# 0.02012f
C146 1bitblock$1$1_0/a_4290_63# m1_n563_n5091# 0
C147 m2_5443_n3913# 1bitblock$2$1_0/a_6520_n37# 0.00151f
C148 1bitblock$3$1_0/a_2419_63# 1bitblock$3$1_0/a_705_407# -0
C149 1bitblock$3$1_0/a_705_407# 1bitblock$3$1_0/a_160_63# 0
C150 1bitblock$2$1_0/a_2419_63# 1bitblock$3$1_0/a_11922_3# 0
C151 1bitblock$3$1_0/a_9609_407# 1bitblock$3$1_0/m2_7791_79# -0
C152 1bitblock$2$1_0/a_705_407# 1bitblock$1$1_0/a_510_63# 0
C153 1bitblock$1$1_0/a_7410_63# m1_n563_n5091# 0
C154 1bitblock$2$1_0/a_2861_3# m1_n563_n5091# 0.00101f
C155 m1_15541_n412# 1bitblock$1$1_0/a_11922_3# 0
C156 m2_5443_n3913# 1bitblock$1$1_0/a_5042_n37# 0
C157 m1_8729_n3942# 1bitblock$3$1_0/a_7768_n37# 0
C158 1bitblock$4_0/a_11922_3# m1_n563_n5091# 0
C159 1bitblock$2$1_0/a_2419_63# m1_13543_n1146# 0.00534f
C160 m2_5443_n3913# 1bitblock$4_0/a_2419_63# 0.00862f
C161 1bitblock$2$1_0/a_705_407# 1bitblock$3$1_0/m2_24_342# 0
C162 1bitblock$2$1_0/a_160_63# 1bitblock$3$1_0/a_160_63# 0.0454f
C163 1bitblock$4_0/a_1845_n37# m1_14167_n1145# 0
C164 1bitblock$3$1_0/a_2419_63# 1bitblock$3$1_0/a_3498_3# -0
C165 m1_15541_n412# m2_1701_n784# 2.16295f
C166 m1_14167_n1145# m1_12486_242# 0.0897f
C167 1bitblock$4_0/a_1845_466# m1_n563_n5091# 0
C168 m2_2396_n2595# m2_10721_n3315# 0.01652f
C169 1bitblock$4_0/a_3940_63# 1bitblock$1$1_0/a_2419_63# 0
C170 1bitblock$4_0/a_10363_63# m1_8729_n3942# 0.00105f
C171 1bitblock$1$1_0/a_7410_63# m1_8729_n3942# 0.00637f
C172 1bitblock$4_0/a_2419_63# m1_n563_n5091# 0
C173 1bitblock$2$1_0/m2_7791_79# m1_n563_n5091# -0
C174 1bitblock$3$1_0/a_3498_3# 1bitblock$3$1_0/m2_9431_79# -0
C175 1bitblock$2$1_0/a_378_271# 1bitblock$3$1_0/a_705_407# 0
C176 1bitblock$4_0/a_10906_n37# m1_12486_242# 0.00168f
C177 1bitblock$1$1_0/m2_24_342# 1bitblock$2$1_0/m2_24_342# 0.0286f
C178 MUX21$1_0/a_718_407# m1_n563_n5091# 0.0018f
C179 m1_13543_n1146# 1bitblock$3$1_0/m2_7791_79# 0.01676f
C180 1bitblock$4_0/a_7083_63# m2_1701_n784# 0.02635f
C181 1bitblock$2$1_0/a_3498_3# m2_1701_n784# 0.0012f
C182 1bitblock$1$1_0/a_4290_63# 1bitblock$1$1_0/a_5042_407# 0
C183 1bitblock$4_0/a_11480_63# m1_12486_242# 0.00896f
C184 m1_14167_n1145# 1bitblock$1$1_0/a_1845_466# 0.00183f
C185 AND4$1_0/a_704_n441# m2_1701_n784# 0.01591f
C186 m1_14167_n1145# m2_1701_n784# 0.36644f
C187 m2_5443_n3913# 1bitblock$2$1_0/a_3940_63# 0.00421f
C188 m2_2396_n2595# 1bitblock$3$1_0/a_1845_466# 0.00179f
C189 1bitblock$4_0/a_9609_407# m1_8729_n3942# 0.00143f
C190 1bitblock$3$1_0/m2_7791_79# 1bitblock$3$1_0/a_8723_63# 0
C191 m2_2396_n2595# m1_13543_n1146# 0.33711f
C192 1bitblock$4_0/a_2419_63# 1bitblock$1$1_0/a_2419_63# 1.63229f
C193 1bitblock$4_0/a_2419_63# m1_8729_n3942# 0.00658f
C194 1bitblock$3$1_0/a_11922_3# m2_10721_n3315# 0.01722f
C195 1bitblock$2$1_0/m2_7791_79# m1_8729_n3942# 0.02388f
C196 1bitblock$4_0/a_2419_63# 1bitblock$4_0/a_705_407# -0
C197 1bitblock$2$1_0/a_378_271# 1bitblock$3$1_0/a_160_63# 0.00362f
C198 m1_13543_n1146# 1bitblock$3$1_0/a_9609_407# 0.10003f
C199 1bitblock$4_0/a_8723_63# m2_1701_n784# 0
C200 1bitblock$4_0/m2_7791_79# 1bitblock$4_0/m2_9431_79# -0.00444f
C201 m2_5443_n3913# 1bitblock$4_0/a_4650_n37# 0.00119f
C202 m1_13543_n1146# m2_10721_n3315# 0.17094f
C203 1bitblock$2$1_0/a_3940_63# m1_n563_n5091# 0
C204 1bitblock$3$1_0/a_2861_391# 1bitblock$3$1_0/a_705_407# -0
C205 1bitblock$3$1_0/a_2419_63# 1bitblock$3$1_0/a_3940_63# -0
C206 1bitblock$3$1_0/a_11922_391# m2_10721_n3315# 0.00397f
C207 1bitblock$2$1_0/a_2419_63# m1_12484_n953# 0.03322f
C208 1bitblock$4_0/a_3940_63# 1bitblock$1$1_0/a_3940_63# 0.01129f
C209 1bitblock$3$1_0/a_10363_63# m1_13543_n1146# 0.00478f
C210 1bitblock$1$1_0/a_510_63# m1_n563_n5091# 0
C211 m1_8729_n3942# 1bitblock$3$1_0/a_8160_n37# 0.00163f
C212 m1_13543_n1146# 1bitblock$3$1_0/a_8361_407# 0.03557f
C213 1bitblock$2$1_0/a_2419_63# 1bitblock$3$1_0/a_2861_3# 0
C214 1bitblock$3$1_0/a_11922_3# m1_13543_n1146# 0.01495f
C215 1bitblock$4_0/a_3498_3# m1_14167_n1145# 1.79259f
C216 1bitblock$2$1_0/a_8361_407# m2_2396_n2595# 0.03425f
C217 m1_13543_n1146# 1bitblock$3$1_0/a_7083_63# 0.0048f
C218 1bitblock$3$1_0/a_2861_391# 1bitblock$3$1_0/a_3498_3# -0
C219 1bitblock$3$1_0/m2_24_342# m1_n563_n5091# 0.01803f
C220 1bitblock$1$1_0/a_9050_63# 1bitblock$1$1_0/m2_7791_79# -0
C221 1bitblock$3$1_0/a_1845_466# m1_13543_n1146# 0.01449f
C222 1bitblock$1$1_0/m2_24_342# m2_2396_n2595# 0
C223 1bitblock$3$1_0/a_10906_466# m2_10721_n3315# 0.0161f
C224 1bitblock$4_0/a_9800_n37# m1_8729_n3942# 0.00139f
C225 MUX21$1_0/a_157_63# m1_n563_n5091# 0.00149f
C226 1bitblock$4_0/a_2419_63# 1bitblock$1$1_0/a_3940_63# 0
C227 1bitblock$4_0/m2_24_342# 1bitblock$1$1_0/m2_24_342# 0.16333f
C228 1bitblock$4_0/a_4290_63# m2_5443_n3913# 0.00478f
C229 1bitblock$4_0/a_705_407# 1bitblock$1$1_0/a_510_63# 0
C230 1bitblock$3$1_0/a_11922_391# m1_13543_n1146# 0.00701f
C231 1bitblock$2$1_0/m2_9431_79# m1_n563_n5091# -0
C232 1bitblock$2$1_0/a_705_407# 1bitblock$3$1_0/a_160_63# 0
C233 1bitblock$4_0/a_160_63# m1_14167_n1145# 0
C234 m1_13543_n1146# 1bitblock$3$1_0/a_8723_63# 0.02911f
C235 MUX21$1_0/m2_540_79# m1_n563_n5091# -0.00173f
C236 1bitblock$4_0/a_2861_3# 1bitblock$1$1_0/a_2419_63# 0
C237 1bitblock$2$1_0/a_9609_407# m2_2396_n2595# 0.09632f
C238 m1_12484_n953# m2_2396_n2595# 0.16107f
C239 AND4$1_0/a_912_n441# m2_14516_n651# 0.00402f
C240 1bitblock$4_0/a_2861_3# 1bitblock$4_0/a_705_407# -0
C241 m1_14167_n1145# 1bitblock$1$1_0/a_2861_3# 0.00149f
C242 m1_14167_n1145# 1bitblock$4_0/m2_9431_79# 0.02029f
C243 m2_2396_n2595# 1bitblock$3$1_0/a_2861_3# 0.00145f
C244 1bitblock$4_0/a_9609_407# 1bitblock$4_0/m2_7791_79# -0
C245 1bitblock$2$1_0/a_2861_391# m2_2396_n2595# 0.01578f
C246 1bitblock$3$1_0/a_10906_466# m1_13543_n1146# 0.01097f
C247 m2_5443_n3913# 1bitblock$2$1_0/a_4290_63# 0.00738f
C248 1bitblock$2$1_0/m2_9431_79# m1_8729_n3942# 0.02467f
C249 m1_12484_n953# m2_10721_n3315# 2.41735f
C250 AND4$1_0/a_518_229# m2_2396_n2595# 0.05061f
C251 1bitblock$4_0/m2_9431_79# 1bitblock$4_0/a_8723_63# -0
C252 1bitblock$4_0/a_11922_3# m1_15541_n412# 0
C253 m2_14516_n651# m2_2396_n2595# 0.00583f
C254 m2_5443_n3913# 1bitblock$4_0/a_5042_n37# 0
C255 1bitblock$2$1_0/a_9050_63# m1_n563_n5091# 0
C256 1bitblock$2$1_0/a_378_271# 1bitblock$2$1_0/a_705_407# -0
C257 1bitblock$2$1_0/a_4290_63# m1_n563_n5091# 0
C258 1bitblock$2$1_0/a_11922_3# m2_2396_n2595# 0.01144f
C259 1bitblock$1$1_0/a_378_271# m2_1701_n784# 0.00848f
C260 m2_14516_n651# m2_10721_n3315# 0.00204f
C261 1bitblock$1$1_0/a_9050_63# m2_1701_n784# 0
C262 m1_12484_n953# 1bitblock$3$1_0/a_11922_3# 0
C263 m2_5443_n3913# 1bitblock$3$1_0/m2_6151_79# 0.01067f
C264 1bitblock$4_0/a_2419_63# m1_15541_n412# 0.07066f
C265 m1_n563_n5091# 1bitblock$3$1_0/a_705_407# -0
C266 1bitblock$4_0/a_2861_391# 1bitblock$4_0/a_3498_3# -0
C267 1bitblock$2$1_0/a_2861_3# 1bitblock$2$1_0/a_3498_3# -0
C268 1bitblock$4_0/a_7410_63# m1_8729_n3942# 0.00465f
C269 1bitblock$4_0/a_10363_63# m1_14167_n1145# 0.00489f
C270 m1_14167_n1145# 1bitblock$4_0/a_3940_63# 0
C271 MUX21$1_0/a_718_407# m1_15541_n412# 0
C272 m2_5443_n3913# 1bitblock$3$1_0/a_3498_3# 0
C273 1bitblock$2$1_0/a_11922_3# m2_10721_n3315# 0.00359f
C274 m1_12484_n953# m1_13543_n1146# 0.08498f
C275 1bitblock$4_0/a_11922_3# m1_14167_n1145# 0.01214f
C276 m2_5443_n3913# 1bitblock$3$1_0/a_2419_63# 0.00867f
C277 1bitblock$2$1_0/a_9050_63# m1_8729_n3942# 0.02224f
C278 1bitblock$3$1_0/a_2861_3# m1_13543_n1146# 0.01984f
C279 m1_n563_n5091# 1bitblock$3$1_0/m2_6151_79# 0
C280 1bitblock$2$1_0/m2_24_342# m2_1701_n784# 0
C281 1bitblock$2$1_0/a_160_63# 1bitblock$1$1_0/a_705_407# 0
C282 1bitblock$2$1_0/a_160_63# m1_n563_n5091# 0.02629f
C283 m2_2396_n2595# 1bitblock$1$1_0/m2_7791_79# 0.0169f
C284 1bitblock$4_0/a_1845_466# m1_14167_n1145# 0.01466f
C285 m1_n563_n5091# 1bitblock$3$1_0/a_3498_3# -0.0086f
C286 1bitblock$4_0/a_10906_466# m1_15541_n412# 0.00242f
C287 1bitblock$2$1_0/a_11922_3# 1bitblock$3$1_0/a_11922_3# 0.0017f
C288 AND4$1_0/a_518_229# m1_13543_n1146# 0.05606f
C289 m2_14516_n651# m1_13543_n1146# 0.00988f
C290 1bitblock$4_0/a_9609_407# m1_14167_n1145# 0.10113f
C291 m1_n563_n5091# 1bitblock$3$1_0/a_2419_63# 0
C292 m1_n563_n5091# 1bitblock$3$1_0/a_160_63# 0.0255f
C293 1bitblock$4_0/a_2419_63# m1_14167_n1145# 0.07947f
C294 1bitblock$4_0/a_11922_391# m1_14167_n1145# 0.00712f
C295 1bitblock$2$1_0/a_1845_n37# m1_13543_n1146# 0.00179f
C296 MUX21$1_0/a_718_407# m1_14167_n1145# 0
C297 1bitblock$2$1_0/a_11922_3# m1_13543_n1146# 0
C298 1bitblock$1$1_0/a_7768_n37# m1_8729_n3942# 0
C299 1bitblock$2$1_0/a_2419_63# m2_1701_n784# 0
C300 m2_5443_n3913# 1bitblock$3$1_0/a_5042_407# 0.05824f
C301 m1_n563_n5091# 1bitblock$3$1_0/m2_9431_79# -0.00106f
C302 m2_2396_n2595# 1bitblock$1$1_0/a_9609_407# 0.1012f
C303 1bitblock$2$1_0/a_160_63# 1bitblock$1$1_0/a_160_63# 0.00196f
C304 m1_8729_n3942# 1bitblock$3$1_0/a_3498_3# 0.0014f
C305 m2_2396_n2595# m1_12486_242# 0.0866f
C306 1bitblock$4_0/a_160_63# 1bitblock$1$1_0/a_378_271# 0.00373f
C307 1bitblock$3$1_0/a_2419_63# m1_8729_n3942# 0.00663f
C308 1bitblock$4_0/a_10906_466# m1_14167_n1145# 0.01125f
C309 1bitblock$3$1_0/a_7410_63# m1_13543_n1146# 0.0016f
C310 m1_n563_n5091# 1bitblock$3$1_0/a_5042_407# 0
C311 1bitblock$2$1_0/a_378_271# 1bitblock$1$1_0/a_705_407# 0
C312 m2_2396_n2595# 1bitblock$1$1_0/a_10363_63# 0.00482f
C313 AND4$1_0/a_912_n441# m2_1701_n784# 0.01194f
C314 m2_5443_n3913# 1bitblock$3$1_0/a_3940_63# 0.00284f
C315 1bitblock$2$1_0/a_378_271# m1_n563_n5091# 0.00489f
C316 m2_2396_n2595# 1bitblock$1$1_0/a_8361_407# 0.03598f
C317 m2_2396_n2595# 1bitblock$1$1_0/a_11922_3# 0.01205f
C318 m1_8729_n3942# 1bitblock$3$1_0/m2_9431_79# 0.02041f
C319 m2_2396_n2595# 1bitblock$1$1_0/a_7083_63# 0.00482f
C320 MUX21$1_0/a_157_63# m1_15541_n412# 0.00238f
C321 m2_5443_n3913# 1bitblock$2$1_0/a_6128_n37# 0
C322 1bitblock$4_0/a_7410_63# 1bitblock$4_0/m2_7791_79# 0
C323 1bitblock$2$1_0/a_10906_n37# m2_2396_n2595# 0.00148f
C324 m2_2396_n2595# 1bitblock$1$1_0/a_1845_466# 0.0015f
C325 1bitblock$4_0/a_705_407# 1bitblock$1$1_0/a_1262_n37# 0
C326 m1_n563_n5091# 1bitblock$3$1_0/a_3940_63# 0
C327 m2_2396_n2595# m2_1701_n784# 1.22078f
C328 m1_14167_n1145# 1bitblock$1$1_0/a_510_63# 0
C329 m2_2396_n2595# 1bitblock$3$1_0/a_510_63# 0
C330 1bitblock$4_0/m2_24_342# 1bitblock$1$1_0/a_1845_466# 0
C331 1bitblock$4_0/m2_24_342# m2_1701_n784# 0.01532f
C332 MUX21$1_0/m2_540_79# m1_15541_n412# 0.01017f
C333 m2_2396_n2595# 1bitblock$1$1_0/a_11922_391# 0.00705f
C334 m1_n563_n5091# m1_12480_n3815# 0.04173f
C335 1bitblock$4_0/a_9408_n37# m1_8729_n3942# 0
C336 m1_12484_n953# AND4$1_0/a_518_229# 0.00876f
C337 m2_14516_n651# m1_12484_n953# 0.10897f
C338 1bitblock$2$1_0/a_160_63# 1bitblock$3$1_0/a_378_271# 0.00364f
C339 m2_2396_n2595# 1bitblock$1$1_0/a_8723_63# 0.02997f
C340 1bitblock$4_0/a_2861_3# m1_14167_n1145# 0.0205f
C341 1bitblock$2$1_0/a_510_63# 1bitblock$1$1_0/a_510_63# 0.00154f
C342 1bitblock$4_0/a_378_271# 1bitblock$1$1_0/a_705_407# 0
C343 MUX21$1_0/a_157_63# m1_14167_n1145# 0.0056f
C344 m1_12484_n953# 1bitblock$2$1_0/a_11922_3# 0.03274f
C345 1bitblock$2$1_0/a_10906_466# m1_n563_n5091# 0.00105f
C346 1bitblock$2$1_0/a_705_407# 1bitblock$1$1_0/a_705_407# 0.04927f
C347 m2_14516_n651# AND4$1_0/a_518_229# 0.01804f
C348 1bitblock$1$1_0/a_8160_n37# m1_8729_n3942# 0.00164f
C349 m2_2396_n2595# 1bitblock$1$1_0/a_10906_466# 0.0111f
C350 1bitblock$2$1_0/a_705_407# m1_n563_n5091# 0.00817f
C351 1bitblock$1$1_0/a_11922_3# m1_13543_n1146# 0
C352 MUX21$1_0/m2_540_79# m1_14167_n1145# 0.01323f
C353 1bitblock$3$1_0/a_9050_63# 1bitblock$3$1_0/m2_9431_79# -0
C354 1bitblock$4_0/m2_24_342# 1bitblock$4_0/a_3498_3# -0
C355 1bitblock$4_0/a_9050_63# m2_1701_n784# 0
C356 m2_1701_n784# m1_13543_n1146# 0.0051f
C357 1bitblock$3$1_0/a_510_63# m1_13543_n1146# 0.00107f
C358 1bitblock$4_0/a_378_271# 1bitblock$1$1_0/a_160_63# 0.00372f
C359 1bitblock$4_0/a_870_n37# 1bitblock$1$1_0/a_160_63# 0.00138f
C360 1bitblock$4_0/a_7410_63# m1_14167_n1145# 0.00163f
C361 1bitblock$2$1_0/a_705_407# 1bitblock$1$1_0/a_160_63# 0
C362 1bitblock$4_0/m2_24_342# 1bitblock$4_0/a_160_63# -0
C363 1bitblock$1$1_0/a_1845_n37# m2_1701_n784# 0.00561f
C364 m2_2396_n2595# 1bitblock$1$1_0/a_2861_3# 0.01004f
C365 m2_5443_n3913# 1bitblock$2$1_0/a_5768_63# 0.01877f
C366 1bitblock$2$1_0/a_1262_n37# m1_13543_n1146# 0
C367 1bitblock$4_0/a_510_63# m2_1701_n784# 0
C368 m1_12484_n953# m1_12486_242# 0.0157f
C369 1bitblock$4_0/a_7768_n37# m1_8729_n3942# 0
C370 1bitblock$2$1_0/a_5768_63# m1_n563_n5091# 0
C371 1bitblock$1$1_0/m2_24_342# m2_1701_n784# 0.02455f
C372 m2_5443_n3913# m1_n563_n5091# 0.18639f
C373 1bitblock$2$1_0/a_510_63# 1bitblock$3$1_0/a_705_407# 0
C374 1bitblock$2$1_0/a_11922_391# m2_2396_n2595# 0.00681f
C375 1bitblock$4_0/a_1262_n37# 1bitblock$1$1_0/a_705_407# 0
C376 1bitblock$2$1_0/a_8723_63# 1bitblock$2$1_0/m2_9431_79# -0
C377 m2_14516_n651# m1_12486_242# 0.00988f
C378 m1_12484_n953# 1bitblock$1$1_0/a_11922_3# 0.01185f
C379 AND4$1_0/a_1120_n441# m2_2396_n2595# 0
C380 m2_5443_n3913# 1bitblock$1$1_0/m2_6151_79# 0.01607f
C381 1bitblock$2$1_0/a_705_407# 1bitblock$3$1_0/a_378_271# 0
C382 1bitblock$1$1_0/a_705_407# m1_n563_n5091# 0.00876f
C383 m1_12484_n953# 1bitblock$2$1_0/a_10906_n37# 0.00483f
C384 m2_5443_n3913# 1bitblock$1$1_0/a_3498_3# 0.05026f
C385 m2_2396_n2595# 1bitblock$1$1_0/a_7410_63# 0.00161f
C386 m1_12484_n953# m2_1701_n784# 0.00165f
C387 1bitblock$2$1_0/a_2861_3# m2_2396_n2595# 0.01973f
C388 m2_5443_n3913# 1bitblock$1$1_0/a_2419_63# 0.00541f
C389 AND4$1_0/a_518_229# 1bitblock$1$1_0/a_11922_3# 0.0046f
C390 m2_14516_n651# 1bitblock$1$1_0/a_11922_3# 0.00533f
C391 m2_5443_n3913# m1_8729_n3942# 0.00777f
C392 1bitblock$1$1_0/m2_6151_79# m1_n563_n5091# 0
C393 1bitblock$2$1_0/a_510_63# 1bitblock$3$1_0/a_160_63# 0
C394 m1_12484_n953# 1bitblock$1$1_0/a_11922_391# 0.00359f
C395 1bitblock$2$1_0/m2_24_342# 1bitblock$1$1_0/a_510_63# 0
C396 m2_5443_n3913# 1bitblock$1$1_0/a_6721_407# 0.01358f
C397 1bitblock$1$1_0/a_3498_3# m1_n563_n5091# 0.03072f
C398 1bitblock$2$1_0/a_11922_3# 1bitblock$1$1_0/a_11922_3# 0
C399 AND4$1_0/a_518_229# m2_1701_n784# 0.02153f
C400 1bitblock$4_0/a_1262_n37# 1bitblock$4_0/a_705_407# 0
C401 m1_14167_n1145# 1bitblock$1$1_0/a_1262_n37# 0
C402 m2_14516_n651# m2_1701_n784# 0.85907f
C403 m2_2396_n2595# 1bitblock$3$1_0/a_1262_n37# 0
C404 1bitblock$1$1_0/a_2419_63# m1_n563_n5091# 0.00292f
C405 1bitblock$1$1_0/a_160_63# m1_n563_n5091# 0.0263f
C406 1bitblock$1$1_0/a_9609_407# 1bitblock$1$1_0/m2_7791_79# -0
C407 m1_n563_n5091# m1_8729_n3942# 0.27477f
C408 m1_15541_n412# m1_12480_n3815# 0.00167f
C409 1bitblock$2$1_0/m2_24_342# 1bitblock$3$1_0/m2_24_342# 0.14833f
C410 1bitblock$4_0/a_705_407# m1_n563_n5091# -0
C411 m2_5443_n3913# 1bitblock$3$1_0/a_6128_n37# 0
C412 m2_2396_n2595# 1bitblock$4_0/a_2419_63# 0
C413 1bitblock$2$1_0/m2_7791_79# m2_2396_n2595# 0.01632f
C414 m1_12484_n953# 1bitblock$1$1_0/a_10906_466# 0
C415 MUX21$1_0/a_718_407# m2_2396_n2595# 0.00276f
C416 m2_5443_n3913# 1bitblock$1$1_0/a_5042_407# 0.06275f
C417 1bitblock$1$1_0/m2_9431_79# m1_n563_n5091# -0
C418 AND4$1_0/a_1120_n441# m1_13543_n1146# 0.0044f
C419 1bitblock$1$1_0/a_3498_3# m1_8729_n3942# 0.00389f
C420 1bitblock$1$1_0/m2_24_342# 1bitblock$4_0/a_160_63# 0.00432f
C421 m2_5443_n3913# 1bitblock$2$1_0/a_7083_63# 0.00187f
C422 1bitblock$2$1_0/a_10363_63# m1_8729_n3942# 0.00192f
C423 1bitblock$1$1_0/a_2419_63# m1_8729_n3942# 0.00237f
C424 1bitblock$2$1_0/a_2861_3# m1_13543_n1146# 0.00145f
C425 1bitblock$4_0/a_705_407# 1bitblock$1$1_0/a_160_63# 0
C426 m2_14516_n651# 1bitblock$1$1_0/a_10906_466# 0
C427 1bitblock$1$1_0/a_5042_407# m1_n563_n5091# 0
C428 1bitblock$1$1_0/a_11480_63# m1_n563_n5091# 0
C429 m1_14167_n1145# m1_12480_n3815# 0
C430 m2_5443_n3913# 1bitblock$1$1_0/a_3940_63# 0.00421f
C431 1bitblock$1$1_0/a_5768_63# m2_1701_n784# 0
C432 1bitblock$2$1_0/a_7083_63# m1_n563_n5091# 0
C433 m2_1701_n784# 1bitblock$1$1_0/m2_7791_79# 0
C434 1bitblock$1$1_0/m2_9431_79# m1_8729_n3942# 0.02467f
C435 1bitblock$2$1_0/a_3940_63# m2_2396_n2595# 0
C436 1bitblock$3$1_0/a_1262_n37# m1_13543_n1146# -0
C437 m1_n563_n5091# 1bitblock$3$1_0/a_378_271# 0
C438 1bitblock$4_0/a_378_271# m1_14167_n1145# 0.00199f
C439 1bitblock$1$1_0/a_3940_63# m1_n563_n5091# 0
C440 1bitblock$1$1_0/a_11922_3# m1_12486_242# 0.01722f
C441 1bitblock$2$1_0/a_1845_466# m1_n563_n5091# 0.00109f
C442 1bitblock$2$1_0/a_3940_63# m2_10721_n3315# 0
C443 m2_1701_n784# 1bitblock$1$1_0/a_9609_407# -0
C444 1bitblock$2$1_0/a_7083_63# m1_8729_n3942# 0.0547f
C445 1bitblock$4_0/a_1845_n37# m2_1701_n784# 0.00311f
C446 m2_1701_n784# m1_12486_242# 0.92821f
C447 1bitblock$2$1_0/m2_24_342# 1bitblock$3$1_0/a_705_407# 0
C448 m2_2396_n2595# 1bitblock$3$1_0/m2_24_342# 0.00389f
C449 1bitblock$1$1_0/a_2419_63# 1bitblock$1$1_0/a_3940_63# -0
C450 1bitblock$4_0/m2_7791_79# m1_n563_n5091# -0
C451 m1_12484_n953# 1bitblock$2$1_0/a_11922_391# 0.00755f
C452 1bitblock$1$1_0/a_11922_391# m1_12486_242# 0.00397f
C453 m2_5443_n3913# 1bitblock$3$1_0/a_6520_n37# 0.00151f
C454 m1_8729_n3942# 1bitblock$3$1_0/a_9050_63# 0.01697f
C455 m2_2396_n2595# MUX21$1_0/a_157_63# 0
C456 m2_1701_n784# 1bitblock$1$1_0/a_8361_407# -0
C457 1bitblock$2$1_0/m2_9431_79# m2_2396_n2595# 0.01952f
C458 1bitblock$1$1_0/a_11922_3# m2_1701_n784# 0
C459 m2_5443_n3913# m1_15541_n412# 0.05217f
C460 1bitblock$2$1_0/a_3940_63# m1_13543_n1146# 0
C461 m2_1701_n784# 1bitblock$1$1_0/a_7083_63# 0.03418f
C462 m2_5443_n3913# 1bitblock$2$1_0/m2_6151_79# 0.01608f
C463 1bitblock$2$1_0/m2_24_342# 1bitblock$3$1_0/a_160_63# 0.00437f
C464 1bitblock$1$1_0/a_1845_466# m2_1701_n784# 0.01233f
C465 m2_14516_n651# AND4$1_0/a_1120_n441# 0.00515f
C466 1bitblock$1$1_0/a_10906_466# m1_12486_242# 0.0161f
C467 1bitblock$4_0/m2_7791_79# m1_8729_n3942# 0.01993f
C468 m1_15541_n412# m1_n563_n5091# 0.00249f
C469 1bitblock$2$1_0/a_378_271# 1bitblock$1$1_0/a_378_271# 0.00593f
C470 m2_5443_n3913# 1bitblock$4_0/a_7083_63# 0.00107f
C471 m2_1701_n784# 1bitblock$1$1_0/a_8723_63# -0
C472 m2_5443_n3913# 1bitblock$2$1_0/a_3498_3# 0.05092f
C473 1bitblock$3$1_0/m2_24_342# m1_13543_n1146# 0.0031f
C474 m2_5443_n3913# m1_14167_n1145# 0.00325f
C475 1bitblock$2$1_0/m2_7791_79# 1bitblock$2$1_0/a_9609_407# -0
C476 1bitblock$2$1_0/a_2419_63# 1bitblock$3$1_0/a_2419_63# 1.31417f
C477 1bitblock$2$1_0/a_9050_63# m2_2396_n2595# 0.00483f
C478 MUX21$1_0/a_157_63# m1_13543_n1146# 0
C479 m1_15541_n412# 1bitblock$1$1_0/a_2419_63# 0.01284f
C480 1bitblock$2$1_0/a_3498_3# m1_n563_n5091# 0.02184f
C481 m1_15541_n412# m1_8729_n3942# 0.0504f
C482 1bitblock$1$1_0/a_10906_466# m2_1701_n784# 0
C483 m1_14167_n1145# 1bitblock$1$1_0/a_705_407# 0
C484 m2_2396_n2595# 1bitblock$3$1_0/a_705_407# 0
C485 m1_14167_n1145# m1_n563_n5091# 0.68409f
C486 1bitblock$4_0/a_3498_3# m2_1701_n784# 0
C487 AND4$1_0/a_518_229# MUX21$1_0/a_718_407# 0
C488 1bitblock$4_0/m2_6151_79# m2_1701_n784# 0
C489 1bitblock$4_0/a_8361_407# m1_8729_n3942# 0
C490 1bitblock$2$1_0/a_510_63# 1bitblock$1$1_0/a_705_407# 0
C491 1bitblock$2$1_0/a_3498_3# 1bitblock$1$1_0/a_3498_3# 0.01312f
C492 1bitblock$4_0/a_8723_63# m1_n563_n5091# -0.0053f
C493 1bitblock$2$1_0/a_510_63# m1_n563_n5091# 0
C494 m1_14167_n1145# 1bitblock$1$1_0/a_3498_3# 0
C495 1bitblock$4_0/a_7083_63# m1_8729_n3942# 0.05365f
C496 1bitblock$2$1_0/a_160_63# m2_2396_n2595# 0
C497 1bitblock$2$1_0/a_3498_3# 1bitblock$1$1_0/a_2419_63# 0
C498 1bitblock$2$1_0/a_3498_3# m1_8729_n3942# 0.00389f
C499 m2_2396_n2595# 1bitblock$3$1_0/a_3498_3# 0
C500 1bitblock$2$1_0/a_705_407# 1bitblock$1$1_0/a_378_271# 0
C501 m1_14167_n1145# 1bitblock$1$1_0/a_2419_63# 0.004f
C502 m1_14167_n1145# 1bitblock$1$1_0/a_160_63# 0.00107f
C503 1bitblock$2$1_0/a_11480_63# m1_n563_n5091# 0
C504 1bitblock$4_0/a_160_63# m2_1701_n784# 0.00109f
C505 m1_14167_n1145# m1_8729_n3942# 0.01252f
C506 m2_2396_n2595# 1bitblock$3$1_0/a_2419_63# 0.00529f
C507 1bitblock$4_0/a_705_407# m1_14167_n1145# 0.00558f
C508 m2_2396_n2595# 1bitblock$3$1_0/a_160_63# 0.00103f
C509 1bitblock$3$1_0/m2_7791_79# 1bitblock$3$1_0/m2_9431_79# -0.00447f
C510 1bitblock$2$1_0/a_8160_n37# m1_8729_n3942# 0.00164f
C511 1bitblock$4_0/a_5768_63# m2_1701_n784# 0
C512 1bitblock$1$1_0/a_2861_3# m2_1701_n784# 0
C513 1bitblock$2$1_0/a_2419_63# 1bitblock$3$1_0/a_3940_63# 0
C514 1bitblock$4_0/a_8723_63# m1_8729_n3942# 0.07922f
C515 1bitblock$4_0/m2_9431_79# m2_1701_n784# 0
C516 1bitblock$3$1_0/a_2419_63# m2_10721_n3315# 0.02948f
C517 1bitblock$4_0/a_3940_63# m1_12486_242# 0
C518 1bitblock$3$1_0/a_705_407# m1_13543_n1146# 0.00558f
C519 1bitblock$4_0/a_11922_3# m1_12486_242# 0.01844f
C520 1bitblock$4_0/a_5042_407# m2_1701_n784# 0.01787f
C521 m2_5443_n3913# 1bitblock$1$1_0/a_6128_n37# 0
C522 1bitblock$3$1_0/a_10906_n37# m2_10721_n3315# 0.00484f
C523 1bitblock$2$1_0/a_7410_63# m1_n563_n5091# 0
C524 1bitblock$2$1_0/a_378_271# m2_2396_n2595# 0.00194f
C525 1bitblock$1$1_0/a_4290_63# m2_1701_n784# 0
C526 AND4$1_0/a_1120_n441# m2_1701_n784# 0.00916f
C527 1bitblock$2$1_0/a_160_63# m1_13543_n1146# 0.00107f
C528 1bitblock$3$1_0/a_1845_466# 1bitblock$3$1_0/a_3498_3# -0
C529 1bitblock$3$1_0/a_3498_3# m1_13543_n1146# 1.66674f
C530 1bitblock$4_0/a_11922_3# 1bitblock$1$1_0/a_11922_3# 0.00177f
C531 1bitblock$2$1_0/a_2419_63# 1bitblock$2$1_0/a_705_407# -0
C532 1bitblock$2$1_0/a_8723_63# m1_n563_n5091# -0.0053f
C533 1bitblock$4_0/a_2419_63# m1_12486_242# 0.05407f
C534 m2_14516_n651# MUX21$1_0/a_157_63# 0.01122f
C535 1bitblock$3$1_0/a_160_63# m1_13543_n1146# 0
C536 1bitblock$3$1_0/a_2419_63# m1_13543_n1146# 0.07504f
C537 1bitblock$4_0/a_11922_391# m1_12486_242# 0.00287f
C538 1bitblock$3$1_0/a_11480_63# m2_10721_n3315# 0.01269f
C539 m1_14167_n1145# 1bitblock$1$1_0/a_3940_63# 0
C540 1bitblock$4_0/a_3940_63# m2_1701_n784# 0.00164f
C541 1bitblock$2$1_0/a_1845_466# 1bitblock$2$1_0/a_3498_3# -0
C542 1bitblock$1$1_0/a_7410_63# m2_1701_n784# 0
C543 1bitblock$4_0/a_3498_3# 1bitblock$4_0/m2_9431_79# -0
C544 m2_2396_n2595# 1bitblock$3$1_0/a_3940_63# 0
C545 1bitblock$2$1_0/a_9408_n37# m1_8729_n3942# 0
C546 1bitblock$2$1_0/a_11480_63# 1bitblock$1$1_0/a_11480_63# 0.00182f
C547 1bitblock$4_0/a_11922_3# m2_1701_n784# 0
C548 1bitblock$2$1_0/a_7410_63# m1_8729_n3942# 0.00637f
C549 m1_13543_n1146# 1bitblock$3$1_0/m2_9431_79# 0.0201f
C550 1bitblock$3$1_0/a_10906_n37# m1_13543_n1146# 0.00152f
C551 m2_14516_n651# MUX21$1_0/m2_540_79# 0.00787f
C552 1bitblock$4_0/a_2419_63# 1bitblock$1$1_0/a_11922_3# 0
C553 MUX21$1_0/a_517_n37# m1_15541_n412# 0
C554 1bitblock$4_0/a_1845_466# 1bitblock$1$1_0/a_1845_466# 0.00192f
C555 1bitblock$4_0/a_1845_466# m2_1701_n784# 0.00247f
C556 1bitblock$4_0/a_10906_466# m1_12486_242# 0.00953f
C557 1bitblock$4_0/a_2861_391# 1bitblock$4_0/a_705_407# -0
C558 1bitblock$2$1_0/a_8723_63# m1_8729_n3942# 0.09622f
C559 m1_14167_n1145# 1bitblock$4_0/m2_7791_79# 0.01686f
C560 1bitblock$1$1_0/a_378_271# m1_n563_n5091# 0.00489f
C561 1bitblock$3$1_0/m2_9431_79# 1bitblock$3$1_0/a_8723_63# -0
C562 1bitblock$4_0/a_2419_63# m2_1701_n784# 0.36366f
C563 1bitblock$1$1_0/a_9050_63# m1_n563_n5091# 0
C564 m1_12480_n3815# m2_10721_n3315# 0.02463f
C565 1bitblock$3$1_0/a_11480_63# m1_13543_n1146# 0.0097f
C566 1bitblock$2$1_0/a_10906_466# m2_2396_n2595# 0.01059f
C567 MUX21$1_0/a_718_407# m2_1701_n784# 0
C568 1bitblock$2$1_0/a_378_271# m1_13543_n1146# 0.0025f
C569 1bitblock$2$1_0/a_705_407# m2_2396_n2595# 0.00549f
C570 1bitblock$1$1_0/m2_24_342# 1bitblock$2$1_0/a_160_63# 0
C571 1bitblock$3$1_0/a_2861_3# 1bitblock$3$1_0/a_705_407# -0
C572 1bitblock$2$1_0/m2_24_342# 1bitblock$1$1_0/a_705_407# 0
C573 1bitblock$3$1_0/a_11922_3# m1_12480_n3815# 0.00447f
C574 1bitblock$2$1_0/a_10906_466# m2_10721_n3315# 0
C575 MUX21$1_0/a_517_n37# m1_14167_n1145# 0
C576 1bitblock$2$1_0/m2_24_342# m1_n563_n5091# 0.03105f
C577 m1_13543_n1146# 1bitblock$3$1_0/a_3940_63# 0
C578 1bitblock$4_0/a_705_407# 1bitblock$1$1_0/a_378_271# 0
C579 m1_14167_n1145# m1_15541_n412# 0.08477f
C580 m2_5443_n3913# 1bitblock$1$1_0/a_6520_n37# 0.00151f
C581 1bitblock$1$1_0/a_9050_63# m1_8729_n3942# 0.02224f
C582 m1_8729_n3942# 1bitblock$3$1_0/a_9408_n37# 0
C583 m2_5443_n3913# 1bitblock$2$1_0/a_2419_63# 0.00972f
C584 1bitblock$4_0/a_1845_466# 1bitblock$4_0/a_3498_3# -0
C585 m1_12480_n3815# m1_13543_n1146# 0.07257f
C586 1bitblock$3$1_0/a_2861_3# 1bitblock$3$1_0/a_3498_3# -0
C587 m1_12484_n953# 1bitblock$3$1_0/a_2419_63# 0.04408f
C588 1bitblock$1$1_0/a_9050_63# 1bitblock$1$1_0/m2_9431_79# -0
C589 1bitblock$4_0/a_2419_63# 1bitblock$4_0/a_3498_3# -0
C590 1bitblock$4_0/a_10906_n37# m1_15541_n412# 0.00266f
C591 m1_14167_n1145# 1bitblock$4_0/a_8361_407# 0.03596f
C592 1bitblock$3$1_0/a_2861_391# m1_13543_n1146# 0.01584f
C593 1bitblock$2$1_0/a_2419_63# m1_n563_n5091# 0.00232f
C594 1bitblock$2$1_0/m2_24_342# 1bitblock$1$1_0/a_160_63# 0
C595 m1_14167_n1145# 1bitblock$4_0/a_7083_63# 0.00482f
C596 1bitblock$2$1_0/a_2861_3# 1bitblock$1$1_0/a_2861_3# 0
C597 1bitblock$1$1_0/a_510_63# m2_1701_n784# 0.00173f
C598 1bitblock$4_0/a_11480_63# m1_15541_n412# 0
C599 1bitblock$2$1_0/a_705_407# m1_13543_n1146# 0
C600 m2_5443_n3913# 1bitblock$3$1_0/a_5768_63# 0.01326f
C601 1bitblock$1$1_0/m2_24_342# 1bitblock$2$1_0/a_378_271# 0
C602 AND4$1_0/a_704_n441# m1_14167_n1145# 0.01112f
C603 1bitblock$2$1_0/a_2419_63# 1bitblock$1$1_0/a_3498_3# 0
C604 1bitblock$4_0/a_2861_3# m2_1701_n784# 0.00149f
C605 1bitblock$2$1_0/a_2419_63# 1bitblock$1$1_0/a_2419_63# 0.00365f
C606 m2_5443_n3913# m2_2396_n2595# 0.06231f
C607 m1_14167_n1145# 1bitblock$4_0/a_8723_63# 0.0292f
C608 1bitblock$2$1_0/a_2419_63# m1_8729_n3942# 0.00665f
C609 1bitblock$4_0/a_10906_n37# m1_14167_n1145# 0.00154f
C610 1bitblock$4_0/a_2419_63# 1bitblock$1$1_0/a_2861_3# 0
C611 MUX21$1_0/a_157_63# m2_1701_n784# 0
C612 m1_n563_n5091# 1bitblock$3$1_0/m2_7791_79# -0
C613 m2_2396_n2595# 1bitblock$1$1_0/a_705_407# 0.00123f
C614 m2_5443_n3913# 1bitblock$4_0/a_6128_n37# 0
C615 1bitblock$4_0/a_11480_63# m1_14167_n1145# 0.00995f
C616 m2_5443_n3913# m2_10721_n3315# 0.05254f
C617 1bitblock$4_0/m2_24_342# 1bitblock$1$1_0/a_705_407# 0
C618 m2_2396_n2595# m1_n563_n5091# 1.58588f
C619 1bitblock$4_0/m2_24_342# m1_n563_n5091# 0.01777f
C620 1bitblock$4_0/a_4290_63# m2_1701_n784# 0
C621 m1_8729_n3942# 1bitblock$3$1_0/m2_7791_79# 0.01998f
C622 1bitblock$3$1_0/a_7410_63# 1bitblock$3$1_0/m2_9431_79# -0
C623 m1_12484_n953# m1_12480_n3815# 0
C624 m1_8729_n3942# 1bitblock$3$1_0/a_9800_n37# 0.0014f
C625 1bitblock$1$1_0/m2_24_342# 1bitblock$2$1_0/a_705_407# 0
C626 m1_n563_n5091# m2_10721_n3315# 0.0925f
C627 m2_2396_n2595# 1bitblock$1$1_0/a_3498_3# 1.69486f
C628 1bitblock$4_0/a_2861_3# 1bitblock$4_0/a_3498_3# -0
C629 1bitblock$4_0/a_7410_63# m2_1701_n784# 0
C630 m2_5443_n3913# 1bitblock$3$1_0/a_7083_63# 0.00109f
C631 1bitblock$1$1_0/a_870_n37# m2_1701_n784# 0
C632 1bitblock$2$1_0/a_10363_63# m2_2396_n2595# 0.00459f
C633 m2_2396_n2595# 1bitblock$1$1_0/a_2419_63# 0.01135f
C634 m2_2396_n2595# m1_8729_n3942# 0.09192f
C635 1bitblock$4_0/a_160_63# 1bitblock$1$1_0/a_510_63# 0
C636 m2_5443_n3913# m1_13543_n1146# 0.00329f
C637 m1_12484_n953# 1bitblock$2$1_0/a_10906_466# 0.0176f
C638 1bitblock$4_0/m2_24_342# 1bitblock$1$1_0/a_160_63# 0.00441f
C639 m2_14516_n651# m1_12480_n3815# 0
C640 m1_n563_n5091# 1bitblock$3$1_0/a_11922_3# 0
C641 m1_8729_n3942# 1bitblock$3$1_0/a_9609_407# 0.00145f
C642 m2_2396_n2595# 1bitblock$1$1_0/m2_9431_79# 0.0203f
C643 1bitblock$4_0/a_2861_391# m1_14167_n1145# 0.01608f
C644 m2_2396_n2595# 1bitblock$1$1_0/a_10906_n37# 0.00153f
C645 m1_8729_n3942# m2_10721_n3315# 0.05078f
C646 1bitblock$2$1_0/a_705_407# 1bitblock$2$1_0/a_2861_391# -0
C647 m1_n563_n5091# 1bitblock$3$1_0/a_1845_466# 0
C648 m1_n563_n5091# m1_13543_n1146# 0.69902f
C649 m1_8729_n3942# 1bitblock$3$1_0/a_10363_63# 0.00105f
C650 m2_2396_n2595# 1bitblock$1$1_0/a_11480_63# 0.00982f
C651 m1_8729_n3942# 1bitblock$3$1_0/a_8361_407# 0
C652 m1_n563_n5091# 1bitblock$3$1_0/a_8723_63# -0.00531f
C653 1bitblock$2$1_0/a_7083_63# m2_2396_n2595# 0.00471f
C654 1bitblock$3$1_0/a_9050_63# 1bitblock$3$1_0/m2_7791_79# -0
C655 m1_8729_n3942# 1bitblock$3$1_0/a_7083_63# 0.0537f
C656 1bitblock$2$1_0/a_160_63# 1bitblock$3$1_0/a_510_63# 0
C657 m1_14167_n1145# 1bitblock$1$1_0/a_378_271# 0.00256f
C658 1bitblock$2$1_0/a_1262_n37# 1bitblock$3$1_0/a_705_407# 0
C659 1bitblock$1$1_0/a_2419_63# m1_13543_n1146# 0
C660 m2_5443_n3913# 1bitblock$4_0/a_6520_n37# 0.0015f
C661 1bitblock$4_0/a_9050_63# m1_8729_n3942# 0.01686f
C662 m1_8729_n3942# m1_13543_n1146# 0.01251f
C663 m2_2396_n2595# 1bitblock$3$1_0/a_378_271# 0.00248f
C664 1bitblock$4_0/a_510_63# 1bitblock$1$1_0/a_705_407# 0
C665 m2_14516_n651# MUX21$1_0/a_909_n37# 0
C666 1bitblock$2$1_0/a_1845_466# m2_2396_n2595# 0.01396f
C667 1bitblock$4_0/a_160_63# 1bitblock$1$1_0/a_870_n37# 0.00138f
C668 m1_8729_n3942# 1bitblock$3$1_0/a_8723_63# 0.08003f
C669 1bitblock$2$1_0/a_510_63# 1bitblock$1$1_0/a_378_271# 0
C670 m2_5443_n3913# 1bitblock$2$1_0/a_5042_407# 0.06277f
C671 1bitblock$2$1_0/a_3498_3# 1bitblock$2$1_0/m2_24_342# -0
C672 m2_5443_n3913# 1bitblock$3$1_0/a_4650_n37# 0.00118f
C673 m2_10721_n3315# VSUBS 3.33193f
C674 1bitblock$3$1_0/a_7083_63# VSUBS 0.85964f
C675 1bitblock$3$1_0/a_8723_63# VSUBS 0.40583f
C676 1bitblock$3$1_0/m2_9431_79# VSUBS 0.62602f
C677 1bitblock$3$1_0/m2_7791_79# VSUBS 0.61996f
C678 1bitblock$3$1_0/a_9609_407# VSUBS 0.11896f
C679 1bitblock$3$1_0/a_8361_407# VSUBS 0.05045f
C680 1bitblock$3$1_0/m2_6151_79# VSUBS 0.60126f
C681 1bitblock$3$1_0/a_6721_407# VSUBS 0.01523f
C682 1bitblock$3$1_0/a_5042_407# VSUBS 0.80196f
C683 1bitblock$3$1_0/a_3940_63# VSUBS 0.46874f
C684 m1_13543_n1146# VSUBS 3.96884f
C685 1bitblock$3$1_0/a_160_63# VSUBS 0.60578f
C686 1bitblock$3$1_0/a_5243_407# VSUBS 0.01459f
C687 1bitblock$3$1_0/a_705_407# VSUBS 0.14117f
C688 1bitblock$3$1_0/a_3498_3# VSUBS 1.27919f
C689 1bitblock$3$1_0/a_10906_n37# VSUBS 0.02232f
C690 1bitblock$3$1_0/a_9800_n37# VSUBS 0.01742f
C691 1bitblock$3$1_0/a_9408_n37# VSUBS 0.01326f
C692 1bitblock$3$1_0/a_8160_n37# VSUBS 0.01743f
C693 1bitblock$3$1_0/a_7768_n37# VSUBS 0.01327f
C694 1bitblock$3$1_0/a_6520_n37# VSUBS 0.01743f
C695 1bitblock$3$1_0/a_6128_n37# VSUBS 0.01327f
C696 1bitblock$3$1_0/a_5042_n37# VSUBS 0.01422f
C697 1bitblock$3$1_0/a_4650_n37# VSUBS 0.01569f
C698 m1_12480_n3815# VSUBS 2.27952f
C699 1bitblock$3$1_0/a_11922_3# VSUBS 0.64588f
C700 1bitblock$3$1_0/a_11922_391# VSUBS 0.00119f
C701 1bitblock$3$1_0/a_10906_466# VSUBS 0.59833f
C702 1bitblock$3$1_0/a_11480_63# VSUBS 0.42359f
C703 1bitblock$3$1_0/a_10363_63# VSUBS 0.13924f
C704 1bitblock$3$1_0/a_9050_63# VSUBS 0.55151f
C705 m1_8729_n3942# VSUBS 2.90486f
C706 1bitblock$3$1_0/a_7410_63# VSUBS 0.55618f
C707 1bitblock$3$1_0/a_5768_63# VSUBS 0.55887f
C708 1bitblock$3$1_0/a_1845_n37# VSUBS 0.01974f
C709 1bitblock$3$1_0/a_1262_n37# VSUBS 0.0127f
C710 1bitblock$3$1_0/a_870_n37# VSUBS 0.01586f
C711 1bitblock$3$1_0/a_4290_63# VSUBS 0.59072f
C712 1bitblock$3$1_0/a_2861_3# VSUBS 0.62907f
C713 1bitblock$3$1_0/a_1845_466# VSUBS 0.59877f
C714 1bitblock$3$1_0/a_2419_63# VSUBS 6.72858f
C715 1bitblock$3$1_0/a_510_63# VSUBS 0.58169f
C716 1bitblock$3$1_0/a_378_271# VSUBS 1.3894f
C717 m1_n563_n5091# VSUBS 0.11782p
C718 1bitblock$3$1_0/m2_24_342# VSUBS 2.00163f
C719 m2_5443_n3913# VSUBS 5.24763f
C720 m1_12486_242# VSUBS 3.28362f
C721 1bitblock$1$1_0/a_7083_63# VSUBS 0.85222f
C722 1bitblock$1$1_0/a_8723_63# VSUBS 0.40722f
C723 1bitblock$1$1_0/m2_9431_79# VSUBS 0.62597f
C724 1bitblock$1$1_0/m2_7791_79# VSUBS 0.61991f
C725 1bitblock$1$1_0/a_9609_407# VSUBS 0.11896f
C726 1bitblock$1$1_0/a_8361_407# VSUBS 0.05045f
C727 1bitblock$1$1_0/m2_6151_79# VSUBS 0.6012f
C728 1bitblock$1$1_0/a_6721_407# VSUBS 0.01523f
C729 1bitblock$1$1_0/a_5042_407# VSUBS 0.79698f
C730 1bitblock$1$1_0/a_3940_63# VSUBS 0.46873f
C731 m2_1701_n784# VSUBS 7.90146f
C732 1bitblock$1$1_0/a_160_63# VSUBS 0.60582f
C733 1bitblock$1$1_0/a_5243_407# VSUBS 0.01459f
C734 1bitblock$1$1_0/a_705_407# VSUBS 0.14113f
C735 1bitblock$1$1_0/a_3498_3# VSUBS 1.27913f
C736 1bitblock$1$1_0/a_10906_n37# VSUBS 0.02232f
C737 1bitblock$1$1_0/a_9800_n37# VSUBS 0.01742f
C738 1bitblock$1$1_0/a_9408_n37# VSUBS 0.01326f
C739 1bitblock$1$1_0/a_8160_n37# VSUBS 0.01743f
C740 1bitblock$1$1_0/a_7768_n37# VSUBS 0.01327f
C741 1bitblock$1$1_0/a_6520_n37# VSUBS 0.01743f
C742 1bitblock$1$1_0/a_6128_n37# VSUBS 0.01327f
C743 1bitblock$1$1_0/a_5042_n37# VSUBS 0.01422f
C744 1bitblock$1$1_0/a_4650_n37# VSUBS 0.01569f
C745 1bitblock$1$1_0/a_11922_3# VSUBS 0.64605f
C746 1bitblock$1$1_0/a_11922_391# VSUBS 0.00119f
C747 1bitblock$1$1_0/a_10906_466# VSUBS 0.59827f
C748 1bitblock$1$1_0/a_11480_63# VSUBS 0.42359f
C749 1bitblock$1$1_0/a_10363_63# VSUBS 0.13924f
C750 1bitblock$1$1_0/a_9050_63# VSUBS 0.55145f
C751 1bitblock$1$1_0/a_7410_63# VSUBS 0.55612f
C752 1bitblock$1$1_0/a_5768_63# VSUBS 0.55881f
C753 1bitblock$1$1_0/a_1845_n37# VSUBS 0.01974f
C754 1bitblock$1$1_0/a_1262_n37# VSUBS 0.0127f
C755 1bitblock$1$1_0/a_870_n37# VSUBS 0.01586f
C756 1bitblock$1$1_0/a_4290_63# VSUBS 0.59067f
C757 1bitblock$1$1_0/a_2861_3# VSUBS 0.62907f
C758 1bitblock$1$1_0/a_1845_466# VSUBS 0.59871f
C759 1bitblock$1$1_0/a_2419_63# VSUBS 6.60418f
C760 1bitblock$1$1_0/a_510_63# VSUBS 0.58168f
C761 1bitblock$1$1_0/a_378_271# VSUBS 1.38973f
C762 1bitblock$1$1_0/m2_24_342# VSUBS 1.99971f
C763 m1_15541_n412# VSUBS 5.47565f
C764 1bitblock$4_0/a_7083_63# VSUBS 0.85222f
C765 1bitblock$4_0/a_8723_63# VSUBS 0.40569f
C766 1bitblock$4_0/m2_9431_79# VSUBS 0.62597f
C767 1bitblock$4_0/m2_7791_79# VSUBS 0.61991f
C768 1bitblock$4_0/a_8361_407# VSUBS 0.05045f
C769 1bitblock$4_0/m2_6151_79# VSUBS 0.6012f
C770 1bitblock$4_0/a_6721_407# VSUBS 0.01523f
C771 1bitblock$4_0/a_5042_407# VSUBS 0.79698f
C772 1bitblock$4_0/a_3940_63# VSUBS 0.46873f
C773 m1_14167_n1145# VSUBS 3.95101f
C774 1bitblock$4_0/a_160_63# VSUBS 0.59457f
C775 1bitblock$4_0/a_5243_407# VSUBS 0.01459f
C776 1bitblock$4_0/a_705_407# VSUBS 0.13654f
C777 1bitblock$4_0/a_3498_3# VSUBS 1.27913f
C778 1bitblock$4_0/a_10906_n37# VSUBS 0.02232f
C779 1bitblock$4_0/a_9800_n37# VSUBS 0.01742f
C780 1bitblock$4_0/a_9408_n37# VSUBS 0.01326f
C781 1bitblock$4_0/a_8160_n37# VSUBS 0.01743f
C782 1bitblock$4_0/a_7768_n37# VSUBS 0.01327f
C783 1bitblock$4_0/a_6520_n37# VSUBS 0.01743f
C784 1bitblock$4_0/a_6128_n37# VSUBS 0.01327f
C785 1bitblock$4_0/a_5042_n37# VSUBS 0.01422f
C786 1bitblock$4_0/a_4650_n37# VSUBS 0.01569f
C787 1bitblock$4_0/a_11922_3# VSUBS 0.64588f
C788 1bitblock$4_0/a_11922_391# VSUBS 0.00119f
C789 1bitblock$4_0/a_10906_466# VSUBS 0.59827f
C790 1bitblock$4_0/a_11480_63# VSUBS 0.42359f
C791 1bitblock$4_0/a_10363_63# VSUBS 0.13924f
C792 1bitblock$4_0/a_9050_63# VSUBS 0.55145f
C793 1bitblock$4_0/a_7410_63# VSUBS 0.55612f
C794 1bitblock$4_0/a_5768_63# VSUBS 0.55881f
C795 1bitblock$4_0/a_1845_n37# VSUBS 0.01974f
C796 1bitblock$4_0/a_1262_n37# VSUBS 0.0127f
C797 1bitblock$4_0/a_870_n37# VSUBS 0.01517f
C798 1bitblock$4_0/a_4290_63# VSUBS 0.59067f
C799 1bitblock$4_0/a_2861_3# VSUBS 0.62907f
C800 1bitblock$4_0/a_1845_466# VSUBS 0.5987f
C801 1bitblock$4_0/a_2419_63# VSUBS 6.63957f
C802 1bitblock$4_0/a_510_63# VSUBS 0.58009f
C803 1bitblock$4_0/a_378_271# VSUBS 1.3862f
C804 1bitblock$4_0/a_9609_407# VSUBS 0.11896f
C805 1bitblock$4_0/m2_24_342# VSUBS 1.9762f
C806 MUX21$1_0/m2_540_79# VSUBS 0.82007f
C807 MUX21$1_0/a_718_407# VSUBS 0.15145f
C808 MUX21$1_0/a_909_n37# VSUBS 0.01743f
C809 MUX21$1_0/a_517_n37# VSUBS 0.01327f
C810 MUX21$1_0/a_1472_63# VSUBS 0.17898f
C811 MUX21$1_0/a_157_63# VSUBS 0.65278f
C812 AND4$1_0/a_1120_n441# VSUBS 0.02626f
C813 AND4$1_0/a_912_n441# VSUBS 0.02949f
C814 AND4$1_0/a_704_n441# VSUBS 0.03642f
C815 m2_14516_n651# VSUBS 2.96054f
C816 AND4$1_0/a_518_229# VSUBS 0.81913f
C817 m1_12484_n953# VSUBS 3.35772f
C818 1bitblock$2$1_0/a_7083_63# VSUBS 0.85965f
C819 1bitblock$2$1_0/a_8723_63# VSUBS 0.40727f
C820 1bitblock$2$1_0/m2_9431_79# VSUBS 0.62602f
C821 1bitblock$2$1_0/m2_7791_79# VSUBS 0.61996f
C822 1bitblock$2$1_0/a_9609_407# VSUBS 0.11896f
C823 1bitblock$2$1_0/a_8361_407# VSUBS 0.05045f
C824 1bitblock$2$1_0/m2_6151_79# VSUBS 0.60126f
C825 1bitblock$2$1_0/a_6721_407# VSUBS 0.01523f
C826 1bitblock$2$1_0/a_5042_407# VSUBS 0.80196f
C827 1bitblock$2$1_0/a_3940_63# VSUBS 0.46875f
C828 m2_2396_n2595# VSUBS 3.96636f
C829 1bitblock$2$1_0/a_160_63# VSUBS 0.60571f
C830 1bitblock$2$1_0/a_5243_407# VSUBS 0.01459f
C831 1bitblock$2$1_0/a_705_407# VSUBS 0.14113f
C832 1bitblock$2$1_0/a_3498_3# VSUBS 1.27919f
C833 1bitblock$2$1_0/a_10906_n37# VSUBS 0.02232f
C834 1bitblock$2$1_0/a_9800_n37# VSUBS 0.01742f
C835 1bitblock$2$1_0/a_9408_n37# VSUBS 0.01326f
C836 1bitblock$2$1_0/a_8160_n37# VSUBS 0.01743f
C837 1bitblock$2$1_0/a_7768_n37# VSUBS 0.01327f
C838 1bitblock$2$1_0/a_6520_n37# VSUBS 0.01743f
C839 1bitblock$2$1_0/a_6128_n37# VSUBS 0.01327f
C840 1bitblock$2$1_0/a_5042_n37# VSUBS 0.01422f
C841 1bitblock$2$1_0/a_4650_n37# VSUBS 0.01569f
C842 1bitblock$2$1_0/a_11922_3# VSUBS 0.64587f
C843 1bitblock$2$1_0/a_11922_391# VSUBS 0.00119f
C844 1bitblock$2$1_0/a_10906_466# VSUBS 0.59833f
C845 1bitblock$2$1_0/a_11480_63# VSUBS 0.42359f
C846 1bitblock$2$1_0/a_10363_63# VSUBS 0.13924f
C847 1bitblock$2$1_0/a_9050_63# VSUBS 0.55151f
C848 1bitblock$2$1_0/a_7410_63# VSUBS 0.55618f
C849 1bitblock$2$1_0/a_5768_63# VSUBS 0.55887f
C850 1bitblock$2$1_0/a_1845_n37# VSUBS 0.01974f
C851 1bitblock$2$1_0/a_1262_n37# VSUBS 0.0127f
C852 1bitblock$2$1_0/a_870_n37# VSUBS 0.01586f
C853 1bitblock$2$1_0/a_4290_63# VSUBS 0.59072f
C854 1bitblock$2$1_0/a_2861_3# VSUBS 0.62907f
C855 1bitblock$2$1_0/a_1845_466# VSUBS 0.59875f
C856 1bitblock$2$1_0/a_2419_63# VSUBS 6.72858f
C857 1bitblock$2$1_0/a_510_63# VSUBS 0.58168f
C858 1bitblock$2$1_0/a_378_271# VSUBS 1.38936f
C859 1bitblock$2$1_0/m2_24_342# VSUBS 2.00127f
.ends

.subckt ALU VDD GND A0 B0 A1 B1 A2 B2 A3 B3 A4 B4 A5 B5 A6 B6 A7 B7 A8 B8 A9 B9 A10
+ B10 A11 B11 A12 B12 A13 B13 A14 B14 A15 B15 Cin S0 S1 F N Z Y0 Y1 Y2 Y3 Y4 Y5 Y6
+ Y7 Y8 Y9 Y10 Y11 Y12 Y13 Y14 Y15 BP3 BP0 BP2 BP1
X4bitblock_0 4bitblock_0/1bitblock$2_0/a_9609_407# 4bitblock_0/1bitblock$3_0/a_8361_407#
+ 4bitblock_0/1bitblock$2_0/a_8160_n37# 4bitblock_0/1bitblock$2_0/a_5042_407# 4bitblock_0/1bitblock_0/m2_6151_79#
+ 4bitblock_0/1bitblock$2_0/m2_9431_79# 4bitblock_0/1bitblock$2_0/a_4290_63# 4bitblock_0/1bitblock$2_0/a_4650_n37#
+ 4bitblock_0/1bitblock$3_0/a_8723_63# 4bitblock_0/1bitblock$3_0/a_510_63# 4bitblock_0/1bitblock_0/a_2419_63#
+ B3 4bitblock_0/1bitblock_0/a_5042_n37# 4bitblock_0/1bitblock$2_0/a_7410_63# 4bitblock_0/1bitblock$3_0/a_1845_466#
+ 4bitblock_0/MUX21_0/a_157_63# 4bitblock_0/1bitblock$2_0/a_5243_407# 4bitblock_0/1bitblock$1_0/a_3940_63#
+ 4bitblock_0/1bitblock_0/a_5042_407# 4bitblock_0/1bitblock_0/a_8160_n37# 4bitblock_0/1bitblock$2_0/a_7768_n37#
+ 4bitblock_0/1bitblock$2_0/a_10906_466# 4bitblock_0/1bitblock$3_0/a_6721_407# 4bitblock_0/1bitblock_0/m2_9431_79#
+ 4bitblock_0/1bitblock$3_0/a_11480_63# 4bitblock_0/1bitblock_0/a_4650_n37# 4bitblock_0/1bitblock$2_0/m2_7791_79#
+ 4bitblock_0/m2_10721_n3315# 4bitblock_0/1bitblock$3_0/a_3498_3# 4bitblock_0/1bitblock_0/a_3940_63#
+ 4bitblock_0/1bitblock$1_0/a_7083_63# 4bitblock_0/1bitblock$1_0/a_4290_63# 4bitblock_0/1bitblock$3_0/m2_6151_79#
+ Y2 4bitblock_0/1bitblock$1_0/a_8361_407# 4bitblock_0/1bitblock$2_0/a_8723_63# 4bitblock_0/1bitblock_0/a_7768_n37#
+ B2 4bitblock_0/MUX21_0/a_718_407# BP0 4bitblock_0/1bitblock$1_0/a_7410_63# 4bitblock_0/1bitblock$2_0/a_3498_3#
+ 4bitblock_0/1bitblock$2_0/a_7083_63# 4bitblock_0/MUX21_0/m2_540_79# 4bitblock_0/1bitblock$3_0/a_5042_n37#
+ 4bitblock_0/1bitblock_0/m2_7791_79# 4bitblock_0/1bitblock_0/a_4290_63# A2 4bitblock_0/1bitblock_0/a_7083_63#
+ 4bitblock_0/1bitblock$3_0/a_9609_407# 4bitblock_0/1bitblock$3_0/a_5768_63# 4bitblock_0/1bitblock$3_0/a_8160_n37#
+ 4bitblock_0/1bitblock$3_0/a_5042_407# Y0 S1 4bitblock_0/1bitblock$3_0/m2_9431_79#
+ 4bitblock_0/1bitblock_0/a_7410_63# 4bitblock_0/1bitblock$3_0/a_10906_466# 4bitblock_0/1bitblock$3_0/a_4650_n37#
+ 4bitblock_0/1bitblock$3_0/a_160_63# 4bitblock_0/1bitblock$1_0/a_8723_63# B1 4bitblock_0/1bitblock$1_0/a_3498_3#
+ 4bitblock_0/1bitblock$3_0/a_5243_407# 4bitblock_0/m2_1701_n784# 4bitblock_0/1bitblock$1_0/m2_6151_79#
+ 4bitblock_0/1bitblock$3_0/a_7768_n37# 4bitblock_0/1bitblock$3_0/a_11922_3# 4bitblock_0/1bitblock$3_0/a_2419_63#
+ 4bitblock_0/1bitblock$2_0/a_5768_63# 4bitblock_0/1bitblock_0/a_8723_63# 4bitblock_0/1bitblock$3_0/m2_7791_79#
+ B0 4bitblock_0/1bitblock$1_0/a_5042_n37# A0 Y3 4bitblock_0/1bitblock$1_0/a_9609_407#
+ 4bitblock_0/1bitblock$2_0/a_8361_407# 4bitblock_0/1bitblock$1_0/a_8160_n37# 4bitblock_0/1bitblock$1_0/a_5042_407#
+ 4bitblock_0/1bitblock$3_0/a_9050_63# 4bitblock_0/1bitblock$1_0/m2_9431_79# 4bitblock_0/AND4_0/a_518_229#
+ 4bitblock_0/1bitblock$1_0/a_4650_n37# 4bitblock_0/m1_14167_n1145# 4bitblock_0/AND4_0/a_704_n441#
+ 4bitblock_0/m1_12486_242# 4bitblock_0/1bitblock$3_0/a_3940_63# 4bitblock_0/1bitblock$2_0/a_11922_3#
+ 4bitblock_0/1bitblock$1_0/a_5243_407# 4bitblock_0/1bitblock_0/a_8361_407# 4bitblock_0/1bitblock$2_0/a_2419_63#
+ 4bitblock_0/1bitblock$1_0/a_5768_63# 4bitblock_0/1bitblock$1_0/a_7768_n37# 4bitblock_0/m1_12484_n953#
+ S0 4bitblock_0/1bitblock$3_0/a_4290_63# 4bitblock_0/1bitblock$1_0/m2_7791_79# 4bitblock_0/1bitblock$3_0/a_7083_63#
+ A1 A3 4bitblock_0/1bitblock$3_0/a_705_407# 4bitblock_0/m2_2396_n2595# 4bitblock_0/1bitblock_0/a_5768_63#
+ Y1 4bitblock_0/1bitblock$2_0/m2_6151_79# 4bitblock_0/1bitblock$1_0/a_10906_466#
+ 4bitblock_0/m1_12480_n3815# 4bitblock_0/1bitblock$3_0/a_2861_3# 4bitblock_0/1bitblock_0/a_3498_3#
+ m1_16451_n989# 4bitblock_0/1bitblock$3_0/a_7410_63# 4bitblock_0/1bitblock$2_0/a_3940_63#
+ VDD Cin 4bitblock_0/1bitblock$1_0/a_11922_3# 4bitblock_0/AND4_0/a_912_n441# 4bitblock_0/m1_13543_n1146#
+ 4bitblock_0/1bitblock$1_0/a_2419_63# 4bitblock_0/1bitblock$2_0/a_5042_n37# GND x4bitblock
XXOR$9_0 XOR$9_0/a_1262_n37# XOR$9_0/a_510_63# XOR$9_0/a_870_n37# XOR$9_0/a_160_63#
+ F XOR$9_0/a_705_407# F N GND m2_6320_n21444# VDD XOR$9
X4bitblock$2_0 4bitblock$2_0/1bitblock$5_0/m2_6151_79# 4bitblock$2_0/1bitblock$3$2_0/a_8160_n37#
+ 4bitblock$2_0/1bitblock$3$2_0/a_5042_407# 4bitblock$2_0/1bitblock$1$2_0/a_8361_407#
+ A10 4bitblock$2_0/1bitblock$3$2_0/m2_9431_79# 4bitblock$2_0/1bitblock$1$2_0/a_8723_63#
+ 4bitblock$2_0/1bitblock$3$2_0/a_4650_n37# B9 4bitblock$2_0/1bitblock$3$2_0/a_11922_3#
+ 4bitblock$2_0/1bitblock$2$2_0/m2_6151_79# 4bitblock$2_0/1bitblock$3$2_0/a_2419_63#
+ 4bitblock$2_0/1bitblock$5_0/a_5042_n37# 4bitblock$2_0/1bitblock$2$2_0/a_4290_63#
+ 4bitblock$2_0/1bitblock$3$2_0/a_2861_3# 4bitblock$2_0/1bitblock$5_0/a_9609_407#
+ 4bitblock$2_0/1bitblock$5_0/a_510_63# 4bitblock$2_0/1bitblock$3$2_0/a_5243_407#
+ 4bitblock$2_0/1bitblock$5_0/a_5042_407# 4bitblock$2_0/1bitblock$5_0/a_8160_n37#
+ 4bitblock$2_0/MUX21$2_0/a_909_n37# 4bitblock$2_0/1bitblock$2$2_0/a_7083_63# 4bitblock$2_0/1bitblock$3$2_0/a_7768_n37#
+ 4bitblock$2_0/1bitblock$5_0/a_11922_3# 4bitblock$2_0/1bitblock$2$2_0/a_7410_63#
+ 4bitblock$2_0/1bitblock$2$2_0/a_5042_n37# 4bitblock$2_0/1bitblock$3$2_0/a_9050_63#
+ 4bitblock$2_0/1bitblock$5_0/m2_9431_79# 4bitblock$2_0/1bitblock$5_0/a_2419_63# 4bitblock$2_0/1bitblock$5_0/a_4650_n37#
+ 4bitblock$2_0/1bitblock$2$2_0/a_9609_407# 4bitblock$2_0/1bitblock$2$2_0/a_5042_407#
+ 4bitblock$2_0/1bitblock$2$2_0/a_8160_n37# 4bitblock$2_0/1bitblock$3$2_0/m2_7791_79#
+ 4bitblock$2_0/1bitblock$2$2_0/m2_9431_79# 4bitblock$2_0/1bitblock$3$2_0/a_3940_63#
+ 4bitblock$2_0/1bitblock$5_0/a_5243_407# 4bitblock$2_0/1bitblock$5_0/a_9050_63# Y11
+ 4bitblock$2_0/1bitblock$2$2_0/a_4650_n37# 4bitblock$2_0/1bitblock$1$2_0/m2_6151_79#
+ 4bitblock$2_0/1bitblock$5_0/a_7768_n37# 4bitblock$2_0/MUX21$2_0/a_517_n37# 4bitblock$2_0/MUX21$2_0/a_718_407#
+ 4bitblock$2_0/1bitblock$3$2_0/a_510_63# 4bitblock$2_0/1bitblock$2$2_0/a_5243_407#
+ 4bitblock$2_0/1bitblock$2$2_0/a_8723_63# B10 4bitblock$2_0/1bitblock$5_0/a_3940_63#
+ 4bitblock$2_0/1bitblock$5_0/m2_7791_79# 4bitblock$2_0/1bitblock$2$2_0/a_7768_n37#
+ 4bitblock$2_0/1bitblock$1$2_0/a_5042_n37# 4bitblock$2_0/1bitblock$1$2_0/a_5768_63#
+ 4bitblock$2_0/1bitblock$3$2_0/a_4290_63# Y8 4bitblock$2_0/1bitblock$1$2_0/a_10906_466#
+ 4bitblock$2_0/1bitblock$1$2_0/a_9609_407# 4bitblock$2_0/1bitblock$3$2_0/a_705_407#
+ 4bitblock$2_0/1bitblock$1$2_0/a_8160_n37# 4bitblock$2_0/1bitblock$1$2_0/a_5042_407#
+ 4bitblock$2_0/1bitblock$2$2_0/m2_7791_79# 4bitblock$2_0/1bitblock$1$2_0/m2_9431_79#
+ 4bitblock$2_0/1bitblock$3$2_0/a_7410_63# 4bitblock$2_0/1bitblock$1$2_0/a_4650_n37#
+ 4bitblock$2_0/1bitblock$5_0/a_4290_63# Y10 4bitblock$2_0/1bitblock$2$2_0/a_3498_3#
+ 4bitblock$2_0/1bitblock$5_0/a_7083_63# 4bitblock$2_0/1bitblock$5_0/a_705_407# 4bitblock$2_0/1bitblock$1$2_0/a_5243_407#
+ 4bitblock$2_0/1bitblock$5_0/a_7410_63# 4bitblock$2_0/1bitblock$5_0/a_160_63# 4bitblock$2_0/1bitblock$1$2_0/a_7768_n37#
+ 4bitblock$2_0/1bitblock$1$2_0/a_11922_3# 4bitblock$2_0/1bitblock$1$2_0/a_2419_63#
+ 4bitblock$2_0/m1_12480_n3815# 4bitblock$2_0/1bitblock$3$2_0/a_10906_466# S1 4bitblock$2_0/AND4$2_0/a_518_229#
+ 4bitblock$2_0/1bitblock$3$2_0/a_8723_63# 4bitblock$2_0/MUX21$2_0/a_157_63# B11 4bitblock$2_0/1bitblock$1$2_0/m2_7791_79#
+ 4bitblock$2_0/1bitblock$2$2_0/a_5768_63# Y9 4bitblock$2_0/1bitblock$3$2_0/a_8361_407#
+ BP2 4bitblock$2_0/1bitblock$5_0/a_8723_63# 4bitblock$2_0/MUX21$2_0/m2_540_79# A9
+ B8 4bitblock$2_0/1bitblock$3$2_0/a_160_63# 4bitblock$2_0/1bitblock$1$2_0/a_3940_63#
+ 4bitblock$2_0/1bitblock$1$2_0/a_3498_3# 4bitblock$2_0/1bitblock$3$2_0/a_3498_3#
+ 4bitblock$2_0/1bitblock$3$2_0/a_1845_466# 4bitblock$2_0/m1_12486_242# 4bitblock$2_0/1bitblock$3$2_0/a_7083_63#
+ 4bitblock$2_0/1bitblock$5_0/a_8361_407# 4bitblock$2_0/m2_1701_n784# 4bitblock$2_0/1bitblock$5_0/a_3498_3#
+ 4bitblock$2_0/1bitblock$2$2_0/a_11922_3# 4bitblock$2_0/1bitblock$3$2_0/a_6721_407#
+ 4bitblock$2_0/1bitblock$3$2_0/a_11480_63# 4bitblock$2_0/1bitblock$2$2_0/a_2419_63#
+ A11 4bitblock$2_0/1bitblock$2$2_0/a_8361_407# 4bitblock$2_0/1bitblock$1$2_0/a_7083_63#
+ 4bitblock$2_0/1bitblock$1$2_0/a_4290_63# 4bitblock$2_0/m2_2396_n2595# 4bitblock$2_0/1bitblock$5_0/a_1845_466#
+ 4bitblock$2_0/1bitblock$3$2_0/m2_6151_79# 4bitblock$2_0/1bitblock$3$2_0/a_5768_63#
+ 4bitblock$2_0/1bitblock$1$2_0/a_7410_63# m2_16192_n18174# 4bitblock$2_0/m1_13543_n1146#
+ m1_16199_n12176# 4bitblock$2_0/1bitblock$5_0/a_6721_407# 4bitblock$2_0/1bitblock$5_0/a_11480_63#
+ A8 4bitblock$2_0/1bitblock$5_0/a_2861_3# VDD 4bitblock$2_0/1bitblock$5_0/a_870_n37#
+ 4bitblock$2_0/1bitblock$3$2_0/a_5042_n37# 4bitblock$2_0/1bitblock$5_0/a_10906_466#
+ 4bitblock$2_0/1bitblock$2$2_0/a_10906_466# 4bitblock$2_0/1bitblock$5_0/a_5768_63#
+ 4bitblock$2_0/1bitblock$2$2_0/a_3940_63# S0 4bitblock$2_0/m2_10721_n3315# GND 4bitblock$2_0/m1_12484_n953#
+ 4bitblock$2_0/m1_14167_n1145# 4bitblock$2_0/1bitblock$3$2_0/a_9609_407# x4bitblock$2
XAND4$4_0 BP1 GND BP0 Z VDD BP2 AND4$4_0/a_704_n441# BP3 AND4$4_0/a_912_n441# AND4$4_0/a_518_229#
+ AND4$4_0/a_1120_n441# AND4$4
X4bitblock_LAST_0 4bitblock_LAST_0/1bitblock$3$4_0/a_7410_63# 4bitblock_LAST_0/1bitblock$3$4_0/a_11922_391#
+ 4bitblock_LAST_0/1bitblock$7_0/a_4290_63# 4bitblock_LAST_0/1bitblock$7_0/a_705_407#
+ 4bitblock_LAST_0/1bitblock$7_0/m2_7791_79# 4bitblock_LAST_0/1bitblock$2$4_0/a_7768_n37#
+ A14 4bitblock_LAST_0/1bitblock$3$4_0/a_10906_466# 4bitblock_LAST_0/1bitblock$7_0/a_7410_63#
+ Y12 4bitblock_LAST_0/1bitblock$1$4_0/a_5042_407# 4bitblock_LAST_0/1bitblock$1$4_0/a_2419_63#
+ 4bitblock_LAST_0/1bitblock$2$4_0/m2_7791_79# 4bitblock_LAST_0/1bitblock$7_0/a_510_63#
+ 4bitblock_LAST_0/1bitblock$3$4_0/a_8723_63# Y14 B15 4bitblock_LAST_0/1bitblock$2$4_0/a_10906_n37#
+ 4bitblock_LAST_0/1bitblock$7_0/a_8723_63# B12 4bitblock_LAST_0/1bitblock$1$4_0/m2_7791_79#
+ Y13 4bitblock_LAST_0/1bitblock$3$4_0/a_8361_407# 4bitblock_LAST_0/1bitblock$3$4_0/a_6520_n37#
+ 4bitblock_LAST_0/1bitblock$2$4_0/a_11922_3# 4bitblock_LAST_0/1bitblock$7_0/a_3498_3#
+ 4bitblock_LAST_0/1bitblock$2$4_0/a_2419_63# 4bitblock_LAST_0/1bitblock$1$4_0/a_7083_63#
+ A15 4bitblock_LAST_0/1bitblock$3$4_0/a_5768_63# 4bitblock_LAST_0/1bitblock$2$4_0/a_9050_63#
+ m1_17438_n9725# 4bitblock_LAST_0/1bitblock$7_0/a_8361_407# 4bitblock_LAST_0/1bitblock$7_0/a_10906_466#
+ 4bitblock_LAST_0/1bitblock$2$4_0/a_10906_466# 4bitblock_LAST_0/1bitblock$7_0/a_870_n37#
+ 4bitblock_LAST_0/1bitblock$3$4_0/a_9800_n37# 4bitblock_LAST_0/1bitblock$3$4_0/a_6721_407#
+ 4bitblock_LAST_0/1bitblock$3$4_0/a_11480_63# 4bitblock_LAST_0/1bitblock$3$4_0/a_6128_n37#
+ 4bitblock_LAST_0/1bitblock$7_0/a_160_63# 4bitblock_LAST_0/1bitblock$7_0/a_5768_63#
+ 4bitblock_LAST_0/1bitblock$7_0/a_1845_466# 4bitblock_LAST_0/1bitblock$3$4_0/m2_6151_79#
+ 4bitblock_LAST_0/1bitblock$1$4_0/a_8723_63# 4bitblock_LAST_0/MUX21$4_0/a_157_63#
+ 4bitblock_LAST_0/1bitblock$2$4_0/a_3498_3# B13 4bitblock_LAST_0/1bitblock$3$4_0/a_11922_3#
+ 4bitblock_LAST_0/1bitblock$7_0/a_6721_407# m2_16192_n18174# 4bitblock_LAST_0/1bitblock$7_0/a_7083_63#
+ 4bitblock_LAST_0/1bitblock$7_0/a_11480_63# 4bitblock_LAST_0/1bitblock$3$4_0/a_2419_63#
+ 4bitblock_LAST_0/1bitblock$2$4_0/a_7083_63# m1_17790_n9717# 4bitblock_LAST_0/1bitblock$3$4_0/a_9408_n37#
+ 4bitblock_LAST_0/1bitblock$2$4_0/a_9800_n37# 4bitblock_LAST_0/m1_14167_n1145# 4bitblock_LAST_0/MUX21$4_0/a_909_n37#
+ 4bitblock_LAST_0/1bitblock$2$4_0/a_11480_63# 4bitblock_LAST_0/1bitblock$7_0/a_11922_3#
+ 4bitblock_LAST_0/1bitblock$3$4_0/a_9609_407# 4bitblock_LAST_0/1bitblock$3$4_0/a_8160_n37#
+ 4bitblock_LAST_0/1bitblock$7_0/m2_6151_79# 4bitblock_LAST_0/1bitblock$3$4_0/a_9050_63#
+ 4bitblock_LAST_0/1bitblock$2$4_0/a_7410_63# A13 S1 4bitblock_LAST_0/1bitblock$7_0/a_2419_63#
+ 4bitblock_LAST_0/1bitblock$3$4_0/m2_9431_79# 4bitblock_LAST_0/m2_2396_n2595# 4bitblock_LAST_0/1bitblock$3$4_0/a_10906_n37#
+ 4bitblock_LAST_0/1bitblock$3$4_0/a_5243_407# 4bitblock_LAST_0/1bitblock$2$4_0/m2_6151_79#
+ 4bitblock_LAST_0/m2_1701_n784# 4bitblock_LAST_0/1bitblock$7_0/a_9050_63# m2_6320_n21444#
+ 4bitblock_LAST_0/1bitblock$7_0/a_9609_407# 4bitblock_LAST_0/MUX21$4_0/a_517_n37#
+ 4bitblock_LAST_0/1bitblock$7_0/a_5042_407# S0 A12 4bitblock_LAST_0/MUX21$4_0/a_718_407#
+ 4bitblock_LAST_0/1bitblock$3$4_0/a_7768_n37# 4bitblock_LAST_0/m1_13543_n1146# 4bitblock_LAST_0/1bitblock$7_0/m2_9431_79#
+ 4bitblock_LAST_0/1bitblock$2$4_0/a_8723_63# 4bitblock_LAST_0/1bitblock$2$4_0/a_9408_n37#
+ 4bitblock_LAST_0/m1_12486_242# B14 4bitblock_LAST_0/1bitblock$3$4_0/a_3498_3# 4bitblock_LAST_0/MUX21$4_0/m2_540_79#
+ 4bitblock_LAST_0/1bitblock$7_0/a_3940_63# BP3 4bitblock_LAST_0/1bitblock$2$4_0/a_8160_n37#
+ 4bitblock_LAST_0/1bitblock$3$4_0/m2_7791_79# 4bitblock_LAST_0/1bitblock$3$4_0/a_7083_63#
+ VDD 4bitblock_LAST_0/AND4$5_0/a_518_229# 4bitblock_LAST_0/1bitblock$2$4_0/m2_9431_79#
+ 4bitblock_LAST_0/1bitblock$7_0/a_5243_407# 4bitblock_LAST_0/m1_12484_n953# 4bitblock_LAST_0/1bitblock$7_0/a_2861_3#
+ Y15 GND 4bitblock_LAST_0/m1_12480_n3815# x4bitblock_LAST
XXOR$8_0 XOR$8_0/a_1262_n37# XOR$8_0/a_510_63# XOR$8_0/a_870_n37# m1_17438_n9725#
+ m1_18541_n9769# XOR$8_0/a_705_407# m1_18541_n9769# F m1_17438_n9725# GND m1_17790_n9717#
+ VDD XOR$8
X4bitblock$1_0 Y4 4bitblock$1_0/1bitblock$1$1_0/a_9609_407# 4bitblock$1_0/1bitblock$1$1_0/a_5042_407#
+ 4bitblock$1_0/1bitblock$1$1_0/a_8160_n37# 4bitblock$1_0/1bitblock$2$1_0/a_2419_63#
+ 4bitblock$1_0/1bitblock$1$1_0/a_4290_63# 4bitblock$1_0/1bitblock$2$1_0/m2_7791_79#
+ 4bitblock$1_0/1bitblock$1$1_0/m2_9431_79# Y6 4bitblock$1_0/1bitblock$1$1_0/a_4650_n37#
+ 4bitblock$1_0/1bitblock$3$1_0/a_5768_63# 4bitblock$1_0/1bitblock$1$1_0/a_7410_63#
+ 4bitblock$1_0/1bitblock$3$1_0/a_2861_3# 4bitblock$1_0/1bitblock$4_0/a_510_63# m1_16199_n12176#
+ 4bitblock$1_0/1bitblock$1$1_0/a_5243_407# A5 4bitblock$1_0/1bitblock$4_0/a_870_n37#
+ 4bitblock$1_0/1bitblock$1$1_0/a_7768_n37# 4bitblock$1_0/1bitblock$4_0/a_5768_63#
+ 4bitblock$1_0/1bitblock$2$1_0/a_3940_63# 4bitblock$1_0/1bitblock$1$1_0/m2_7791_79#
+ 4bitblock$1_0/1bitblock$1$1_0/a_8723_63# Y5 B5 4bitblock$1_0/1bitblock$3$1_0/a_11922_3#
+ 4bitblock$1_0/1bitblock$3$1_0/a_8361_407# 4bitblock$1_0/1bitblock$3$1_0/a_510_63#
+ 4bitblock$1_0/1bitblock$1$1_0/a_7083_63# 4bitblock$1_0/1bitblock$3$1_0/a_2419_63#
+ 4bitblock$1_0/1bitblock$2$1_0/a_4290_63# 4bitblock$1_0/1bitblock$3$1_0/a_10906_466#
+ 4bitblock$1_0/MUX21$1_0/a_909_n37# BP1 4bitblock$1_0/1bitblock$4_0/a_11922_3# 4bitblock$1_0/1bitblock$2$1_0/a_7410_63#
+ 4bitblock$1_0/1bitblock$3$1_0/a_9050_63# 4bitblock$1_0/1bitblock$3$1_0/a_1845_466#
+ 4bitblock$1_0/1bitblock$4_0/a_2419_63# 4bitblock$1_0/1bitblock$4_0/a_8361_407# 4bitblock$1_0/m2_10721_n3315#
+ 4bitblock$1_0/1bitblock$3$1_0/a_6721_407# 4bitblock$1_0/1bitblock$3$1_0/a_11480_63#
+ 4bitblock$1_0/1bitblock$3$1_0/a_3498_3# 4bitblock$1_0/1bitblock$3$1_0/a_3940_63#
+ 4bitblock$1_0/1bitblock$4_0/a_9050_63# 4bitblock$1_0/1bitblock$2$1_0/a_8361_407#
+ 4bitblock$1_0/MUX21$1_0/a_517_n37# 4bitblock$1_0/1bitblock$4_0/a_1845_466# A6 4bitblock$1_0/MUX21$1_0/a_718_407#
+ 4bitblock$1_0/1bitblock$4_0/a_160_63# 4bitblock$1_0/1bitblock$3$1_0/m2_6151_79#
+ 4bitblock$1_0/1bitblock$2$1_0/a_8723_63# B6 4bitblock$1_0/MUX21$1_0/m2_540_79# 4bitblock$1_0/1bitblock$4_0/a_3940_63#
+ 4bitblock$1_0/1bitblock$4_0/a_6721_407# m1_16451_n989# 4bitblock$1_0/1bitblock$1$1_0/a_5768_63#
+ 4bitblock$1_0/1bitblock$4_0/a_11480_63# 4bitblock$1_0/1bitblock$3$1_0/a_7083_63#
+ 4bitblock$1_0/1bitblock$3$1_0/a_4290_63# VDD A4 4bitblock$1_0/MUX21$1_0/a_157_63#
+ 4bitblock$1_0/1bitblock$3$1_0/a_705_407# 4bitblock$1_0/1bitblock$3$1_0/a_5042_n37#
+ 4bitblock$1_0/m1_12484_n953# 4bitblock$1_0/1bitblock$3$1_0/a_7410_63# 4bitblock$1_0/1bitblock$3$1_0/a_9609_407#
+ 4bitblock$1_0/1bitblock$4_0/m2_6151_79# 4bitblock$1_0/1bitblock$1$1_0/a_8361_407#
+ 4bitblock$1_0/1bitblock$3$1_0/a_8160_n37# 4bitblock$1_0/1bitblock$3$1_0/a_5042_407#
+ 4bitblock$1_0/1bitblock$4_0/a_4290_63# S1 4bitblock$1_0/1bitblock$3$1_0/m2_9431_79#
+ 4bitblock$1_0/1bitblock$3$1_0/a_160_63# 4bitblock$1_0/1bitblock$4_0/a_705_407# 4bitblock$1_0/1bitblock$3$1_0/a_4650_n37#
+ 4bitblock$1_0/m2_2396_n2595# 4bitblock$1_0/1bitblock$4_0/a_10906_466# 4bitblock$1_0/1bitblock$2$1_0/m2_6151_79#
+ 4bitblock$1_0/1bitblock$1$1_0/a_3498_3# S0 4bitblock$1_0/1bitblock$4_0/a_5042_n37#
+ 4bitblock$1_0/1bitblock$4_0/a_7410_63# 4bitblock$1_0/1bitblock$1$1_0/a_2419_63#
+ 4bitblock$1_0/1bitblock$3$1_0/a_5243_407# 4bitblock$1_0/1bitblock$4_0/a_9609_407#
+ 4bitblock$1_0/m1_12480_n3815# 4bitblock$1_0/1bitblock$4_0/a_8160_n37# 4bitblock$1_0/1bitblock$4_0/a_5042_407#
+ 4bitblock$1_0/AND4$1_0/a_518_229# 4bitblock$1_0/1bitblock$3$1_0/a_7768_n37# 4bitblock$1_0/1bitblock$2$1_0/a_5042_n37#
+ 4bitblock$1_0/1bitblock$3$1_0/a_8723_63# 4bitblock$1_0/1bitblock$4_0/m2_9431_79#
+ B7 4bitblock$1_0/1bitblock$4_0/a_4650_n37# 4bitblock$1_0/1bitblock$2$1_0/a_9609_407#
+ 4bitblock$1_0/1bitblock$2$1_0/a_5768_63# 4bitblock$1_0/1bitblock$2$1_0/a_5042_407#
+ 4bitblock$1_0/1bitblock$2$1_0/a_8160_n37# A7 4bitblock$1_0/1bitblock$3$1_0/m2_7791_79#
+ 4bitblock$1_0/1bitblock$2$1_0/a_3498_3# 4bitblock$1_0/1bitblock$2$1_0/m2_9431_79#
+ 4bitblock$1_0/1bitblock$4_0/a_8723_63# 4bitblock$1_0/1bitblock$4_0/a_7083_63# 4bitblock$1_0/1bitblock$2$1_0/a_7083_63#
+ 4bitblock$1_0/1bitblock$2$1_0/a_4650_n37# 4bitblock$1_0/1bitblock$4_0/a_5243_407#
+ Y7 4bitblock$1_0/m2_1701_n784# B4 4bitblock$1_0/1bitblock$1$1_0/m2_6151_79# 4bitblock$1_0/m1_13543_n1146#
+ 4bitblock$1_0/1bitblock$4_0/a_7768_n37# 4bitblock$1_0/1bitblock$1$1_0/a_3940_63#
+ 4bitblock$1_0/1bitblock$4_0/a_2861_3# 4bitblock$1_0/m1_12486_242# 4bitblock$1_0/1bitblock$2$1_0/a_5243_407#
+ 4bitblock$1_0/1bitblock$4_0/a_3498_3# 4bitblock$1_0/1bitblock$4_0/m2_7791_79# 4bitblock$1_0/m1_14167_n1145#
+ 4bitblock$1_0/1bitblock$2$1_0/a_7768_n37# 4bitblock$1_0/1bitblock$1$1_0/a_5042_n37#
+ GND x4bitblock$1
X0 4bitblock_LAST_0/1bitblock$3$4_0/a_7768_n37# S0.t70 GND GND nfet_03v3 ad=0.3625p pd=1.725u as=0.54p ps=3.08u w=0 l=0
X1 4bitblock$2_0/1bitblock$1$2_0/a_9050_63# S1.t30 VDD VDD pfet_03v3 ad=0.64p pd=3.28u as=0.48p ps=2.96u w=0 l=0
X2 4bitblock_LAST_0/1bitblock$7_0/a_5768_63# S0.t82 VDD VDD pfet_03v3 ad=0.65p pd=3.3u as=0.635p ps=3.27u w=0 l=0
X3 AND4$4_0/a_518_229# BP2.t4 VDD VDD pfet_03v3 ad=0.38p pd=1.76u as=0.38p ps=1.76u w=0 l=0
X4 4bitblock_0/1bitblock_0/a_870_n37# B0.t5 GND GND nfet_03v3 ad=0.3625p pd=1.725u as=0.54p ps=3.08u w=0 l=0
X5 4bitblock$1_0/1bitblock$3$1_0/m2_7791_79# S0.t127 4bitblock$1_0/1bitblock$3$1_0/a_8361_407# VDD pfet_03v3 ad=0.725p pd=2.725u as=1.09p ps=5.09u w=0 l=0
X6 4bitblock_0/1bitblock$3_0/a_160_63# A3.t1 GND GND nfet_03v3 ad=0.315p pd=2.26u as=0.325p ps=2.3u w=0 l=0
X7 4bitblock_LAST_0/m1_13543_n1146# A15.t3 4bitblock_LAST_0/1bitblock$3$4_0/a_870_n37# GND nfet_03v3 ad=0.3375p pd=1.675u as=0.3625p ps=1.725u w=0 l=0
X8 4bitblock_0/1bitblock$1_0/a_6128_n37# S0.t27 GND GND nfet_03v3 ad=0.3625p pd=1.725u as=0.54p ps=3.08u w=0 l=0
X9 4bitblock_0/1bitblock_0/a_9408_n37# S1.t9 GND GND nfet_03v3 ad=0.3625p pd=1.725u as=0.54p ps=3.08u w=0 l=0
X10 4bitblock$1_0/1bitblock$4_0/a_9408_n37# S1.t53 GND GND nfet_03v3 ad=0.3625p pd=1.725u as=0.54p ps=3.08u w=0 l=0
X11 4bitblock$1_0/1bitblock$3$1_0/a_705_407# A7.t4 VDD VDD pfet_03v3 ad=0.675p pd=2.675u as=0.725p ps=2.725u w=0 l=0
X12 VDD A15.t5 4bitblock_LAST_0/1bitblock$3$4_0/a_1845_466# VDD pfet_03v3 ad=0.735p pd=2.47u as=0.42p ps=1.84u w=0 l=0
X13 4bitblock_0/1bitblock_0/a_4290_63# Cin.t7 VDD VDD pfet_03v3 ad=0.65p pd=3.3u as=0.56p ps=3.12u w=0 l=0
X14 4bitblock$1_0/1bitblock$4_0/a_5768_63# S0.t104 GND GND nfet_03v3 ad=0.315p pd=2.26u as=0.3175p ps=2.27u w=0 l=0
X15 4bitblock$1_0/1bitblock$3$1_0/a_7410_63# S0.t124 VDD VDD pfet_03v3 ad=0.64p pd=3.28u as=0.48p ps=2.96u w=0 l=0
X16 4bitblock_LAST_0/1bitblock$3$4_0/a_510_63# B15.t3 GND GND nfet_03v3 ad=0.315p pd=2.26u as=0.28p ps=2.12u w=0 l=0
X17 4bitblock_LAST_0/MUX21$4_0/a_517_n37# BP3.t3 GND GND nfet_03v3 ad=0.3625p pd=1.725u as=0.54p ps=3.08u w=0 l=0
X18 4bitblock$1_0/1bitblock$1$1_0/a_7410_63# S0.t113 GND GND nfet_03v3 ad=0.31p pd=2.24u as=0.24p ps=1.96u w=0 l=0
X19 4bitblock$2_0/1bitblock$2$2_0/a_6128_n37# S0.t43 GND GND nfet_03v3 ad=0.3625p pd=1.725u as=0.54p ps=3.08u w=0 l=0
X20 4bitblock_0/1bitblock$3_0/a_870_n37# B3.t5 GND GND nfet_03v3 ad=0.3625p pd=1.725u as=0.54p ps=3.08u w=0 l=0
X21 4bitblock_0/1bitblock_0/m2_7791_79# S0.t23 4bitblock_0/1bitblock_0/a_8361_407# VDD pfet_03v3 ad=0.725p pd=2.725u as=1.09p ps=5.09u w=0 l=0
X22 4bitblock$2_0/1bitblock$1$2_0/a_160_63# A9.t2 VDD VDD pfet_03v3 ad=0.63p pd=3.26u as=0.65p ps=3.3u w=0 l=0
X23 XOR$9_0/a_160_63# F.t0 GND GND nfet_03v3 ad=0.315p pd=2.26u as=0.325p ps=2.3u w=0 l=0
X24 4bitblock_LAST_0/1bitblock$1$4_0/m2_6151_79# S0.t93 4bitblock_LAST_0/1bitblock$1$4_0/a_6721_407# VDD pfet_03v3 ad=0.725p pd=2.725u as=1.09p ps=5.09u w=0 l=0
X25 4bitblock_LAST_0/1bitblock$3$4_0/a_160_63# A15.t1 GND GND nfet_03v3 ad=0.315p pd=2.26u as=0.325p ps=2.3u w=0 l=0
X26 4bitblock$2_0/1bitblock$2$2_0/a_7768_n37# S0.t46 GND GND nfet_03v3 ad=0.3625p pd=1.725u as=0.54p ps=3.08u w=0 l=0
X27 4bitblock_0/1bitblock$3_0/a_1845_466# A3.t0 4bitblock_0/1bitblock$3_0/a_1845_n37# GND nfet_03v3 ad=0.65p pd=3.3u as=0.42p ps=1.84u w=0 l=0
X28 4bitblock$2_0/m2_2396_n2595# A10.t3 4bitblock$2_0/1bitblock$2$2_0/a_870_n37# GND nfet_03v3 ad=0.3375p pd=1.675u as=0.3625p ps=1.725u w=0 l=0
X29 4bitblock$1_0/1bitblock$2$1_0/a_1845_466# B6.t1 VDD VDD pfet_03v3 ad=0.42p pd=1.84u as=0.65p ps=3.3u w=0 l=0
X30 4bitblock_LAST_0/1bitblock$1$4_0/m2_7791_79# S0.t95 4bitblock_LAST_0/1bitblock$1$4_0/a_8361_407# VDD pfet_03v3 ad=0.725p pd=2.725u as=1.09p ps=5.09u w=0 l=0
X31 4bitblock$1_0/1bitblock$3$1_0/a_7410_63# S0.t121 GND GND nfet_03v3 ad=0.31p pd=2.24u as=0.24p ps=1.96u w=0 l=0
X32 VDD A10.t5 4bitblock$2_0/1bitblock$2$2_0/a_1845_466# VDD pfet_03v3 ad=0.735p pd=2.47u as=0.42p ps=1.84u w=0 l=0
X33 VDD 4bitblock_0/m1_14167_n1145# 4bitblock_0/1bitblock_0/a_10906_466# VDD.t10 pfet_03v3 ad=0.735p pd=2.47u as=0.42p ps=1.84u w=0 l=0
X34 4bitblock_LAST_0/1bitblock$1$4_0/a_705_407# A13.t4 VDD VDD pfet_03v3 ad=0.675p pd=2.675u as=0.725p ps=2.725u w=0 l=0
X35 4bitblock_LAST_0/1bitblock$1$4_0/a_7410_63# S0.t92 VDD VDD pfet_03v3 ad=0.64p pd=3.28u as=0.48p ps=2.96u w=0 l=0
X36 4bitblock$2_0/1bitblock$1$2_0/a_510_63# B9.t2 VDD VDD pfet_03v3 ad=0.65p pd=3.3u as=0.56p ps=3.12u w=0 l=0
X37 4bitblock_0/1bitblock$2_0/m2_6151_79# S0.t5 4bitblock_0/1bitblock$2_0/a_6721_407# VDD pfet_03v3 ad=0.725p pd=2.725u as=1.09p ps=5.09u w=0 l=0
X38 4bitblock_0/1bitblock_0/m2_6151_79# S0.t21 4bitblock_0/1bitblock_0/a_6721_407# VDD pfet_03v3 ad=0.725p pd=2.725u as=1.09p ps=5.09u w=0 l=0
X39 4bitblock$1_0/1bitblock$4_0/a_160_63# A4.t1 GND GND nfet_03v3 ad=0.315p pd=2.26u as=0.325p ps=2.3u w=0 l=0
X40 4bitblock_0/1bitblock$1_0/a_1845_466# B1.t1 VDD VDD pfet_03v3 ad=0.42p pd=1.84u as=0.65p ps=3.3u w=0 l=0
X41 VDD B11.t0 4bitblock$2_0/1bitblock$3$2_0/a_705_407# VDD pfet_03v3 ad=0.725p pd=2.725u as=1.09p ps=5.09u w=0 l=0
X42 VDD B6.t0 4bitblock$1_0/1bitblock$2$1_0/a_705_407# VDD pfet_03v3 ad=0.725p pd=2.725u as=1.09p ps=5.09u w=0 l=0
X43 4bitblock_LAST_0/1bitblock$7_0/a_5768_63# S0.t80 GND GND nfet_03v3 ad=0.315p pd=2.26u as=0.3175p ps=2.27u w=0 l=0
X44 4bitblock_LAST_0/1bitblock$3$4_0/m2_6151_79# S0.t69 4bitblock_LAST_0/1bitblock$3$4_0/a_6721_407# VDD pfet_03v3 ad=0.725p pd=2.725u as=1.09p ps=5.09u w=0 l=0
X45 GND 4bitblock_0/1bitblock_0/a_2419_63# 4bitblock_0/1bitblock_0/a_2861_3# GND.t4 nfet_03v3 ad=0.315p pd=2.26u as=0.18125p ps=1.225u w=0 l=0
X46 4bitblock_0/1bitblock$2_0/a_9050_63# S1.t2 VDD VDD pfet_03v3 ad=0.64p pd=3.28u as=0.48p ps=2.96u w=0 l=0
X47 4bitblock$2_0/1bitblock$1$2_0/a_7410_63# S0.t57 GND GND nfet_03v3 ad=0.31p pd=2.24u as=0.24p ps=1.96u w=0 l=0
X48 4bitblock_0/1bitblock$2_0/m2_9431_79# S1.t3 4bitblock_0/1bitblock$2_0/a_9609_407# VDD pfet_03v3 ad=0.725p pd=2.725u as=1.09p ps=5.09u w=0 l=0
X49 4bitblock$1_0/1bitblock$4_0/m2_6151_79# S0.t109 4bitblock$1_0/1bitblock$4_0/a_6721_407# VDD pfet_03v3 ad=0.725p pd=2.725u as=1.09p ps=5.09u w=0 l=0
X50 4bitblock_LAST_0/1bitblock$3$4_0/m2_7791_79# S0.t71 4bitblock_LAST_0/1bitblock$3$4_0/a_8361_407# VDD pfet_03v3 ad=0.725p pd=2.725u as=1.09p ps=5.09u w=0 l=0
X51 4bitblock_LAST_0/1bitblock$1$4_0/a_1845_466# A13.t0 4bitblock_LAST_0/1bitblock$1$4_0/a_1845_n37# GND nfet_03v3 ad=0.65p pd=3.3u as=0.42p ps=1.84u w=0 l=0
X52 4bitblock$2_0/1bitblock$3$2_0/a_1845_n37# B11.t4 GND GND nfet_03v3 ad=0.42p pd=1.84u as=0.63p ps=3.26u w=0 l=0
X53 4bitblock_0/1bitblock_0/a_10906_466# 4bitblock_0/m1_14167_n1145# 4bitblock_0/1bitblock_0/a_10906_n37# GND.t9 nfet_03v3 ad=0.65p pd=3.3u as=0.42p ps=1.84u w=0 l=0
X54 4bitblock_LAST_0/1bitblock$3$4_0/a_705_407# A15.t4 VDD VDD pfet_03v3 ad=0.675p pd=2.675u as=0.725p ps=2.725u w=0 l=0
X55 4bitblock_LAST_0/1bitblock$3$4_0/a_7410_63# S0.t68 VDD VDD pfet_03v3 ad=0.64p pd=3.28u as=0.48p ps=2.96u w=0 l=0
X56 4bitblock_LAST_0/1bitblock$3$4_0/a_9408_n37# S1.t33 GND GND nfet_03v3 ad=0.3625p pd=1.725u as=0.54p ps=3.08u w=0 l=0
X57 4bitblock$1_0/1bitblock$4_0/a_9050_63# S1.t54 VDD VDD pfet_03v3 ad=0.64p pd=3.28u as=0.48p ps=2.96u w=0 l=0
X58 AND4$4_0/a_518_229# BP0.t5 VDD VDD pfet_03v3 ad=0.55p pd=3.1u as=0.38p ps=1.76u w=0 l=0
X59 AND4$4_0/a_1120_n441# BP1.t1 AND4$4_0/a_912_n441# GND nfet_03v3 ad=0.76p pd=2.76u as=0.76p ps=2.76u w=0 l=0
X60 4bitblock$1_0/1bitblock$3$1_0/m2_9431_79# S1.t63 4bitblock$1_0/1bitblock$3$1_0/a_9609_407# VDD pfet_03v3 ad=0.725p pd=2.725u as=1.09p ps=5.09u w=0 l=0
X61 4bitblock$1_0/1bitblock$4_0/m2_9431_79# S1.t55 4bitblock$1_0/1bitblock$4_0/a_9609_407# VDD pfet_03v3 ad=0.725p pd=2.725u as=1.09p ps=5.09u w=0 l=0
X62 4bitblock$2_0/1bitblock$3$2_0/a_1845_466# A11.t0 4bitblock$2_0/1bitblock$3$2_0/a_1845_n37# GND nfet_03v3 ad=0.65p pd=3.3u as=0.42p ps=1.84u w=0 l=0
X63 VDD B3.t0 4bitblock_0/1bitblock$3_0/a_705_407# VDD pfet_03v3 ad=0.725p pd=2.725u as=1.09p ps=5.09u w=0 l=0
X64 4bitblock$1_0/1bitblock$1$1_0/a_160_63# A5.t1 GND GND nfet_03v3 ad=0.315p pd=2.26u as=0.325p ps=2.3u w=0 l=0
X65 4bitblock_LAST_0/1bitblock$2$4_0/a_1845_n37# B14.t4 GND GND nfet_03v3 ad=0.42p pd=1.84u as=0.63p ps=3.26u w=0 l=0
X66 4bitblock$2_0/1bitblock$1$2_0/a_870_n37# B9.t5 GND GND nfet_03v3 ad=0.3625p pd=1.725u as=0.54p ps=3.08u w=0 l=0
X67 4bitblock$2_0/1bitblock$2$2_0/m2_6151_79# S0.t45 4bitblock$2_0/1bitblock$2$2_0/a_6721_407# VDD pfet_03v3 ad=0.725p pd=2.725u as=1.09p ps=5.09u w=0 l=0
X68 4bitblock$1_0/MUX21$1_0/m2_540_79# BP1.t4 4bitblock$1_0/MUX21$1_0/a_718_407# VDD pfet_03v3 ad=0.725p pd=2.725u as=1.09p ps=5.09u w=0 l=0
X69 4bitblock$2_0/1bitblock$3$2_0/a_5768_63# S0.t34 VDD VDD pfet_03v3 ad=0.65p pd=3.3u as=0.635p ps=3.27u w=0 l=0
X70 4bitblock$1_0/1bitblock$1$1_0/a_510_63# B5.t3 GND GND nfet_03v3 ad=0.315p pd=2.26u as=0.28p ps=2.12u w=0 l=0
X71 GND 4bitblock_0/1bitblock_0/a_2419_63# 4bitblock_0/1bitblock_0/a_11922_3# GND.t1 nfet_03v3 ad=0.315p pd=2.26u as=0.18125p ps=1.225u w=0 l=0
X72 4bitblock_0/1bitblock_0/a_10906_466# Cin.t2 VDD VDD pfet_03v3 ad=0.42p pd=1.84u as=0.65p ps=3.3u w=0 l=0
X73 4bitblock_LAST_0/1bitblock$7_0/a_6128_n37# S0.t83 GND GND nfet_03v3 ad=0.3625p pd=1.725u as=0.54p ps=3.08u w=0 l=0
X74 4bitblock_0/1bitblock$3_0/a_7410_63# S0.t12 VDD VDD pfet_03v3 ad=0.64p pd=3.28u as=0.48p ps=2.96u w=0 l=0
X75 4bitblock_LAST_0/1bitblock$2$4_0/a_5768_63# S0.t74 VDD VDD pfet_03v3 ad=0.65p pd=3.3u as=0.635p ps=3.27u w=0 l=0
X76 4bitblock_0/1bitblock$1_0/m2_6151_79# S0.t29 4bitblock_0/1bitblock$1_0/a_6721_407# VDD pfet_03v3 ad=0.725p pd=2.725u as=1.09p ps=5.09u w=0 l=0
X77 4bitblock_0/1bitblock$2_0/a_870_n37# B2.t5 GND GND nfet_03v3 ad=0.3625p pd=1.725u as=0.54p ps=3.08u w=0 l=0
X78 4bitblock$2_0/1bitblock$2$2_0/m2_7791_79# S0.t47 4bitblock$2_0/1bitblock$2$2_0/a_8361_407# VDD pfet_03v3 ad=0.725p pd=2.725u as=1.09p ps=5.09u w=0 l=0
X79 4bitblock$2_0/1bitblock$2$2_0/a_9408_n37# S1.t21 GND GND nfet_03v3 ad=0.3625p pd=1.725u as=0.54p ps=3.08u w=0 l=0
X80 4bitblock$2_0/1bitblock$5_0/a_1845_n37# B8.t4 GND GND nfet_03v3 ad=0.42p pd=1.84u as=0.63p ps=3.26u w=0 l=0
X81 4bitblock$2_0/1bitblock$2$2_0/a_705_407# A10.t4 VDD VDD pfet_03v3 ad=0.675p pd=2.675u as=0.725p ps=2.725u w=0 l=0
X82 VDD B5.t0 4bitblock$1_0/1bitblock$1$1_0/a_705_407# VDD pfet_03v3 ad=0.725p pd=2.725u as=1.09p ps=5.09u w=0 l=0
X83 4bitblock_LAST_0/1bitblock$1$4_0/m2_9431_79# S1.t47 4bitblock_LAST_0/1bitblock$1$4_0/a_9609_407# VDD pfet_03v3 ad=0.725p pd=2.725u as=1.09p ps=5.09u w=0 l=0
X84 4bitblock_LAST_0/1bitblock$7_0/a_7768_n37# S0.t86 GND GND nfet_03v3 ad=0.3625p pd=1.725u as=0.54p ps=3.08u w=0 l=0
X85 4bitblock$2_0/1bitblock$1$2_0/a_1845_466# B9.t1 VDD VDD pfet_03v3 ad=0.42p pd=1.84u as=0.65p ps=3.3u w=0 l=0
X86 4bitblock_0/1bitblock$2_0/a_1845_466# A2.t0 4bitblock_0/1bitblock$2_0/a_1845_n37# GND nfet_03v3 ad=0.65p pd=3.3u as=0.42p ps=1.84u w=0 l=0
X87 4bitblock_0/1bitblock$2_0/a_9050_63# S1.t0 GND GND nfet_03v3 ad=0.31p pd=2.24u as=0.24p ps=1.96u w=0 l=0
X88 4bitblock_0/1bitblock_0/a_5042_407# 4bitblock_0/m1_14167_n1145# 4bitblock_0/1bitblock_0/a_4650_n37# GND.t8 nfet_03v3 ad=0.3375p pd=1.675u as=0.3625p ps=1.725u w=0 l=0
X89 4bitblock_0/1bitblock_0/a_1845_n37# B0.t4 GND GND nfet_03v3 ad=0.42p pd=1.84u as=0.63p ps=3.26u w=0 l=0
X90 4bitblock$2_0/1bitblock$2$2_0/a_9050_63# S1.t22 VDD VDD pfet_03v3 ad=0.64p pd=3.28u as=0.48p ps=2.96u w=0 l=0
X91 4bitblock_0/1bitblock$1_0/m2_9431_79# S1.t15 4bitblock_0/1bitblock$1_0/a_9609_407# VDD pfet_03v3 ad=0.725p pd=2.725u as=1.09p ps=5.09u w=0 l=0
X92 4bitblock$1_0/1bitblock$4_0/a_870_n37# B4.t5 GND GND nfet_03v3 ad=0.3625p pd=1.725u as=0.54p ps=3.08u w=0 l=0
X93 4bitblock$1_0/1bitblock$3$1_0/a_510_63# B7.t3 GND GND nfet_03v3 ad=0.315p pd=2.26u as=0.28p ps=2.12u w=0 l=0
X94 4bitblock$2_0/1bitblock$5_0/a_5768_63# S0.t50 VDD VDD pfet_03v3 ad=0.65p pd=3.3u as=0.635p ps=3.27u w=0 l=0
X95 VDD A12.t5 4bitblock_LAST_0/1bitblock$7_0/a_1845_466# VDD pfet_03v3 ad=0.735p pd=2.47u as=0.42p ps=1.84u w=0 l=0
X96 4bitblock$1_0/1bitblock$1$1_0/a_7410_63# S0.t116 VDD VDD pfet_03v3 ad=0.64p pd=3.28u as=0.48p ps=2.96u w=0 l=0
X97 4bitblock$1_0/1bitblock$4_0/a_1845_466# A4.t0 4bitblock$1_0/1bitblock$4_0/a_1845_n37# GND nfet_03v3 ad=0.65p pd=3.3u as=0.42p ps=1.84u w=0 l=0
X98 4bitblock$1_0/1bitblock$4_0/a_9050_63# S1.t52 GND GND nfet_03v3 ad=0.31p pd=2.24u as=0.24p ps=1.96u w=0 l=0
X99 4bitblock$1_0/1bitblock$1$1_0/a_7768_n37# S0.t118 GND GND nfet_03v3 ad=0.3625p pd=1.725u as=0.54p ps=3.08u w=0 l=0
X100 4bitblock_LAST_0/1bitblock$3$4_0/a_7410_63# S0.t65 GND GND nfet_03v3 ad=0.31p pd=2.24u as=0.24p ps=1.96u w=0 l=0
X101 4bitblock$2_0/MUX21$2_0/a_517_n37# BP2.t1 GND GND nfet_03v3 ad=0.3625p pd=1.725u as=0.54p ps=3.08u w=0 l=0
X102 4bitblock_LAST_0/1bitblock$1$4_0/a_5768_63# S0.t88 GND GND nfet_03v3 ad=0.315p pd=2.26u as=0.3175p ps=2.27u w=0 l=0
X103 4bitblock_LAST_0/1bitblock$3$4_0/m2_9431_79# S1.t35 4bitblock_LAST_0/1bitblock$3$4_0/a_9609_407# VDD pfet_03v3 ad=0.725p pd=2.725u as=1.09p ps=5.09u w=0 l=0
X104 4bitblock_0/1bitblock_0/m2_9431_79# 4bitblock_0/1bitblock_0/a_8723_63# 4bitblock_0/1bitblock_0/a_9408_n37# GND.t27 nfet_03v3 ad=0.3375p pd=1.675u as=0.3625p ps=1.725u w=0 l=0
X105 4bitblock$2_0/1bitblock$2$2_0/a_160_63# A10.t2 VDD VDD pfet_03v3 ad=0.63p pd=3.26u as=0.65p ps=3.3u w=0 l=0
X106 4bitblock$1_0/MUX21$1_0/a_157_63# BP1.t5 GND GND nfet_03v3 ad=0.315p pd=2.26u as=0.3175p ps=2.27u w=0 l=0
X107 4bitblock$2_0/1bitblock$1$2_0/m2_6151_79# S0.t61 4bitblock$2_0/1bitblock$1$2_0/a_6721_407# VDD pfet_03v3 ad=0.725p pd=2.725u as=1.09p ps=5.09u w=0 l=0
X108 4bitblock_0/1bitblock_0/a_160_63# A0.t1 GND GND nfet_03v3 ad=0.315p pd=2.26u as=0.325p ps=2.3u w=0 l=0
X109 4bitblock_0/1bitblock_0/a_9050_63# S1.t8 GND GND nfet_03v3 ad=0.31p pd=2.24u as=0.24p ps=1.96u w=0 l=0
X110 4bitblock$2_0/1bitblock$3$2_0/a_5768_63# S0.t32 GND GND nfet_03v3 ad=0.315p pd=2.26u as=0.3175p ps=2.27u w=0 l=0
X111 4bitblock_LAST_0/1bitblock$2$4_0/a_5768_63# S0.t72 GND GND nfet_03v3 ad=0.315p pd=2.26u as=0.3175p ps=2.27u w=0 l=0
X112 4bitblock_0/1bitblock$1_0/a_1845_n37# B1.t4 GND GND nfet_03v3 ad=0.42p pd=1.84u as=0.63p ps=3.26u w=0 l=0
X113 4bitblock_0/1bitblock$2_0/a_1845_466# B2.t1 VDD VDD pfet_03v3 ad=0.42p pd=1.84u as=0.65p ps=3.3u w=0 l=0
X114 4bitblock$1_0/1bitblock$3$1_0/a_7768_n37# S0.t126 GND GND nfet_03v3 ad=0.3625p pd=1.725u as=0.54p ps=3.08u w=0 l=0
X115 4bitblock$2_0/1bitblock$1$2_0/m2_7791_79# S0.t63 4bitblock$2_0/1bitblock$1$2_0/a_8361_407# VDD pfet_03v3 ad=0.725p pd=2.725u as=1.09p ps=5.09u w=0 l=0
X116 4bitblock$1_0/1bitblock$1$1_0/a_5768_63# S0.t112 GND GND nfet_03v3 ad=0.315p pd=2.26u as=0.3175p ps=2.27u w=0 l=0
X117 4bitblock_0/1bitblock$3_0/a_7410_63# S0.t9 GND GND nfet_03v3 ad=0.31p pd=2.24u as=0.24p ps=1.96u w=0 l=0
X118 4bitblock_0/1bitblock_0/a_5768_63# S0.t16 GND GND nfet_03v3 ad=0.315p pd=2.26u as=0.3175p ps=2.27u w=0 l=0
X119 4bitblock$2_0/1bitblock$2$2_0/a_510_63# B10.t2 VDD VDD pfet_03v3 ad=0.65p pd=3.3u as=0.56p ps=3.12u w=0 l=0
X120 4bitblock$2_0/1bitblock$1$2_0/a_705_407# A9.t4 VDD VDD pfet_03v3 ad=0.675p pd=2.675u as=0.725p ps=2.725u w=0 l=0
X121 4bitblock$2_0/1bitblock$1$2_0/a_7410_63# S0.t60 VDD VDD pfet_03v3 ad=0.64p pd=3.28u as=0.48p ps=2.96u w=0 l=0
X122 4bitblock$1_0/m2_1701_n784# A5.t3 4bitblock$1_0/1bitblock$1$1_0/a_870_n37# GND nfet_03v3 ad=0.3375p pd=1.675u as=0.3625p ps=1.725u w=0 l=0
X123 4bitblock_LAST_0/1bitblock$3$4_0/a_870_n37# B15.t5 GND GND nfet_03v3 ad=0.3625p pd=1.725u as=0.54p ps=3.08u w=0 l=0
X124 4bitblock_0/MUX21_0/a_517_n37# BP0.t1 GND GND nfet_03v3 ad=0.3625p pd=1.725u as=0.54p ps=3.08u w=0 l=0
X125 4bitblock$2_0/1bitblock$2$2_0/a_9050_63# S1.t20 GND GND nfet_03v3 ad=0.31p pd=2.24u as=0.24p ps=1.96u w=0 l=0
X126 4bitblock_LAST_0/1bitblock$7_0/m2_6151_79# S0.t85 4bitblock_LAST_0/1bitblock$7_0/a_6721_407# VDD pfet_03v3 ad=0.725p pd=2.725u as=1.09p ps=5.09u w=0 l=0
X127 VDD B7.t0 4bitblock$1_0/1bitblock$3$1_0/a_705_407# VDD pfet_03v3 ad=0.725p pd=2.725u as=1.09p ps=5.09u w=0 l=0
X128 4bitblock$1_0/1bitblock$4_0/a_1845_466# B4.t1 VDD VDD pfet_03v3 ad=0.42p pd=1.84u as=0.65p ps=3.3u w=0 l=0
X129 4bitblock$2_0/1bitblock$5_0/a_5768_63# S0.t48 GND GND nfet_03v3 ad=0.315p pd=2.26u as=0.3175p ps=2.27u w=0 l=0
X130 VDD B2.t0 4bitblock_0/1bitblock$2_0/a_705_407# VDD pfet_03v3 ad=0.725p pd=2.725u as=1.09p ps=5.09u w=0 l=0
X131 4bitblock$2_0/1bitblock$2$2_0/m2_9431_79# S1.t23 4bitblock$2_0/1bitblock$2$2_0/a_9609_407# VDD pfet_03v3 ad=0.725p pd=2.725u as=1.09p ps=5.09u w=0 l=0
X132 4bitblock_0/1bitblock$3_0/a_510_63# B3.t2 VDD VDD pfet_03v3 ad=0.65p pd=3.3u as=0.56p ps=3.12u w=0 l=0
X133 4bitblock$1_0/1bitblock$3$1_0/a_5768_63# S0.t120 GND GND nfet_03v3 ad=0.315p pd=2.26u as=0.3175p ps=2.27u w=0 l=0
X134 4bitblock$1_0/1bitblock$1$1_0/a_1845_n37# B5.t4 GND GND nfet_03v3 ad=0.42p pd=1.84u as=0.63p ps=3.26u w=0 l=0
X135 4bitblock_LAST_0/MUX21$4_0/a_157_63# BP3.t5 GND GND nfet_03v3 ad=0.315p pd=2.26u as=0.3175p ps=2.27u w=0 l=0
X136 4bitblock_LAST_0/1bitblock$7_0/m2_7791_79# S0.t87 4bitblock_LAST_0/1bitblock$7_0/a_8361_407# VDD pfet_03v3 ad=0.725p pd=2.725u as=1.09p ps=5.09u w=0 l=0
X137 4bitblock_0/1bitblock_0/a_5243_407# 4bitblock_0/m1_14167_n1145# VDD.t9 VDD.t8 pfet_03v3 ad=0.675p pd=2.675u as=0.725p ps=2.725u w=0 l=0
X138 4bitblock_LAST_0/1bitblock$7_0/a_9408_n37# S1.t41 GND GND nfet_03v3 ad=0.3625p pd=1.725u as=0.54p ps=3.08u w=0 l=0
X139 4bitblock_0/1bitblock_0/a_7410_63# S0.t17 GND GND nfet_03v3 ad=0.31p pd=2.24u as=0.24p ps=1.96u w=0 l=0
X140 4bitblock$2_0/1bitblock$1$2_0/a_1845_466# A9.t0 4bitblock$2_0/1bitblock$1$2_0/a_1845_n37# GND nfet_03v3 ad=0.65p pd=3.3u as=0.42p ps=1.84u w=0 l=0
X141 4bitblock_0/1bitblock_0/a_11922_3# 4bitblock_0/1bitblock_0/a_2419_63# 4bitblock_0/1bitblock_0/a_11922_391# VDD.t0 pfet_03v3 ad=1.3p pd=5.3u as=0.725p ps=2.725u w=0 l=0
X142 4bitblock$1_0/m1_13543_n1146# A7.t3 4bitblock$1_0/1bitblock$3$1_0/a_870_n37# GND nfet_03v3 ad=0.3375p pd=1.675u as=0.3625p ps=1.725u w=0 l=0
X143 4bitblock$1_0/1bitblock$1$1_0/a_160_63# A5.t2 VDD VDD pfet_03v3 ad=0.63p pd=3.26u as=0.65p ps=3.3u w=0 l=0
X144 VDD B4.t0 4bitblock$1_0/1bitblock$4_0/a_705_407# VDD pfet_03v3 ad=0.725p pd=2.725u as=1.09p ps=5.09u w=0 l=0
X145 4bitblock$2_0/1bitblock$2$2_0/a_160_63# A10.t1 GND GND nfet_03v3 ad=0.315p pd=2.26u as=0.325p ps=2.3u w=0 l=0
X146 4bitblock$2_0/1bitblock$2$2_0/a_870_n37# B10.t5 GND GND nfet_03v3 ad=0.3625p pd=1.725u as=0.54p ps=3.08u w=0 l=0
X147 VDD A0.t5 4bitblock_0/1bitblock_0/a_1845_466# VDD.t5 pfet_03v3 ad=0.735p pd=2.47u as=0.42p ps=1.84u w=0 l=0
X148 VDD A5.t5 4bitblock$1_0/1bitblock$1$1_0/a_1845_466# VDD pfet_03v3 ad=0.735p pd=2.47u as=0.42p ps=1.84u w=0 l=0
X149 4bitblock_LAST_0/1bitblock$2$4_0/a_6128_n37# S0.t75 GND GND nfet_03v3 ad=0.3625p pd=1.725u as=0.54p ps=3.08u w=0 l=0
X150 4bitblock_LAST_0/1bitblock$7_0/a_9050_63# S1.t42 VDD VDD pfet_03v3 ad=0.64p pd=3.28u as=0.48p ps=2.96u w=0 l=0
X151 4bitblock_0/1bitblock$1_0/a_7768_n37# S0.t30 GND GND nfet_03v3 ad=0.3625p pd=1.725u as=0.54p ps=3.08u w=0 l=0
X152 VDD BP1.t0 AND4$4_0/a_518_229# VDD pfet_03v3 ad=0.38p pd=1.76u as=0.38p ps=1.76u w=0 l=0
X153 4bitblock$1_0/1bitblock$1$1_0/a_510_63# B5.t2 VDD VDD pfet_03v3 ad=0.65p pd=3.3u as=0.56p ps=3.12u w=0 l=0
X154 VDD B13.t0 4bitblock_LAST_0/1bitblock$1$4_0/a_705_407# VDD pfet_03v3 ad=0.725p pd=2.725u as=1.09p ps=5.09u w=0 l=0
X155 4bitblock_0/1bitblock_0/m2_6151_79# 4bitblock_0/1bitblock_0/a_2419_63# 4bitblock_0/1bitblock_0/a_6128_n37# GND.t0 nfet_03v3 ad=0.3375p pd=1.675u as=0.3625p ps=1.725u w=0 l=0
X156 4bitblock_LAST_0/1bitblock$7_0/a_160_63# A12.t2 VDD VDD pfet_03v3 ad=0.63p pd=3.26u as=0.65p ps=3.3u w=0 l=0
X157 4bitblock_LAST_0/1bitblock$2$4_0/a_7768_n37# S0.t78 GND GND nfet_03v3 ad=0.3625p pd=1.725u as=0.54p ps=3.08u w=0 l=0
X158 4bitblock_0/1bitblock$1_0/a_510_63# B1.t3 GND GND nfet_03v3 ad=0.315p pd=2.26u as=0.28p ps=2.12u w=0 l=0
X159 4bitblock_0/1bitblock_0/a_9609_407# 4bitblock_0/1bitblock_0/a_8723_63# 4bitblock_0/1bitblock_0/m2_9431_79# VDD.t22 pfet_03v3 ad=0.675p pd=2.675u as=0.725p ps=2.725u w=0 l=0
X160 4bitblock$1_0/1bitblock$3$1_0/a_5768_63# S0.t122 VDD VDD pfet_03v3 ad=0.65p pd=3.3u as=0.635p ps=3.27u w=0 l=0
X161 4bitblock_0/MUX21_0/m2_540_79# BP0.t2 4bitblock_0/MUX21_0/a_718_407# VDD pfet_03v3 ad=0.725p pd=2.725u as=1.09p ps=5.09u w=0 l=0
X162 4bitblock_0/1bitblock$3_0/a_1845_466# B3.t1 VDD VDD pfet_03v3 ad=0.42p pd=1.84u as=0.65p ps=3.3u w=0 l=0
X163 4bitblock_LAST_0/m2_2396_n2595# A14.t3 4bitblock_LAST_0/1bitblock$2$4_0/a_870_n37# GND nfet_03v3 ad=0.3375p pd=1.675u as=0.3625p ps=1.725u w=0 l=0
X164 4bitblock$2_0/1bitblock$2$2_0/a_1845_466# B10.t1 VDD VDD pfet_03v3 ad=0.42p pd=1.84u as=0.65p ps=3.3u w=0 l=0
X165 4bitblock$2_0/1bitblock$2$2_0/a_510_63# B10.t3 GND GND nfet_03v3 ad=0.315p pd=2.26u as=0.28p ps=2.12u w=0 l=0
X166 4bitblock$2_0/1bitblock$5_0/a_6128_n37# S0.t51 GND GND nfet_03v3 ad=0.3625p pd=1.725u as=0.54p ps=3.08u w=0 l=0
X167 VDD A14.t5 4bitblock_LAST_0/1bitblock$2$4_0/a_1845_466# VDD pfet_03v3 ad=0.735p pd=2.47u as=0.42p ps=1.84u w=0 l=0
X168 4bitblock_0/1bitblock_0/a_510_63# B0.t3 GND GND nfet_03v3 ad=0.315p pd=2.26u as=0.28p ps=2.12u w=0 l=0
X169 VDD B1.t0 4bitblock_0/1bitblock$1_0/a_705_407# VDD pfet_03v3 ad=0.725p pd=2.725u as=1.09p ps=5.09u w=0 l=0
X170 4bitblock$2_0/1bitblock$5_0/a_7768_n37# S0.t54 GND GND nfet_03v3 ad=0.3625p pd=1.725u as=0.54p ps=3.08u w=0 l=0
X171 4bitblock$2_0/1bitblock$1$2_0/m2_9431_79# S1.t31 4bitblock$2_0/1bitblock$1$2_0/a_9609_407# VDD pfet_03v3 ad=0.725p pd=2.725u as=1.09p ps=5.09u w=0 l=0
X172 4bitblock_0/1bitblock_0/a_160_63# A0.t2 VDD VDD pfet_03v3 ad=0.63p pd=3.26u as=0.65p ps=3.3u w=0 l=0
X173 VDD B15.t0 4bitblock_LAST_0/1bitblock$3$4_0/a_705_407# VDD pfet_03v3 ad=0.725p pd=2.725u as=1.09p ps=5.09u w=0 l=0
X174 4bitblock_0/1bitblock_0/a_9050_63# S1.t10 VDD VDD pfet_03v3 ad=0.64p pd=3.28u as=0.48p ps=2.96u w=0 l=0
X175 4bitblock$1_0/1bitblock$2$1_0/a_7768_n37# S0.t102 GND GND nfet_03v3 ad=0.3625p pd=1.725u as=0.54p ps=3.08u w=0 l=0
X176 4bitblock_0/1bitblock$3_0/a_510_63# B3.t3 GND GND nfet_03v3 ad=0.315p pd=2.26u as=0.28p ps=2.12u w=0 l=0
X177 4bitblock_0/1bitblock$3_0/a_5768_63# S0.t10 VDD VDD pfet_03v3 ad=0.65p pd=3.3u as=0.635p ps=3.27u w=0 l=0
X178 4bitblock$1_0/1bitblock$2$1_0/a_7410_63# S0.t100 VDD VDD pfet_03v3 ad=0.64p pd=3.28u as=0.48p ps=2.96u w=0 l=0
X179 4bitblock_LAST_0/1bitblock$1$4_0/a_1845_n37# B13.t4 GND GND nfet_03v3 ad=0.42p pd=1.84u as=0.63p ps=3.26u w=0 l=0
X180 VDD A8.t5 4bitblock$2_0/1bitblock$5_0/a_1845_466# VDD pfet_03v3 ad=0.735p pd=2.47u as=0.42p ps=1.84u w=0 l=0
X181 4bitblock_LAST_0/1bitblock$1$4_0/a_5768_63# S0.t90 VDD VDD pfet_03v3 ad=0.65p pd=3.3u as=0.635p ps=3.27u w=0 l=0
X182 4bitblock_LAST_0/1bitblock$7_0/a_510_63# B12.t2 VDD VDD pfet_03v3 ad=0.65p pd=3.3u as=0.56p ps=3.12u w=0 l=0
X183 4bitblock_0/1bitblock$1_0/a_7410_63# S0.t28 VDD VDD pfet_03v3 ad=0.64p pd=3.28u as=0.48p ps=2.96u w=0 l=0
X184 4bitblock_0/1bitblock_0/a_5768_63# S0.t18 VDD VDD pfet_03v3 ad=0.65p pd=3.3u as=0.635p ps=3.27u w=0 l=0
X185 AND4$4_0/a_704_n441# BP3.t1 GND GND nfet_03v3 ad=0.76p pd=2.76u as=1.34p ps=5.34u w=0 l=0
X186 4bitblock_LAST_0/MUX21$4_0/m2_540_79# BP3.t4 4bitblock_LAST_0/MUX21$4_0/a_718_407# VDD pfet_03v3 ad=0.725p pd=2.725u as=1.09p ps=5.09u w=0 l=0
X187 4bitblock_LAST_0/1bitblock$3$4_0/a_1845_n37# B15.t4 GND GND nfet_03v3 ad=0.42p pd=1.84u as=0.63p ps=3.26u w=0 l=0
X188 4bitblock$1_0/MUX21$1_0/a_157_63# BP1.t2 VDD VDD pfet_03v3 ad=0.65p pd=3.3u as=0.635p ps=3.27u w=0 l=0
X189 4bitblock_LAST_0/1bitblock$7_0/a_9050_63# S1.t40 GND GND nfet_03v3 ad=0.31p pd=2.24u as=0.24p ps=1.96u w=0 l=0
X190 VDD B0.t0 4bitblock_0/1bitblock_0/a_705_407# VDD pfet_03v3 ad=0.725p pd=2.725u as=1.09p ps=5.09u w=0 l=0
X191 4bitblock$2_0/1bitblock$1$2_0/a_5768_63# S0.t56 GND GND nfet_03v3 ad=0.315p pd=2.26u as=0.3175p ps=2.27u w=0 l=0
X192 4bitblock_LAST_0/1bitblock$7_0/m2_9431_79# S1.t43 4bitblock_LAST_0/1bitblock$7_0/a_9609_407# VDD pfet_03v3 ad=0.725p pd=2.725u as=1.09p ps=5.09u w=0 l=0
X193 4bitblock_LAST_0/1bitblock$7_0/a_160_63# A12.t1 GND GND nfet_03v3 ad=0.315p pd=2.26u as=0.325p ps=2.3u w=0 l=0
X194 4bitblock_LAST_0/1bitblock$3$4_0/a_1845_466# A15.t0 4bitblock_LAST_0/1bitblock$3$4_0/a_1845_n37# GND nfet_03v3 ad=0.65p pd=3.3u as=0.42p ps=1.84u w=0 l=0
X195 4bitblock$1_0/1bitblock$1$1_0/a_5768_63# S0.t114 VDD VDD pfet_03v3 ad=0.65p pd=3.3u as=0.635p ps=3.27u w=0 l=0
X196 VDD B10.t0 4bitblock$2_0/1bitblock$2$2_0/a_705_407# VDD pfet_03v3 ad=0.725p pd=2.725u as=1.09p ps=5.09u w=0 l=0
X197 4bitblock_0/1bitblock_0/a_7410_63# S0.t20 VDD VDD pfet_03v3 ad=0.64p pd=3.28u as=0.48p ps=2.96u w=0 l=0
X198 4bitblock$1_0/m1_14167_n1145# A4.t3 4bitblock$1_0/1bitblock$4_0/a_870_n37# GND nfet_03v3 ad=0.3375p pd=1.675u as=0.3625p ps=1.725u w=0 l=0
X199 4bitblock_LAST_0/1bitblock$2$4_0/m2_6151_79# S0.t77 4bitblock_LAST_0/1bitblock$2$4_0/a_6721_407# VDD pfet_03v3 ad=0.725p pd=2.725u as=1.09p ps=5.09u w=0 l=0
X200 GND 4bitblock_0/1bitblock_0/a_510_63# 4bitblock_0/1bitblock_0/a_1262_n37# GND.t17 nfet_03v3 ad=0.65p pd=3.3u as=0.3625p ps=1.725u w=0 l=0
X201 4bitblock$1_0/m2_2396_n2595# A6.t3 4bitblock$1_0/1bitblock$2$1_0/a_870_n37# GND nfet_03v3 ad=0.3375p pd=1.675u as=0.3625p ps=1.725u w=0 l=0
X202 4bitblock_LAST_0/1bitblock$3$4_0/a_5768_63# S0.t66 VDD VDD pfet_03v3 ad=0.65p pd=3.3u as=0.635p ps=3.27u w=0 l=0
X203 4bitblock_0/1bitblock_0/a_1845_466# B0.t1 VDD VDD pfet_03v3 ad=0.42p pd=1.84u as=0.65p ps=3.3u w=0 l=0
X204 4bitblock_0/1bitblock$3_0/a_7768_n37# S0.t14 GND GND nfet_03v3 ad=0.3625p pd=1.725u as=0.54p ps=3.08u w=0 l=0
X205 4bitblock$1_0/1bitblock$1$1_0/a_9050_63# S1.t56 GND GND nfet_03v3 ad=0.31p pd=2.24u as=0.24p ps=1.96u w=0 l=0
X206 4bitblock_0/1bitblock_0/a_6721_407# 4bitblock_0/1bitblock_0/a_2419_63# 4bitblock_0/1bitblock_0/m2_6151_79# VDD.t2 pfet_03v3 ad=0.675p pd=2.675u as=0.725p ps=2.725u w=0 l=0
X207 4bitblock_LAST_0/1bitblock$7_0/a_870_n37# B12.t5 GND GND nfet_03v3 ad=0.3625p pd=1.725u as=0.54p ps=3.08u w=0 l=0
X208 4bitblock_LAST_0/1bitblock$2$4_0/m2_7791_79# S0.t79 4bitblock_LAST_0/1bitblock$2$4_0/a_8361_407# VDD pfet_03v3 ad=0.725p pd=2.725u as=1.09p ps=5.09u w=0 l=0
X209 4bitblock_LAST_0/1bitblock$2$4_0/a_9408_n37# S1.t37 GND GND nfet_03v3 ad=0.3625p pd=1.725u as=0.54p ps=3.08u w=0 l=0
X210 4bitblock$2_0/1bitblock$2$2_0/a_7410_63# S0.t44 VDD VDD pfet_03v3 ad=0.64p pd=3.28u as=0.48p ps=2.96u w=0 l=0
X211 4bitblock$1_0/1bitblock$2$1_0/a_1845_n37# B6.t4 GND GND nfet_03v3 ad=0.42p pd=1.84u as=0.63p ps=3.26u w=0 l=0
X212 4bitblock_LAST_0/1bitblock$2$4_0/a_705_407# A14.t4 VDD VDD pfet_03v3 ad=0.675p pd=2.675u as=0.725p ps=2.725u w=0 l=0
X213 4bitblock_LAST_0/MUX21$4_0/a_157_63# BP3.t2 VDD VDD pfet_03v3 ad=0.65p pd=3.3u as=0.635p ps=3.27u w=0 l=0
X214 4bitblock$2_0/1bitblock$3$2_0/a_9050_63# S1.t18 VDD VDD pfet_03v3 ad=0.64p pd=3.28u as=0.48p ps=2.96u w=0 l=0
X215 4bitblock$2_0/1bitblock$2$2_0/a_1845_466# A10.t0 4bitblock$2_0/1bitblock$2$2_0/a_1845_n37# GND nfet_03v3 ad=0.65p pd=3.3u as=0.42p ps=1.84u w=0 l=0
X216 4bitblock$2_0/1bitblock$5_0/m2_6151_79# S0.t53 4bitblock$2_0/1bitblock$5_0/a_6721_407# VDD pfet_03v3 ad=0.725p pd=2.725u as=1.09p ps=5.09u w=0 l=0
X217 4bitblock$1_0/1bitblock$2$1_0/a_7410_63# S0.t97 GND GND nfet_03v3 ad=0.31p pd=2.24u as=0.24p ps=1.96u w=0 l=0
X218 4bitblock$1_0/1bitblock$3$1_0/a_9050_63# S1.t60 GND GND nfet_03v3 ad=0.31p pd=2.24u as=0.24p ps=1.96u w=0 l=0
X219 4bitblock_LAST_0/1bitblock$7_0/a_510_63# B12.t3 GND GND nfet_03v3 ad=0.315p pd=2.26u as=0.28p ps=2.12u w=0 l=0
X220 4bitblock_LAST_0/1bitblock$7_0/a_1845_466# B12.t1 VDD VDD pfet_03v3 ad=0.42p pd=1.84u as=0.65p ps=3.3u w=0 l=0
X221 4bitblock_LAST_0/1bitblock$2$4_0/a_9050_63# S1.t38 VDD VDD pfet_03v3 ad=0.64p pd=3.28u as=0.48p ps=2.96u w=0 l=0
X222 4bitblock_0/1bitblock$3_0/a_5768_63# S0.t8 GND GND nfet_03v3 ad=0.315p pd=2.26u as=0.3175p ps=2.27u w=0 l=0
X223 VDD A6.t5 4bitblock$1_0/1bitblock$2$1_0/a_1845_466# VDD pfet_03v3 ad=0.735p pd=2.47u as=0.42p ps=1.84u w=0 l=0
X224 4bitblock_0/1bitblock$1_0/a_5768_63# S0.t24 GND GND nfet_03v3 ad=0.315p pd=2.26u as=0.3175p ps=2.27u w=0 l=0
X225 4bitblock$2_0/MUX21$2_0/a_157_63# BP2.t3 GND GND nfet_03v3 ad=0.315p pd=2.26u as=0.3175p ps=2.27u w=0 l=0
X226 4bitblock$2_0/1bitblock$5_0/m2_7791_79# S0.t55 4bitblock$2_0/1bitblock$5_0/a_8361_407# VDD pfet_03v3 ad=0.725p pd=2.725u as=1.09p ps=5.09u w=0 l=0
X227 4bitblock$2_0/1bitblock$5_0/a_9408_n37# S1.t25 GND GND nfet_03v3 ad=0.3625p pd=1.725u as=0.54p ps=3.08u w=0 l=0
X228 4bitblock_LAST_0/m1_14167_n1145# A12.t3 4bitblock_LAST_0/1bitblock$7_0/a_870_n37# GND nfet_03v3 ad=0.3375p pd=1.675u as=0.3625p ps=1.725u w=0 l=0
X229 4bitblock_0/1bitblock_0/a_510_63# B0.t2 VDD VDD pfet_03v3 ad=0.65p pd=3.3u as=0.56p ps=3.12u w=0 l=0
X230 4bitblock$1_0/1bitblock$2$1_0/a_160_63# A6.t2 VDD VDD pfet_03v3 ad=0.63p pd=3.26u as=0.65p ps=3.3u w=0 l=0
X231 4bitblock$1_0/1bitblock$1$1_0/a_6128_n37# S0.t115 GND GND nfet_03v3 ad=0.3625p pd=1.725u as=0.54p ps=3.08u w=0 l=0
X232 4bitblock_0/m1_13543_n1146# A3.t3 4bitblock_0/1bitblock$3_0/a_870_n37# GND nfet_03v3 ad=0.3375p pd=1.675u as=0.3625p ps=1.725u w=0 l=0
X233 4bitblock$1_0/1bitblock$2$1_0/m2_7791_79# S0.t103 4bitblock$1_0/1bitblock$2$1_0/a_8361_407# VDD pfet_03v3 ad=0.725p pd=2.725u as=1.09p ps=5.09u w=0 l=0
X234 4bitblock_0/1bitblock$1_0/a_160_63# A1.t2 VDD VDD pfet_03v3 ad=0.63p pd=3.26u as=0.65p ps=3.3u w=0 l=0
X235 4bitblock_0/1bitblock_0/m2_7791_79# 4bitblock_0/m1_14167_n1145# 4bitblock_0/1bitblock_0/a_7768_n37# GND.t10 nfet_03v3 ad=0.3375p pd=1.675u as=0.3625p ps=1.725u w=0 l=0
X236 4bitblock$2_0/1bitblock$5_0/a_9050_63# S1.t26 VDD VDD pfet_03v3 ad=0.64p pd=3.28u as=0.48p ps=2.96u w=0 l=0
X237 VDD A1.t5 4bitblock_0/1bitblock$1_0/a_1845_466# VDD pfet_03v3 ad=0.735p pd=2.47u as=0.42p ps=1.84u w=0 l=0
X238 4bitblock$1_0/1bitblock$2$1_0/a_510_63# B6.t2 VDD VDD pfet_03v3 ad=0.65p pd=3.3u as=0.56p ps=3.12u w=0 l=0
X239 4bitblock_LAST_0/1bitblock$2$4_0/a_160_63# A14.t2 VDD VDD pfet_03v3 ad=0.63p pd=3.26u as=0.65p ps=3.3u w=0 l=0
X240 4bitblock_0/1bitblock$1_0/a_510_63# B1.t2 VDD VDD pfet_03v3 ad=0.65p pd=3.3u as=0.56p ps=3.12u w=0 l=0
X241 VDD B9.t0 4bitblock$2_0/1bitblock$1$2_0/a_705_407# VDD pfet_03v3 ad=0.725p pd=2.725u as=1.09p ps=5.09u w=0 l=0
X242 4bitblock$2_0/1bitblock$5_0/a_160_63# A8.t2 VDD VDD pfet_03v3 ad=0.63p pd=3.26u as=0.65p ps=3.3u w=0 l=0
X243 4bitblock$1_0/1bitblock$1$1_0/a_9408_n37# S1.t57 GND GND nfet_03v3 ad=0.3625p pd=1.725u as=0.54p ps=3.08u w=0 l=0
X244 4bitblock$1_0/1bitblock$3$1_0/a_6128_n37# S0.t123 GND GND nfet_03v3 ad=0.3625p pd=1.725u as=0.54p ps=3.08u w=0 l=0
X245 4bitblock_LAST_0/1bitblock$3$4_0/a_5768_63# S0.t64 GND GND nfet_03v3 ad=0.315p pd=2.26u as=0.3175p ps=2.27u w=0 l=0
X246 4bitblock_0/1bitblock_0/a_10906_n37# Cin.t4 GND GND nfet_03v3 ad=0.42p pd=1.84u as=0.63p ps=3.26u w=0 l=0
X247 4bitblock_LAST_0/1bitblock$1$4_0/a_9050_63# S1.t44 GND GND nfet_03v3 ad=0.31p pd=2.24u as=0.24p ps=1.96u w=0 l=0
X248 4bitblock$2_0/1bitblock$3$2_0/a_510_63# B11.t2 VDD VDD pfet_03v3 ad=0.65p pd=3.3u as=0.56p ps=3.12u w=0 l=0
X249 4bitblock$2_0/1bitblock$2$2_0/a_7410_63# S0.t41 GND GND nfet_03v3 ad=0.31p pd=2.24u as=0.24p ps=1.96u w=0 l=0
X250 4bitblock_0/1bitblock$1_0/a_870_n37# B1.t5 GND GND nfet_03v3 ad=0.3625p pd=1.725u as=0.54p ps=3.08u w=0 l=0
X251 VDD A3.t5 4bitblock_0/1bitblock$3_0/a_1845_466# VDD pfet_03v3 ad=0.735p pd=2.47u as=0.42p ps=1.84u w=0 l=0
X252 4bitblock_0/1bitblock$3_0/m2_7791_79# S0.t15 4bitblock_0/1bitblock$3_0/a_8361_407# VDD pfet_03v3 ad=0.725p pd=2.725u as=1.09p ps=5.09u w=0 l=0
X253 4bitblock_LAST_0/1bitblock$2$4_0/a_510_63# B14.t2 VDD VDD pfet_03v3 ad=0.65p pd=3.3u as=0.56p ps=3.12u w=0 l=0
X254 4bitblock$1_0/1bitblock$4_0/a_705_407# A4.t4 VDD VDD pfet_03v3 ad=0.675p pd=2.675u as=0.725p ps=2.725u w=0 l=0
X255 4bitblock_0/1bitblock_0/a_705_407# 4bitblock_0/1bitblock_0/a_510_63# 4bitblock_0/m1_14167_n1145# VDD.t17 pfet_03v3 ad=1.3p pd=5.3u as=0.725p ps=2.725u w=0 l=0
X256 4bitblock$1_0/1bitblock$3$1_0/a_1845_n37# B7.t4 GND GND nfet_03v3 ad=0.42p pd=1.84u as=0.63p ps=3.26u w=0 l=0
X257 GND 4bitblock_0/1bitblock_0/a_4290_63# 4bitblock_0/1bitblock_0/a_5042_n37# GND.t11 nfet_03v3 ad=0.65p pd=3.3u as=0.3625p ps=1.725u w=0 l=0
X258 4bitblock$1_0/1bitblock$2$1_0/a_705_407# A6.t4 VDD VDD pfet_03v3 ad=0.675p pd=2.675u as=0.725p ps=2.725u w=0 l=0
X259 4bitblock$2_0/1bitblock$3$2_0/a_160_63# A11.t2 VDD VDD pfet_03v3 ad=0.63p pd=3.26u as=0.65p ps=3.3u w=0 l=0
X260 4bitblock_0/1bitblock$1_0/a_7410_63# S0.t25 GND GND nfet_03v3 ad=0.31p pd=2.24u as=0.24p ps=1.96u w=0 l=0
X261 4bitblock$1_0/1bitblock$3$1_0/a_9408_n37# S1.t61 GND GND nfet_03v3 ad=0.3625p pd=1.725u as=0.54p ps=3.08u w=0 l=0
X262 4bitblock_LAST_0/1bitblock$2$4_0/a_9050_63# S1.t36 GND GND nfet_03v3 ad=0.31p pd=2.24u as=0.24p ps=1.96u w=0 l=0
X263 4bitblock$2_0/1bitblock$3$2_0/a_9050_63# S1.t16 GND GND nfet_03v3 ad=0.31p pd=2.24u as=0.24p ps=1.96u w=0 l=0
X264 VDD B12.t0 4bitblock_LAST_0/1bitblock$7_0/a_705_407# VDD pfet_03v3 ad=0.725p pd=2.725u as=1.09p ps=5.09u w=0 l=0
X265 4bitblock_LAST_0/1bitblock$1$4_0/a_6128_n37# S0.t91 GND GND nfet_03v3 ad=0.3625p pd=1.725u as=0.54p ps=3.08u w=0 l=0
X266 4bitblock_LAST_0/1bitblock$2$4_0/m2_9431_79# S1.t39 4bitblock_LAST_0/1bitblock$2$4_0/a_9609_407# VDD pfet_03v3 ad=0.725p pd=2.725u as=1.09p ps=5.09u w=0 l=0
X267 4bitblock_0/1bitblock$2_0/a_7768_n37# S0.t6 GND GND nfet_03v3 ad=0.3625p pd=1.725u as=0.54p ps=3.08u w=0 l=0
X268 4bitblock_0/1bitblock$3_0/a_9050_63# S1.t6 VDD VDD pfet_03v3 ad=0.64p pd=3.28u as=0.48p ps=2.96u w=0 l=0
X269 4bitblock_LAST_0/1bitblock$1$4_0/a_160_63# A13.t1 GND GND nfet_03v3 ad=0.315p pd=2.26u as=0.325p ps=2.3u w=0 l=0
X270 4bitblock_0/1bitblock$2_0/a_7410_63# S0.t4 VDD VDD pfet_03v3 ad=0.64p pd=3.28u as=0.48p ps=2.96u w=0 l=0
X271 4bitblock_0/1bitblock_0/a_4650_n37# Cin.t5 GND GND nfet_03v3 ad=0.3625p pd=1.725u as=0.54p ps=3.08u w=0 l=0
X272 4bitblock$2_0/1bitblock$1$2_0/a_1845_n37# B9.t4 GND GND nfet_03v3 ad=0.42p pd=1.84u as=0.63p ps=3.26u w=0 l=0
X273 4bitblock$1_0/1bitblock$2$1_0/a_160_63# A6.t1 GND GND nfet_03v3 ad=0.315p pd=2.26u as=0.325p ps=2.3u w=0 l=0
X274 4bitblock$2_0/1bitblock$5_0/a_510_63# B8.t2 VDD VDD pfet_03v3 ad=0.65p pd=3.3u as=0.56p ps=3.12u w=0 l=0
X275 4bitblock_0/MUX21_0/a_718_407# Cin.t0 4bitblock_0/MUX21_0/m2_540_79# VDD pfet_03v3 ad=0.675p pd=2.675u as=0.725p ps=2.725u w=0 l=0
X276 4bitblock_LAST_0/1bitblock$7_0/a_7410_63# S0.t84 VDD VDD pfet_03v3 ad=0.64p pd=3.28u as=0.48p ps=2.96u w=0 l=0
X277 4bitblock$2_0/1bitblock$1$2_0/a_5768_63# S0.t58 VDD VDD pfet_03v3 ad=0.65p pd=3.3u as=0.635p ps=3.27u w=0 l=0
X278 4bitblock$1_0/1bitblock$1$1_0/m2_7791_79# S0.t119 4bitblock$1_0/1bitblock$1$1_0/a_8361_407# VDD pfet_03v3 ad=0.725p pd=2.725u as=1.09p ps=5.09u w=0 l=0
X279 4bitblock_LAST_0/1bitblock$1$4_0/a_7768_n37# S0.t94 GND GND nfet_03v3 ad=0.3625p pd=1.725u as=0.54p ps=3.08u w=0 l=0
X280 VDD BP3.t0 AND4$4_0/a_518_229# VDD pfet_03v3 ad=0.38p pd=1.76u as=0.65p ps=3.3u w=0 l=0
X281 4bitblock$2_0/MUX21$2_0/m2_540_79# BP2.t2 4bitblock$2_0/MUX21$2_0/a_718_407# VDD pfet_03v3 ad=0.725p pd=2.725u as=1.09p ps=5.09u w=0 l=0
X282 4bitblock_0/MUX21_0/a_157_63# BP0.t0 VDD VDD pfet_03v3 ad=0.65p pd=3.3u as=0.635p ps=3.27u w=0 l=0
X283 4bitblock$2_0/1bitblock$3$2_0/a_6128_n37# S0.t35 GND GND nfet_03v3 ad=0.3625p pd=1.725u as=0.54p ps=3.08u w=0 l=0
X284 4bitblock_LAST_0/m2_1701_n784# A13.t3 4bitblock_LAST_0/1bitblock$1$4_0/a_870_n37# GND nfet_03v3 ad=0.3375p pd=1.675u as=0.3625p ps=1.725u w=0 l=0
X285 4bitblock$2_0/1bitblock$5_0/a_9050_63# S1.t24 GND GND nfet_03v3 ad=0.31p pd=2.24u as=0.24p ps=1.96u w=0 l=0
X286 4bitblock_LAST_0/1bitblock$7_0/a_1845_466# A12.t0 4bitblock_LAST_0/1bitblock$7_0/a_1845_n37# GND nfet_03v3 ad=0.65p pd=3.3u as=0.42p ps=1.84u w=0 l=0
X287 GND 4bitblock_0/1bitblock_0/a_9050_63# 4bitblock_0/1bitblock_0/a_9800_n37# GND.t21 nfet_03v3 ad=0.65p pd=3.3u as=0.3625p ps=1.725u w=0 l=0
X288 4bitblock$1_0/1bitblock$2$1_0/a_510_63# B6.t3 GND GND nfet_03v3 ad=0.315p pd=2.26u as=0.28p ps=2.12u w=0 l=0
X289 4bitblock_LAST_0/1bitblock$2$4_0/a_160_63# A14.t1 GND GND nfet_03v3 ad=0.315p pd=2.26u as=0.325p ps=2.3u w=0 l=0
X290 4bitblock_0/1bitblock$3_0/a_705_407# A3.t4 VDD VDD pfet_03v3 ad=0.675p pd=2.675u as=0.725p ps=2.725u w=0 l=0
X291 4bitblock$1_0/1bitblock$4_0/a_7768_n37# S0.t110 GND GND nfet_03v3 ad=0.3625p pd=1.725u as=0.54p ps=3.08u w=0 l=0
X292 4bitblock_LAST_0/1bitblock$2$4_0/a_870_n37# B14.t5 GND GND nfet_03v3 ad=0.3625p pd=1.725u as=0.54p ps=3.08u w=0 l=0
X293 VDD Cin.t6 4bitblock_0/1bitblock_0/a_5243_407# VDD pfet_03v3 ad=0.725p pd=2.725u as=1.09p ps=5.09u w=0 l=0
X294 VDD A13.t5 4bitblock_LAST_0/1bitblock$1$4_0/a_1845_466# VDD pfet_03v3 ad=0.735p pd=2.47u as=0.42p ps=1.84u w=0 l=0
X295 4bitblock$2_0/1bitblock$5_0/m2_9431_79# S1.t27 4bitblock$2_0/1bitblock$5_0/a_9609_407# VDD pfet_03v3 ad=0.725p pd=2.725u as=1.09p ps=5.09u w=0 l=0
X296 4bitblock$2_0/1bitblock$3$2_0/a_1845_466# B11.t1 VDD VDD pfet_03v3 ad=0.42p pd=1.84u as=0.65p ps=3.3u w=0 l=0
X297 4bitblock$1_0/1bitblock$4_0/a_7410_63# S0.t108 VDD VDD pfet_03v3 ad=0.64p pd=3.28u as=0.48p ps=2.96u w=0 l=0
X298 4bitblock_LAST_0/1bitblock$1$4_0/a_510_63# B13.t3 GND GND nfet_03v3 ad=0.315p pd=2.26u as=0.28p ps=2.12u w=0 l=0
X299 4bitblock_0/1bitblock$1_0/a_160_63# A1.t1 GND GND nfet_03v3 ad=0.315p pd=2.26u as=0.325p ps=2.3u w=0 l=0
X300 4bitblock_LAST_0/1bitblock$7_0/a_705_407# A12.t4 VDD VDD pfet_03v3 ad=0.675p pd=2.675u as=0.725p ps=2.725u w=0 l=0
X301 4bitblock$2_0/1bitblock$5_0/a_160_63# A8.t1 GND GND nfet_03v3 ad=0.315p pd=2.26u as=0.325p ps=2.3u w=0 l=0
X302 N F.t2 XOR$9_0/a_870_n37# GND nfet_03v3 ad=0.3375p pd=1.675u as=0.3625p ps=1.725u w=0 l=0
X303 4bitblock$1_0/1bitblock$2$1_0/a_5768_63# S0.t98 VDD VDD pfet_03v3 ad=0.65p pd=3.3u as=0.635p ps=3.27u w=0 l=0
X304 4bitblock$1_0/1bitblock$1$1_0/a_9050_63# S1.t58 VDD VDD pfet_03v3 ad=0.64p pd=3.28u as=0.48p ps=2.96u w=0 l=0
X305 4bitblock$2_0/1bitblock$3$2_0/a_7768_n37# S0.t38 GND GND nfet_03v3 ad=0.3625p pd=1.725u as=0.54p ps=3.08u w=0 l=0
X306 4bitblock_0/1bitblock$1_0/a_5768_63# S0.t26 VDD VDD pfet_03v3 ad=0.65p pd=3.3u as=0.635p ps=3.27u w=0 l=0
X307 4bitblock$2_0/m1_13543_n1146# A11.t3 4bitblock$2_0/1bitblock$3$2_0/a_870_n37# GND nfet_03v3 ad=0.3375p pd=1.675u as=0.3625p ps=1.725u w=0 l=0
X308 4bitblock_0/1bitblock_0/a_8361_407# 4bitblock_0/m1_14167_n1145# 4bitblock_0/1bitblock_0/m2_7791_79# VDD.t13 pfet_03v3 ad=0.675p pd=2.675u as=0.725p ps=2.725u w=0 l=0
X309 4bitblock_0/m2_2396_n2595# A2.t3 4bitblock_0/1bitblock$2_0/a_870_n37# GND nfet_03v3 ad=0.3375p pd=1.675u as=0.3625p ps=1.725u w=0 l=0
X310 VDD A11.t5 4bitblock$2_0/1bitblock$3$2_0/a_1845_466# VDD pfet_03v3 ad=0.735p pd=2.47u as=0.42p ps=1.84u w=0 l=0
X311 4bitblock_LAST_0/1bitblock$2$4_0/a_1845_466# B14.t1 VDD VDD pfet_03v3 ad=0.42p pd=1.84u as=0.65p ps=3.3u w=0 l=0
X312 4bitblock$2_0/1bitblock$3$2_0/a_510_63# B11.t3 GND GND nfet_03v3 ad=0.315p pd=2.26u as=0.28p ps=2.12u w=0 l=0
X313 4bitblock_LAST_0/1bitblock$2$4_0/a_510_63# B14.t3 GND GND nfet_03v3 ad=0.315p pd=2.26u as=0.28p ps=2.12u w=0 l=0
X314 4bitblock$2_0/1bitblock$5_0/a_870_n37# B8.t5 GND GND nfet_03v3 ad=0.3625p pd=1.725u as=0.54p ps=3.08u w=0 l=0
X315 4bitblock$1_0/1bitblock$1$1_0/a_705_407# A5.t4 VDD VDD pfet_03v3 ad=0.675p pd=2.675u as=0.725p ps=2.725u w=0 l=0
X316 4bitblock_0/1bitblock_0/m2_9431_79# S1.t11 4bitblock_0/1bitblock_0/a_9609_407# VDD pfet_03v3 ad=0.725p pd=2.725u as=1.09p ps=5.09u w=0 l=0
X317 4bitblock$2_0/1bitblock$3$2_0/a_160_63# A11.t1 GND GND nfet_03v3 ad=0.315p pd=2.26u as=0.325p ps=2.3u w=0 l=0
X318 4bitblock_0/1bitblock$2_0/a_1845_n37# B2.t4 GND GND nfet_03v3 ad=0.42p pd=1.84u as=0.63p ps=3.26u w=0 l=0
X319 GND 4bitblock_0/1bitblock_0/a_7410_63# 4bitblock_0/1bitblock_0/a_8160_n37# GND.t24 nfet_03v3 ad=0.65p pd=3.3u as=0.3625p ps=1.725u w=0 l=0
X320 4bitblock$1_0/1bitblock$3$1_0/a_9050_63# S1.t62 VDD VDD pfet_03v3 ad=0.64p pd=3.28u as=0.48p ps=2.96u w=0 l=0
X321 4bitblock$2_0/MUX21$2_0/a_157_63# BP2.t0 VDD VDD pfet_03v3 ad=0.65p pd=3.3u as=0.635p ps=3.27u w=0 l=0
X322 4bitblock_0/MUX21_0/a_157_63# BP0.t3 GND GND nfet_03v3 ad=0.315p pd=2.26u as=0.3175p ps=2.27u w=0 l=0
X323 4bitblock_0/1bitblock$2_0/a_7410_63# S0.t1 GND GND nfet_03v3 ad=0.31p pd=2.24u as=0.24p ps=1.96u w=0 l=0
X324 4bitblock$1_0/1bitblock$2$1_0/a_6128_n37# S0.t99 GND GND nfet_03v3 ad=0.3625p pd=1.725u as=0.54p ps=3.08u w=0 l=0
X325 4bitblock_0/1bitblock_0/a_5243_407# 4bitblock_0/1bitblock_0/a_4290_63# 4bitblock_0/1bitblock_0/a_5042_407# VDD.t14 pfet_03v3 ad=1.3p pd=5.3u as=0.725p ps=2.725u w=0 l=0
X326 4bitblock$2_0/1bitblock$5_0/a_1845_466# B8.t1 VDD VDD pfet_03v3 ad=0.42p pd=1.84u as=0.65p ps=3.3u w=0 l=0
X327 4bitblock_0/1bitblock$3_0/a_9050_63# S1.t4 GND GND nfet_03v3 ad=0.31p pd=2.24u as=0.24p ps=1.96u w=0 l=0
X328 4bitblock_LAST_0/1bitblock$7_0/a_7410_63# S0.t81 GND GND nfet_03v3 ad=0.31p pd=2.24u as=0.24p ps=1.96u w=0 l=0
X329 4bitblock$2_0/1bitblock$5_0/a_510_63# B8.t3 GND GND nfet_03v3 ad=0.315p pd=2.26u as=0.28p ps=2.12u w=0 l=0
X330 VDD A2.t5 4bitblock_0/1bitblock$2_0/a_1845_466# VDD pfet_03v3 ad=0.735p pd=2.47u as=0.42p ps=1.84u w=0 l=0
X331 4bitblock$1_0/MUX21$1_0/a_517_n37# BP1.t3 GND GND nfet_03v3 ad=0.3625p pd=1.725u as=0.54p ps=3.08u w=0 l=0
X332 4bitblock$1_0/1bitblock$4_0/a_1845_n37# B4.t4 GND GND nfet_03v3 ad=0.42p pd=1.84u as=0.63p ps=3.26u w=0 l=0
X333 4bitblock$2_0/m1_14167_n1145# A8.t3 4bitblock$2_0/1bitblock$5_0/a_870_n37# GND nfet_03v3 ad=0.3375p pd=1.675u as=0.3625p ps=1.725u w=0 l=0
X334 4bitblock_0/1bitblock$2_0/a_160_63# A2.t2 VDD VDD pfet_03v3 ad=0.63p pd=3.26u as=0.65p ps=3.3u w=0 l=0
X335 4bitblock_0/1bitblock$2_0/m2_7791_79# S0.t7 4bitblock_0/1bitblock$2_0/a_8361_407# VDD pfet_03v3 ad=0.725p pd=2.725u as=1.09p ps=5.09u w=0 l=0
X336 4bitblock$1_0/1bitblock$2$1_0/a_9408_n37# S1.t49 GND GND nfet_03v3 ad=0.3625p pd=1.725u as=0.54p ps=3.08u w=0 l=0
X337 4bitblock$1_0/1bitblock$4_0/a_7410_63# S0.t105 GND GND nfet_03v3 ad=0.31p pd=2.24u as=0.24p ps=1.96u w=0 l=0
X338 4bitblock$2_0/1bitblock$3$2_0/m2_6151_79# S0.t37 4bitblock$2_0/1bitblock$3$2_0/a_6721_407# VDD pfet_03v3 ad=0.725p pd=2.725u as=1.09p ps=5.09u w=0 l=0
X339 4bitblock$1_0/1bitblock$2$1_0/a_5768_63# S0.t96 GND GND nfet_03v3 ad=0.315p pd=2.26u as=0.3175p ps=2.27u w=0 l=0
X340 4bitblock$1_0/1bitblock$1$1_0/a_870_n37# B5.t5 GND GND nfet_03v3 ad=0.3625p pd=1.725u as=0.54p ps=3.08u w=0 l=0
X341 GND 4bitblock_0/1bitblock_0/a_5768_63# 4bitblock_0/1bitblock_0/a_6520_n37# GND.t14 nfet_03v3 ad=0.65p pd=3.3u as=0.3625p ps=1.725u w=0 l=0
X342 4bitblock_0/1bitblock_0/a_6128_n37# S0.t19 GND GND nfet_03v3 ad=0.3625p pd=1.725u as=0.54p ps=3.08u w=0 l=0
X343 4bitblock_LAST_0/1bitblock$1$4_0/a_9408_n37# S1.t45 GND GND nfet_03v3 ad=0.3625p pd=1.725u as=0.54p ps=3.08u w=0 l=0
X344 4bitblock_0/1bitblock$2_0/a_510_63# B2.t2 VDD VDD pfet_03v3 ad=0.65p pd=3.3u as=0.56p ps=3.12u w=0 l=0
X345 VDD A4.t5 4bitblock$1_0/1bitblock$4_0/a_1845_466# VDD pfet_03v3 ad=0.735p pd=2.47u as=0.42p ps=1.84u w=0 l=0
X346 4bitblock_LAST_0/1bitblock$1$4_0/a_9050_63# S1.t46 VDD VDD pfet_03v3 ad=0.64p pd=3.28u as=0.48p ps=2.96u w=0 l=0
X347 AND4$4_0/a_912_n441# BP2.t5 AND4$4_0/a_704_n441# GND nfet_03v3 ad=0.76p pd=2.76u as=0.76p ps=2.76u w=0 l=0
X348 4bitblock_0/1bitblock_0/a_9609_407# 4bitblock_0/1bitblock_0/a_9050_63# VDD.t19 VDD.t18 pfet_03v3 ad=1.3p pd=5.3u as=0.725p ps=2.725u w=0 l=0
X349 4bitblock$1_0/1bitblock$3$1_0/a_160_63# A7.t1 GND GND nfet_03v3 ad=0.315p pd=2.26u as=0.325p ps=2.3u w=0 l=0
X350 4bitblock$2_0/1bitblock$3$2_0/m2_7791_79# S0.t39 4bitblock$2_0/1bitblock$3$2_0/a_8361_407# VDD pfet_03v3 ad=0.725p pd=2.725u as=1.09p ps=5.09u w=0 l=0
X351 4bitblock$1_0/1bitblock$1$1_0/a_1845_466# A5.t0 4bitblock$1_0/1bitblock$1$1_0/a_1845_n37# GND nfet_03v3 ad=0.65p pd=3.3u as=0.42p ps=1.84u w=0 l=0
X352 4bitblock$1_0/1bitblock$4_0/m2_7791_79# S0.t111 4bitblock$1_0/1bitblock$4_0/a_8361_407# VDD pfet_03v3 ad=0.725p pd=2.725u as=1.09p ps=5.09u w=0 l=0
X353 VDD B14.t0 4bitblock_LAST_0/1bitblock$2$4_0/a_705_407# VDD pfet_03v3 ad=0.725p pd=2.725u as=1.09p ps=5.09u w=0 l=0
X354 4bitblock_0/1bitblock$3_0/a_6128_n37# S0.t11 GND GND nfet_03v3 ad=0.3625p pd=1.725u as=0.54p ps=3.08u w=0 l=0
X355 4bitblock$2_0/1bitblock$3$2_0/a_705_407# A11.t4 VDD VDD pfet_03v3 ad=0.675p pd=2.675u as=0.725p ps=2.725u w=0 l=0
X356 4bitblock$2_0/1bitblock$1$2_0/a_9050_63# S1.t28 GND GND nfet_03v3 ad=0.31p pd=2.24u as=0.24p ps=1.96u w=0 l=0
X357 4bitblock$1_0/1bitblock$3$1_0/a_510_63# B7.t2 VDD VDD pfet_03v3 ad=0.65p pd=3.3u as=0.56p ps=3.12u w=0 l=0
X358 4bitblock$2_0/1bitblock$3$2_0/a_7410_63# S0.t36 VDD VDD pfet_03v3 ad=0.64p pd=3.28u as=0.48p ps=2.96u w=0 l=0
X359 4bitblock$2_0/1bitblock$3$2_0/a_9408_n37# S1.t17 GND GND nfet_03v3 ad=0.3625p pd=1.725u as=0.54p ps=3.08u w=0 l=0
X360 4bitblock_0/MUX21_0/m2_540_79# Cin.t1 4bitblock_0/MUX21_0/a_517_n37# GND nfet_03v3 ad=0.3375p pd=1.675u as=0.3625p ps=1.725u w=0 l=0
X361 4bitblock$1_0/1bitblock$4_0/a_510_63# B4.t2 VDD VDD pfet_03v3 ad=0.65p pd=3.3u as=0.56p ps=3.12u w=0 l=0
X362 4bitblock$1_0/1bitblock$3$1_0/a_870_n37# B7.t5 GND GND nfet_03v3 ad=0.3625p pd=1.725u as=0.54p ps=3.08u w=0 l=0
X363 4bitblock_LAST_0/1bitblock$2$4_0/a_7410_63# S0.t76 VDD VDD pfet_03v3 ad=0.64p pd=3.28u as=0.48p ps=2.96u w=0 l=0
X364 4bitblock_LAST_0/1bitblock$1$4_0/a_160_63# A13.t2 VDD VDD pfet_03v3 ad=0.63p pd=3.26u as=0.65p ps=3.3u w=0 l=0
X365 4bitblock_0/1bitblock$2_0/a_705_407# A2.t4 VDD VDD pfet_03v3 ad=0.675p pd=2.675u as=0.725p ps=2.725u w=0 l=0
X366 4bitblock_0/1bitblock$3_0/a_1845_n37# B3.t4 GND GND nfet_03v3 ad=0.42p pd=1.84u as=0.63p ps=3.26u w=0 l=0
X367 4bitblock$1_0/1bitblock$3$1_0/a_160_63# A7.t2 VDD VDD pfet_03v3 ad=0.63p pd=3.26u as=0.65p ps=3.3u w=0 l=0
X368 4bitblock$2_0/1bitblock$2$2_0/a_1845_n37# B10.t4 GND GND nfet_03v3 ad=0.42p pd=1.84u as=0.63p ps=3.26u w=0 l=0
X369 4bitblock_0/1bitblock$3_0/a_9408_n37# S1.t5 GND GND nfet_03v3 ad=0.3625p pd=1.725u as=0.54p ps=3.08u w=0 l=0
X370 4bitblock_LAST_0/1bitblock$3$4_0/a_9050_63# S1.t34 VDD VDD pfet_03v3 ad=0.64p pd=3.28u as=0.48p ps=2.96u w=0 l=0
X371 4bitblock$1_0/1bitblock$3$1_0/a_1845_466# A7.t0 4bitblock$1_0/1bitblock$3$1_0/a_1845_n37# GND nfet_03v3 ad=0.65p pd=3.3u as=0.42p ps=1.84u w=0 l=0
X372 4bitblock_LAST_0/1bitblock$2$4_0/a_1845_466# A14.t0 4bitblock_LAST_0/1bitblock$2$4_0/a_1845_n37# GND nfet_03v3 ad=0.65p pd=3.3u as=0.42p ps=1.84u w=0 l=0
X373 VDD B8.t0 4bitblock$2_0/1bitblock$5_0/a_705_407# VDD pfet_03v3 ad=0.725p pd=2.725u as=1.09p ps=5.09u w=0 l=0
X374 4bitblock$2_0/1bitblock$1$2_0/a_6128_n37# S0.t59 GND GND nfet_03v3 ad=0.3625p pd=1.725u as=0.54p ps=3.08u w=0 l=0
X375 4bitblock$2_0/1bitblock$1$2_0/a_160_63# A9.t1 GND GND nfet_03v3 ad=0.315p pd=2.26u as=0.325p ps=2.3u w=0 l=0
X376 4bitblock$2_0/1bitblock$2$2_0/a_5768_63# S0.t42 VDD VDD pfet_03v3 ad=0.65p pd=3.3u as=0.635p ps=3.27u w=0 l=0
X377 4bitblock_0/1bitblock_0/a_8361_407# 4bitblock_0/1bitblock_0/a_7410_63# VDD.t21 VDD.t20 pfet_03v3 ad=1.3p pd=5.3u as=0.725p ps=2.725u w=0 l=0
X378 4bitblock_0/1bitblock$2_0/a_160_63# A2.t1 GND GND nfet_03v3 ad=0.315p pd=2.26u as=0.325p ps=2.3u w=0 l=0
X379 4bitblock$2_0/1bitblock$5_0/a_7410_63# S0.t52 VDD VDD pfet_03v3 ad=0.64p pd=3.28u as=0.48p ps=2.96u w=0 l=0
X380 4bitblock_0/m2_1701_n784# A1.t3 4bitblock_0/1bitblock$1_0/a_870_n37# GND nfet_03v3 ad=0.3375p pd=1.675u as=0.3625p ps=1.725u w=0 l=0
X381 4bitblock$2_0/1bitblock$1$2_0/a_7768_n37# S0.t62 GND GND nfet_03v3 ad=0.3625p pd=1.725u as=0.54p ps=3.08u w=0 l=0
X382 4bitblock_LAST_0/1bitblock$1$4_0/a_510_63# B13.t2 VDD VDD pfet_03v3 ad=0.65p pd=3.3u as=0.56p ps=3.12u w=0 l=0
X383 4bitblock_0/1bitblock$1_0/m2_7791_79# S0.t31 4bitblock_0/1bitblock$1_0/a_8361_407# VDD pfet_03v3 ad=0.725p pd=2.725u as=1.09p ps=5.09u w=0 l=0
X384 4bitblock_0/1bitblock_0/a_1845_466# A0.t0 4bitblock_0/1bitblock_0/a_1845_n37# GND.t20 nfet_03v3 ad=0.65p pd=3.3u as=0.42p ps=1.84u w=0 l=0
X385 4bitblock_0/1bitblock_0/a_4290_63# Cin.t3 GND GND nfet_03v3 ad=0.315p pd=2.26u as=0.28p ps=2.12u w=0 l=0
X386 4bitblock$1_0/1bitblock$2$1_0/m2_6151_79# S0.t101 4bitblock$1_0/1bitblock$2$1_0/a_6721_407# VDD pfet_03v3 ad=0.725p pd=2.725u as=1.09p ps=5.09u w=0 l=0
X387 4bitblock_0/1bitblock$1_0/a_9050_63# S1.t12 GND GND nfet_03v3 ad=0.31p pd=2.24u as=0.24p ps=1.96u w=0 l=0
X388 4bitblock$2_0/m2_1701_n784# A9.t3 4bitblock$2_0/1bitblock$1$2_0/a_870_n37# GND nfet_03v3 ad=0.3375p pd=1.675u as=0.3625p ps=1.725u w=0 l=0
X389 4bitblock_0/1bitblock_0/a_7768_n37# S0.t22 GND GND nfet_03v3 ad=0.3625p pd=1.725u as=0.54p ps=3.08u w=0 l=0
X390 4bitblock$1_0/1bitblock$1$1_0/a_1845_466# B5.t1 VDD VDD pfet_03v3 ad=0.42p pd=1.84u as=0.65p ps=3.3u w=0 l=0
X391 4bitblock$2_0/1bitblock$5_0/a_1845_466# A8.t0 4bitblock$2_0/1bitblock$5_0/a_1845_n37# GND nfet_03v3 ad=0.65p pd=3.3u as=0.42p ps=1.84u w=0 l=0
X392 4bitblock_0/1bitblock$2_0/a_510_63# B2.t3 GND GND nfet_03v3 ad=0.315p pd=2.26u as=0.28p ps=2.12u w=0 l=0
X393 VDD A9.t5 4bitblock$2_0/1bitblock$1$2_0/a_1845_466# VDD pfet_03v3 ad=0.735p pd=2.47u as=0.42p ps=1.84u w=0 l=0
X394 4bitblock$1_0/1bitblock$2$1_0/a_9050_63# S1.t50 VDD VDD pfet_03v3 ad=0.64p pd=3.28u as=0.48p ps=2.96u w=0 l=0
X395 4bitblock$1_0/1bitblock$3$1_0/a_1845_466# B7.t1 VDD VDD pfet_03v3 ad=0.42p pd=1.84u as=0.65p ps=3.3u w=0 l=0
X396 4bitblock$2_0/1bitblock$1$2_0/a_510_63# B9.t3 GND GND nfet_03v3 ad=0.315p pd=2.26u as=0.28p ps=2.12u w=0 l=0
X397 4bitblock_LAST_0/1bitblock$1$4_0/a_7410_63# S0.t89 GND GND nfet_03v3 ad=0.31p pd=2.24u as=0.24p ps=1.96u w=0 l=0
X398 4bitblock$2_0/1bitblock$5_0/a_705_407# A8.t4 VDD VDD pfet_03v3 ad=0.675p pd=2.675u as=0.725p ps=2.725u w=0 l=0
X399 4bitblock_0/1bitblock$2_0/a_5768_63# S0.t2 VDD VDD pfet_03v3 ad=0.65p pd=3.3u as=0.635p ps=3.27u w=0 l=0
X400 4bitblock_0/1bitblock$1_0/a_9050_63# S1.t14 VDD VDD pfet_03v3 ad=0.64p pd=3.28u as=0.48p ps=2.96u w=0 l=0
X401 4bitblock$1_0/1bitblock$2$1_0/m2_9431_79# S1.t51 4bitblock$1_0/1bitblock$2$1_0/a_9609_407# VDD pfet_03v3 ad=0.725p pd=2.725u as=1.09p ps=5.09u w=0 l=0
X402 4bitblock_0/1bitblock$3_0/a_160_63# A3.t2 VDD VDD pfet_03v3 ad=0.63p pd=3.26u as=0.65p ps=3.3u w=0 l=0
X403 4bitblock_0/1bitblock_0/a_2861_3# 4bitblock_0/1bitblock_0/a_2419_63# 4bitblock_0/1bitblock_0/a_2861_391# VDD.t1 pfet_03v3 ad=1.3p pd=5.3u as=0.725p ps=2.725u w=0 l=0
X404 4bitblock_0/1bitblock_0/a_6721_407# 4bitblock_0/1bitblock_0/a_5768_63# VDD.t16 VDD.t15 pfet_03v3 ad=1.3p pd=5.3u as=0.725p ps=2.725u w=0 l=0
X405 4bitblock$1_0/1bitblock$4_0/a_510_63# B4.t3 GND GND nfet_03v3 ad=0.315p pd=2.26u as=0.28p ps=2.12u w=0 l=0
X406 VDD A7.t5 4bitblock$1_0/1bitblock$3$1_0/a_1845_466# VDD pfet_03v3 ad=0.735p pd=2.47u as=0.42p ps=1.84u w=0 l=0
X407 4bitblock_0/1bitblock$1_0/a_1845_466# A1.t0 4bitblock_0/1bitblock$1_0/a_1845_n37# GND nfet_03v3 ad=0.65p pd=3.3u as=0.42p ps=1.84u w=0 l=0
X408 4bitblock_LAST_0/1bitblock$3$4_0/a_510_63# B15.t2 VDD VDD pfet_03v3 ad=0.65p pd=3.3u as=0.56p ps=3.12u w=0 l=0
X409 AND4$4_0/a_518_229# BP0.t4 AND4$4_0/a_1120_n441# GND nfet_03v3 ad=1.14p pd=5.14u as=0.76p ps=2.76u w=0 l=0
X410 4bitblock_LAST_0/1bitblock$2$4_0/a_7410_63# S0.t73 GND GND nfet_03v3 ad=0.31p pd=2.24u as=0.24p ps=1.96u w=0 l=0
X411 4bitblock$2_0/1bitblock$3$2_0/a_7410_63# S0.t33 GND GND nfet_03v3 ad=0.31p pd=2.24u as=0.24p ps=1.96u w=0 l=0
X412 4bitblock_0/1bitblock$3_0/m2_6151_79# S0.t13 4bitblock_0/1bitblock$3_0/a_6721_407# VDD pfet_03v3 ad=0.725p pd=2.725u as=1.09p ps=5.09u w=0 l=0
X413 4bitblock$1_0/1bitblock$4_0/a_5768_63# S0.t106 VDD VDD pfet_03v3 ad=0.65p pd=3.3u as=0.635p ps=3.27u w=0 l=0
X414 4bitblock_0/1bitblock$1_0/a_705_407# A1.t4 VDD VDD pfet_03v3 ad=0.675p pd=2.675u as=0.725p ps=2.725u w=0 l=0
X415 4bitblock$2_0/1bitblock$3$2_0/m2_9431_79# S1.t19 4bitblock$2_0/1bitblock$3$2_0/a_9609_407# VDD pfet_03v3 ad=0.725p pd=2.725u as=1.09p ps=5.09u w=0 l=0
X416 4bitblock_LAST_0/1bitblock$3$4_0/a_160_63# A15.t2 VDD VDD pfet_03v3 ad=0.63p pd=3.26u as=0.65p ps=3.3u w=0 l=0
X417 4bitblock_LAST_0/1bitblock$3$4_0/a_9050_63# S1.t32 GND GND nfet_03v3 ad=0.31p pd=2.24u as=0.24p ps=1.96u w=0 l=0
X418 XOR$9_0/a_160_63# F.t1 VDD VDD pfet_03v3 ad=0.63p pd=3.26u as=0.65p ps=3.3u w=0 l=0
X419 4bitblock_0/1bitblock$1_0/a_9408_n37# S1.t13 GND GND nfet_03v3 ad=0.3625p pd=1.725u as=0.54p ps=3.08u w=0 l=0
X420 4bitblock_LAST_0/1bitblock$1$4_0/a_870_n37# B13.t5 GND GND nfet_03v3 ad=0.3625p pd=1.725u as=0.54p ps=3.08u w=0 l=0
X421 4bitblock_0/1bitblock$2_0/a_6128_n37# S0.t3 GND GND nfet_03v3 ad=0.3625p pd=1.725u as=0.54p ps=3.08u w=0 l=0
X422 4bitblock$2_0/1bitblock$2$2_0/a_5768_63# S0.t40 GND GND nfet_03v3 ad=0.315p pd=2.26u as=0.3175p ps=2.27u w=0 l=0
X423 4bitblock_0/1bitblock$3_0/m2_9431_79# S1.t7 4bitblock_0/1bitblock$3_0/a_9609_407# VDD pfet_03v3 ad=0.725p pd=2.725u as=1.09p ps=5.09u w=0 l=0
X424 4bitblock$2_0/1bitblock$5_0/a_7410_63# S0.t49 GND GND nfet_03v3 ad=0.31p pd=2.24u as=0.24p ps=1.96u w=0 l=0
X425 4bitblock$1_0/1bitblock$1$1_0/m2_6151_79# S0.t117 4bitblock$1_0/1bitblock$1$1_0/a_6721_407# VDD pfet_03v3 ad=0.725p pd=2.725u as=1.09p ps=5.09u w=0 l=0
X426 4bitblock$1_0/1bitblock$2$1_0/a_870_n37# B6.t5 GND GND nfet_03v3 ad=0.3625p pd=1.725u as=0.54p ps=3.08u w=0 l=0
X427 4bitblock_LAST_0/1bitblock$7_0/a_1845_n37# B12.t4 GND GND nfet_03v3 ad=0.42p pd=1.84u as=0.63p ps=3.26u w=0 l=0
X428 4bitblock$2_0/1bitblock$3$2_0/a_870_n37# B11.t5 GND GND nfet_03v3 ad=0.3625p pd=1.725u as=0.54p ps=3.08u w=0 l=0
X429 4bitblock_LAST_0/1bitblock$3$4_0/a_6128_n37# S0.t67 GND GND nfet_03v3 ad=0.3625p pd=1.725u as=0.54p ps=3.08u w=0 l=0
X430 4bitblock_0/1bitblock$2_0/a_9408_n37# S1.t1 GND GND nfet_03v3 ad=0.3625p pd=1.725u as=0.54p ps=3.08u w=0 l=0
X431 4bitblock$1_0/1bitblock$4_0/a_6128_n37# S0.t107 GND GND nfet_03v3 ad=0.3625p pd=1.725u as=0.54p ps=3.08u w=0 l=0
X432 4bitblock$1_0/1bitblock$2$1_0/a_9050_63# S1.t48 GND GND nfet_03v3 ad=0.31p pd=2.24u as=0.24p ps=1.96u w=0 l=0
X433 4bitblock_LAST_0/1bitblock$1$4_0/a_1845_466# B13.t1 VDD VDD pfet_03v3 ad=0.42p pd=1.84u as=0.65p ps=3.3u w=0 l=0
X434 4bitblock$1_0/1bitblock$2$1_0/a_1845_466# A6.t0 4bitblock$1_0/1bitblock$2$1_0/a_1845_n37# GND nfet_03v3 ad=0.65p pd=3.3u as=0.42p ps=1.84u w=0 l=0
X435 4bitblock_0/1bitblock$2_0/a_5768_63# S0.t0 GND GND nfet_03v3 ad=0.315p pd=2.26u as=0.3175p ps=2.27u w=0 l=0
X436 4bitblock$1_0/1bitblock$3$1_0/m2_6151_79# S0.t125 4bitblock$1_0/1bitblock$3$1_0/a_6721_407# VDD pfet_03v3 ad=0.725p pd=2.725u as=1.09p ps=5.09u w=0 l=0
X437 4bitblock$1_0/1bitblock$4_0/a_160_63# A4.t2 VDD VDD pfet_03v3 ad=0.63p pd=3.26u as=0.65p ps=3.3u w=0 l=0
X438 4bitblock_LAST_0/1bitblock$3$4_0/a_1845_466# B15.t1 VDD VDD pfet_03v3 ad=0.42p pd=1.84u as=0.65p ps=3.3u w=0 l=0
X439 4bitblock_0/1bitblock_0/a_705_407# A0.t4 VDD.t4 VDD.t3 pfet_03v3 ad=0.675p pd=2.675u as=0.725p ps=2.725u w=0 l=0
X440 4bitblock_0/m1_14167_n1145# A0.t3 4bitblock_0/1bitblock_0/a_870_n37# GND.t7 nfet_03v3 ad=0.3375p pd=1.675u as=0.3625p ps=1.725u w=0 l=0
X441 4bitblock$2_0/1bitblock$1$2_0/a_9408_n37# S1.t29 GND GND nfet_03v3 ad=0.3625p pd=1.725u as=0.54p ps=3.08u w=0 l=0
X442 4bitblock$1_0/1bitblock$1$1_0/m2_9431_79# S1.t59 4bitblock$1_0/1bitblock$1$1_0/a_9609_407# VDD pfet_03v3 ad=0.725p pd=2.725u as=1.09p ps=5.09u w=0 l=0
X443 XOR$9_0/a_705_407# F.t3 VDD VDD pfet_03v3 ad=0.675p pd=2.675u as=0.725p ps=2.725u w=0 l=0
R0 GND.n111 GND.n96 2.66266e+06
R1 GND.n148 GND.n124 2.66266e+06
R2 GND.n80 GND.n48 2.66266e+06
R3 GND.n93 GND.n76 855962
R4 GND.n108 GND.n70 855962
R5 GND.n139 GND.n69 855962
R6 GND.n111 GND.n108 796250
R7 GND.n148 GND.n69 796250
R8 GND.n76 GND.n48 796250
R9 GND.n83 GND.n76 494214
R10 GND.n108 GND.n107 494214
R11 GND.n130 GND.n69 494214
R12 GND.n156 GND.n155 344714
R13 GND.n79 GND.n47 234914
R14 GND.n155 GND.n64 113659
R15 GND.n53 GND.n52 14513.7
R16 GND.n72 GND.n71 14513.7
R17 GND.n144 GND.n127 14513.7
R18 GND.n85 GND.n81 14337.3
R19 GND.n104 GND.n99 14337.3
R20 GND.n129 GND.n128 14337.3
R21 GND.n63 GND.n62 14337.3
R22 GND.n172 GND.n171 13245.8
R23 GND.n118 GND.n117 13245.8
R24 GND.n145 GND.n125 13245.8
R25 GND.n86 GND.n84 13084.4
R26 GND.n98 GND.n97 13084.4
R27 GND.n134 GND.n133 13084.4
R28 GND.n159 GND.n158 13084.4
R29 GND.n140 GND.n64 11891.4
R30 GND.n93 GND.n92 10940.6
R31 GND.n100 GND.n70 10940.6
R32 GND.n139 GND.n138 10940.6
R33 GND.n96 GND.n95 10697.7
R34 GND.n124 GND.n123 10697.7
R35 GND.n80 GND.n79 10697.7
R36 GND.n92 GND.n80 10695.2
R37 GND.n100 GND.n96 10695.2
R38 GND.n138 GND.n124 10695.2
R39 GND.n95 GND.n93 10587.1
R40 GND.n123 GND.n70 10587.1
R41 GND.n140 GND.n139 10587.1
R42 GND.n64 GND.n61 10113.6
R43 GND.n155 GND.n154 9162.05
R44 GND.n178 GND.n177 8298.3
R45 GND.n175 GND.n50 5977.31
R46 GND.n114 GND.n113 5977.31
R47 GND.n148 GND.n147 5977.31
R48 GND.n110 GND.n109 5303.35
R49 GND.n109 GND.n75 5029.7
R50 GND.n109 GND.n66 4723.58
R51 GND.n73 GND.n66 4100.07
R52 GND.n176 GND.n49 3862.92
R53 GND.n178 GND.n47 2590.73
R54 GND.n154 GND.n153 2439.38
R55 GND.n174 GND.n49 2228.44
R56 GND.n153 GND.n66 2156.24
R57 GND.n176 GND.n175 1524.9
R58 GND.n113 GND.n112 1399.13
R59 GND.n181 GND.t9 1208.4
R60 GND.n23 GND.n1 1167
R61 GND.n11 GND.n6 1164.41
R62 GND.t1 GND.n44 1143.71
R63 GND.n37 GND.n36 1143.71
R64 GND.t4 GND.n34 1143.71
R65 GND.n46 GND.n45 1128.18
R66 GND.n36 GND.n35 1128.18
R67 GND.n154 GND.n65 1118.53
R68 GND.n149 GND.n148 1012.06
R69 GND.n22 GND.n21 936.705
R70 GND.n18 GND.n17 936.705
R71 GND.n14 GND.n13 936.705
R72 GND.t0 GND.n11 931.529
R73 GND.t8 GND.n38 931.529
R74 GND.t27 GND.n19 926.355
R75 GND.t10 GND.n15 926.355
R76 GND.n24 GND.n23 918.591
R77 GND.n110 GND.n49 917.939
R78 GND.n44 GND.n43 905.654
R79 GND.n38 GND.n37 905.654
R80 GND.n34 GND.n33 905.654
R81 GND.n19 GND.n18 846.139
R82 GND.n15 GND.n14 846.139
R83 GND.n112 GND.n111 833.524
R84 GND.n95 GND.n94 727.111
R85 GND.n123 GND.n122 727.111
R86 GND.n141 GND.n140 727.111
R87 GND.n79 GND.n78 727.111
R88 GND.n111 GND.n110 718.17
R89 GND.n92 GND.n91 710.859
R90 GND.n103 GND.n100 710.859
R91 GND.n138 GND.n137 710.859
R92 GND.n43 GND.t9 579.619
R93 GND.n33 GND.t20 579.619
R94 GND.n32 GND.n31 566.681
R95 GND.n45 GND.t1 520.105
R96 GND.n21 GND.t21 520.105
R97 GND.n20 GND.t27 520.105
R98 GND.n17 GND.t24 520.105
R99 GND.n16 GND.t10 520.105
R100 GND.n13 GND.t14 520.105
R101 GND.n12 GND.t0 520.105
R102 GND.n40 GND.t11 520.105
R103 GND.n39 GND.t8 520.105
R104 GND.n35 GND.t4 520.105
R105 GND.t21 GND.n20 494.228
R106 GND.t24 GND.n16 494.228
R107 GND.t14 GND.n12 494.228
R108 GND.t11 GND.n39 494.228
R109 GND.n47 GND.n46 491.64
R110 GND.n25 GND.n24 483.877
R111 GND.n28 GND.n27 460.589
R112 GND.n177 GND.n48 449.048
R113 GND.t7 GND.n26 442.476
R114 GND.n112 GND.n75 441.329
R115 GND.t20 GND.n32 411.425
R116 GND.n74 GND.n73 394.988
R117 GND.t17 GND.n29 367.437
R118 GND.n31 GND.n30 349.324
R119 GND.n175 GND.n174 348.524
R120 GND.n119 GND.n74 294.312
R121 GND.n177 GND.n176 227.77
R122 GND.n149 GND.n65 219.095
R123 GND.n180 GND.n22 191.482
R124 GND.n41 GND.n40 188.893
R125 GND.n30 GND.t17 170.78
R126 GND.n29 GND.n28 77.6279
R127 GND.n27 GND.t7 59.5148
R128 GND.n26 GND.n25 36.2266
R129 GND.n113 GND.n74 26.043
R130 GND.n147 GND.n146 18.7035
R131 GND.n132 GND.n130 18.7035
R132 GND.n135 GND.n134 18.7035
R133 GND.n116 GND.n114 18.7035
R134 GND.n107 GND.n106 18.7035
R135 GND.n101 GND.n97 18.7035
R136 GND.n170 GND.n50 18.7035
R137 GND.n87 GND.n83 18.7035
R138 GND.n84 GND.n82 18.7035
R139 GND.n157 GND.n156 18.7035
R140 GND.n160 GND.n159 18.7035
R141 GND.n75 GND.n67 16.0775
R142 GND.n73 GND.n67 13.8553
R143 GND.n182 GND.n181 12.7557
R144 GND.n186 GND.n6 10.6172
R145 GND.n146 GND.n145 10.6172
R146 GND.n133 GND.n132 10.6172
R147 GND.n135 GND.n129 10.6172
R148 GND.n117 GND.n116 10.6172
R149 GND.n120 GND.n72 10.6172
R150 GND.n119 GND.n118 10.6172
R151 GND.n106 GND.n98 10.6172
R152 GND.n101 GND.n99 10.6172
R153 GND.n171 GND.n170 10.6172
R154 GND.n52 GND.n51 10.6172
R155 GND.n173 GND.n172 10.6172
R156 GND.n87 GND.n86 10.6172
R157 GND.n85 GND.n82 10.6172
R158 GND.n42 GND.n41 10.6172
R159 GND.n180 GND.n179 10.6172
R160 GND.n144 GND.n143 10.6172
R161 GND.n125 GND.n68 10.6172
R162 GND.n151 GND.n65 10.6172
R163 GND.n158 GND.n157 10.6172
R164 GND.n160 GND.n63 10.6172
R165 GND.n127 GND.n126 10.59
R166 GND.n131 GND.n128 10.59
R167 GND.n137 GND.n136 10.59
R168 GND.n115 GND.n71 10.59
R169 GND.n122 GND.n121 10.59
R170 GND.n105 GND.n104 10.59
R171 GND.n103 GND.n102 10.59
R172 GND.n169 GND.n53 10.59
R173 GND.n94 GND.n54 10.59
R174 GND.n88 GND.n81 10.59
R175 GND.n91 GND.n90 10.59
R176 GND.n78 GND.n77 10.59
R177 GND.n142 GND.n141 10.59
R178 GND.n62 GND.n60 10.59
R179 GND.n161 GND.n61 10.59
R180 GND.n191 GND.n1 10.59
R181 GND.n84 GND.n83 10.2287
R182 GND.n86 GND.n85 10.2287
R183 GND.n91 GND.n81 10.2287
R184 GND.n107 GND.n97 10.2287
R185 GND.n99 GND.n98 10.2287
R186 GND.n104 GND.n103 10.2287
R187 GND.n134 GND.n130 10.2287
R188 GND.n133 GND.n129 10.2287
R189 GND.n137 GND.n128 10.2287
R190 GND.n159 GND.n156 10.2287
R191 GND.n158 GND.n63 10.2287
R192 GND.n62 GND.n61 10.2287
R193 GND.n190 GND.n2 10.0847
R194 GND.n187 GND.n5 10.0847
R195 GND.n132 GND.n131 8.97115
R196 GND.n116 GND.n115 8.97115
R197 GND.n106 GND.n105 8.97115
R198 GND.n170 GND.n169 8.97115
R199 GND.n88 GND.n87 8.97115
R200 GND.n157 GND.n60 8.97115
R201 GND.n146 GND.n126 8.97115
R202 GND.n136 GND.n135 8.97115
R203 GND.n121 GND.n120 8.97115
R204 GND.n102 GND.n101 8.97115
R205 GND.n54 GND.n51 8.97115
R206 GND.n90 GND.n82 8.97115
R207 GND.n77 GND.n42 8.97115
R208 GND.n143 GND.n142 8.97115
R209 GND.n161 GND.n160 8.97115
R210 GND.n120 GND.n119 8.08681
R211 GND.n173 GND.n51 8.08681
R212 GND.n179 GND.n42 8.08681
R213 GND.n143 GND.n68 8.08681
R214 GND.n163 GND.n162 7.98353
R215 GND.n55 GND.n0 7.97896
R216 GND.n174 GND.n173 7.84655
R217 GND.n184 GND.n8 7.68721
R218 GND.n182 GND.n10 7.68721
R219 GND.n188 GND.n4 7.62421
R220 GND.n152 GND.n151 7.18633
R221 GND.n189 GND.n3 6.77556
R222 GND.n179 GND.n178 6.67446
R223 GND.n152 GND.n67 6.64959
R224 GND.n150 GND.n68 6.6018
R225 GND.n185 GND.n7 6.44669
R226 GND.n183 GND.n9 6.44669
R227 GND.n172 GND.n50 5.17566
R228 GND.n171 GND.n52 5.17566
R229 GND.n94 GND.n53 5.17566
R230 GND.n118 GND.n114 5.17566
R231 GND.n117 GND.n72 5.17566
R232 GND.n122 GND.n71 5.17566
R233 GND.n147 GND.n125 5.17566
R234 GND.n145 GND.n144 5.17566
R235 GND.n141 GND.n127 5.17566
R236 GND.n181 GND.n180 5.17566
R237 GND.n41 GND.n6 5.17566
R238 GND.n78 GND.n1 5.17566
R239 GND.n164 GND.n58 4.79841
R240 GND.n166 GND.n56 4.79841
R241 GND.n89 GND.n55 4.79841
R242 GND.n165 GND.n57 4.79383
R243 GND.n168 GND.n167 4.79383
R244 GND.n163 GND.n59 4.79383
R245 GND.n188 GND.n187 3.91746
R246 GND.n153 GND.n152 3.71467
R247 GND.n150 GND.n149 3.71467
R248 GND.n167 GND.n55 3.40074
R249 GND.n166 GND.n165 3.40074
R250 GND.n164 GND.n163 3.40074
R251 GND.n167 GND.n166 3.18562
R252 GND.n165 GND.n164 3.18562
R253 GND.n186 GND.n185 2.80811
R254 GND.n187 GND.n186 2.14093
R255 GND.n184 GND.n183 2.08811
R256 GND.n189 GND.n188 1.57746
R257 GND.n191 GND.n190 0.773326
R258 GND.n190 GND.n189 0.563978
R259 GND.n151 GND.n150 0.558109
R260 GND.n185 GND.n184 0.526804
R261 GND.n183 GND.n182 0.526804
R262 GND.n121 GND.n57 0.439861
R263 GND.n168 GND.n54 0.439861
R264 GND.n77 GND.n0 0.439861
R265 GND.n142 GND.n59 0.439861
R266 GND.n126 GND.n59 0.421274
R267 GND.n115 GND.n57 0.421274
R268 GND.n169 GND.n168 0.421274
R269 GND.n131 GND.n58 0.403624
R270 GND.n105 GND.n56 0.403624
R271 GND.n89 GND.n88 0.403624
R272 GND.n162 GND.n60 0.403624
R273 GND.n136 GND.n58 0.382236
R274 GND.n102 GND.n56 0.382236
R275 GND.n90 GND.n89 0.382236
R276 GND.n162 GND.n161 0.382236
R277 GND GND.n0 0.335188
R278 GND GND.n191 0.086587
R279 BP0.n1 BP0.n0 61.6449
R280 BP0.n3 BP0.t4 43.7679
R281 BP0.n0 BP0.t1 39.8898
R282 BP0.n4 BP0.n3 38.4223
R283 BP0.n0 BP0.t2 31.0255
R284 BP0.n1 BP0.t0 25.8112
R285 BP0.n3 BP0.t5 25.2572
R286 BP0.n4 BP0.n2 25.144
R287 BP0.n2 BP0.t3 22.6984
R288 BP0.n2 BP0.n1 4.96987
R289 BP0 BP0.n4 4.55688
R290 VDD.n37 VDD.t10 724.032
R291 VDD.n61 VDD.n60 712.12
R292 VDD.n45 VDD.n2 697.674
R293 VDD.n24 VDD.t0 685.271
R294 VDD.n50 VDD.n49 685.271
R295 VDD.n52 VDD.t1 685.271
R296 VDD.n23 VDD.n22 675.97
R297 VDD.n51 VDD.n50 675.97
R298 VDD.n36 VDD.n35 561.24
R299 VDD.n32 VDD.n31 561.24
R300 VDD.n28 VDD.n27 561.24
R301 VDD.t2 VDD.n2 558.14
R302 VDD.n48 VDD.t8 558.14
R303 VDD.t22 VDD.n33 555.039
R304 VDD.t13 VDD.n29 555.039
R305 VDD.n60 VDD.n59 550.389
R306 VDD.n25 VDD.n24 542.636
R307 VDD.n49 VDD.n48 542.636
R308 VDD.n53 VDD.n52 542.636
R309 VDD.n33 VDD.n32 506.978
R310 VDD.n29 VDD.n28 506.978
R311 VDD.t10 VDD.n25 347.288
R312 VDD.t5 VDD.n53 347.288
R313 VDD.n55 VDD.n54 339.536
R314 VDD.t0 VDD.n23 311.628
R315 VDD.n35 VDD.t18 311.628
R316 VDD.n34 VDD.t22 311.628
R317 VDD.n31 VDD.t20 311.628
R318 VDD.n30 VDD.t13 311.628
R319 VDD.n27 VDD.t15 311.628
R320 VDD.n26 VDD.t2 311.628
R321 VDD.t14 VDD.n46 311.628
R322 VDD.t8 VDD.n47 311.628
R323 VDD.t1 VDD.n51 311.628
R324 VDD.t18 VDD.n34 296.125
R325 VDD.t20 VDD.n30 296.125
R326 VDD.t15 VDD.n26 296.125
R327 VDD.n47 VDD.t14 296.125
R328 VDD.n59 VDD.n58 289.923
R329 VDD.t3 VDD.n57 275.969
R330 VDD.n58 VDD.t3 265.116
R331 VDD.n54 VDD.t5 246.512
R332 VDD.n57 VDD.t17 220.155
R333 VDD.n56 VDD.n55 209.303
R334 VDD.n37 VDD.n36 117.829
R335 VDD.n46 VDD.n45 116.279
R336 VDD.t17 VDD.n56 102.326
R337 VDD.n45 VDD.n44 12.8954
R338 VDD.n38 VDD.n37 12.8954
R339 VDD.n42 VDD.n15 10.2587
R340 VDD.n40 VDD.n18 10.2587
R341 VDD.n38 VDD.n21 9.5865
R342 VDD.n1 VDD.n0 9.58202
R343 VDD.n11 VDD.n10 9.58202
R344 VDD.n7 VDD.n6 9.03691
R345 VDD.n9 VDD.n8 8.44781
R346 VDD.n5 VDD.n4 5.47481
R347 VDD.n12 VDD.t9 3.31133
R348 VDD.n11 VDD.n9 3.09572
R349 VDD.n43 VDD.n14 1.98133
R350 VDD.n41 VDD.n17 1.98133
R351 VDD.n39 VDD.n20 1.98133
R352 VDD.n44 VDD.n43 1.86898
R353 VDD.n42 VDD.n41 1.67137
R354 VDD.n40 VDD.n39 1.67137
R355 VDD.n7 VDD.n5 1.36224
R356 VDD.n44 VDD.n12 1.36224
R357 VDD.n4 VDD.t4 1.313
R358 VDD.n14 VDD.n13 1.1905
R359 VDD.n17 VDD.n16 1.1905
R360 VDD.n20 VDD.n19 1.1905
R361 VDD.n14 VDD.t16 1.173
R362 VDD.n17 VDD.t21 1.173
R363 VDD.n20 VDD.t19 1.173
R364 VDD.n39 VDD.n38 1.1392
R365 VDD.n43 VDD.n42 1.09224
R366 VDD.n41 VDD.n40 1.09224
R367 VDD.n9 VDD.n7 0.974848
R368 VDD.n5 VDD.n1 0.923978
R369 VDD.n12 VDD.n11 0.923978
R370 VDD.n61 VDD.n1 0.702891
R371 VDD.n4 VDD.n3 0.368
R372 VDD VDD.n61 0.282469
R373 Cin.t1 Cin.t0 70.9148
R374 Cin.n3 Cin.n2 64.3344
R375 Cin.n1 Cin.t1 57.7716
R376 Cin.t3 Cin.n1 56.4716
R377 Cin.n0 Cin.t2 38.3255
R378 Cin.n2 Cin.t6 37.5434
R379 Cin.n2 Cin.t5 33.3719
R380 Cin.n3 Cin.t7 28.6791
R381 Cin.n0 Cin.t4 24.1166
R382 Cin.n3 Cin.t3 20.5969
R383 Cin Cin.n3 14.3483
R384 Cin.n1 Cin.n0 13.027
R385 A2.t1 A2.t0 464.651
R386 A2.t0 A2.t5 65.5701
R387 A2.n0 A2.t4 36.6922
R388 A2.n1 A2.t2 31.4779
R389 A2.n0 A2.t3 28.0886
R390 A2.n1 A2.t1 21.5708
R391 A2.n2 A2.n0 18.1154
R392 A2.n2 A2.n1 8.0005
R393 A2 A2.n2 0.010625
R394 B2.t3 B2.t4 326.356
R395 B2.t4 B2.t1 65.5701
R396 B2.n1 B2.n0 64.3344
R397 B2.n0 B2.t0 37.5434
R398 B2.n0 B2.t5 33.3719
R399 B2.n1 B2.t2 28.6791
R400 B2.n1 B2.t3 20.5969
R401 B2 B2.n1 14.3483
R402 S1.n60 S1.n59 61.2394
R403 S1.n23 S1.n22 61.2394
R404 S1.n19 S1.n18 61.2394
R405 S1.n15 S1.n14 61.2394
R406 S1.n12 S1.n11 61.2394
R407 S1.n38 S1.n37 61.2394
R408 S1.n34 S1.n33 61.2394
R409 S1.n30 S1.n29 61.2394
R410 S1.n27 S1.n26 61.2394
R411 S1.n53 S1.n52 61.2394
R412 S1.n49 S1.n48 61.2394
R413 S1.n45 S1.n44 61.2394
R414 S1.n42 S1.n41 61.2394
R415 S1.n8 S1.n7 61.2394
R416 S1.n4 S1.n3 61.2394
R417 S1.n1 S1.n0 61.2394
R418 S1.n59 S1.t9 39.8898
R419 S1.n22 S1.t53 39.8898
R420 S1.n18 S1.t57 39.8898
R421 S1.n14 S1.t49 39.8898
R422 S1.n11 S1.t61 39.8898
R423 S1.n37 S1.t25 39.8898
R424 S1.n33 S1.t29 39.8898
R425 S1.n29 S1.t21 39.8898
R426 S1.n26 S1.t17 39.8898
R427 S1.n52 S1.t41 39.8898
R428 S1.n48 S1.t45 39.8898
R429 S1.n44 S1.t37 39.8898
R430 S1.n41 S1.t33 39.8898
R431 S1.n7 S1.t13 39.8898
R432 S1.n3 S1.t1 39.8898
R433 S1.n0 S1.t5 39.8898
R434 S1.n60 S1.t8 33.3719
R435 S1.n23 S1.t52 33.3719
R436 S1.n19 S1.t56 33.3719
R437 S1.n15 S1.t48 33.3719
R438 S1.n12 S1.t60 33.3719
R439 S1.n38 S1.t24 33.3719
R440 S1.n34 S1.t28 33.3719
R441 S1.n30 S1.t20 33.3719
R442 S1.n27 S1.t16 33.3719
R443 S1.n53 S1.t40 33.3719
R444 S1.n49 S1.t44 33.3719
R445 S1.n45 S1.t36 33.3719
R446 S1.n42 S1.t32 33.3719
R447 S1.n8 S1.t12 33.3719
R448 S1.n4 S1.t0 33.3719
R449 S1.n1 S1.t4 33.3719
R450 S1.n59 S1.t11 31.0255
R451 S1.n22 S1.t55 31.0255
R452 S1.n18 S1.t59 31.0255
R453 S1.n14 S1.t51 31.0255
R454 S1.n11 S1.t63 31.0255
R455 S1.n37 S1.t27 31.0255
R456 S1.n33 S1.t31 31.0255
R457 S1.n29 S1.t23 31.0255
R458 S1.n26 S1.t19 31.0255
R459 S1.n52 S1.t43 31.0255
R460 S1.n48 S1.t47 31.0255
R461 S1.n44 S1.t39 31.0255
R462 S1.n41 S1.t35 31.0255
R463 S1.n7 S1.t15 31.0255
R464 S1.n3 S1.t3 31.0255
R465 S1.n0 S1.t7 31.0255
R466 S1.n17 S1.n13 23.0071
R467 S1.n32 S1.n28 23.0071
R468 S1.n47 S1.n43 23.0071
R469 S1.n6 S1.n2 23.0071
R470 S1.n61 S1.t10 22.4219
R471 S1.n24 S1.t54 22.4219
R472 S1.n39 S1.t26 22.4219
R473 S1.n54 S1.t42 22.4219
R474 S1.n13 S1.t62 22.2916
R475 S1.n28 S1.t18 22.2916
R476 S1.n43 S1.t34 22.2916
R477 S1.n2 S1.t6 22.2916
R478 S1.n16 S1.t50 21.1184
R479 S1.n31 S1.t22 21.1184
R480 S1.n46 S1.t38 21.1184
R481 S1.n5 S1.t2 21.1184
R482 S1.n20 S1.t58 20.7273
R483 S1.n35 S1.t30 20.7273
R484 S1.n50 S1.t46 20.7273
R485 S1.n9 S1.t14 20.7273
R486 S1.n25 S1.n24 20.6505
R487 S1.n40 S1.n39 20.6505
R488 S1.n55 S1.n54 20.6505
R489 S1.n21 S1.n20 20.5544
R490 S1.n17 S1.n16 20.5544
R491 S1.n36 S1.n35 20.5544
R492 S1.n32 S1.n31 20.5544
R493 S1.n51 S1.n50 20.5544
R494 S1.n47 S1.n46 20.5544
R495 S1.n10 S1.n9 20.5544
R496 S1.n6 S1.n5 20.5544
R497 S1.n62 S1.n61 11.6505
R498 S1.n62 S1.n58 9.0005
R499 S1.n58 S1.n57 6.79123
R500 S1.n56 S1.n55 6.5472
R501 S1.n57 S1.n56 6.27862
R502 S1.n20 S1.n19 5.08443
R503 S1.n35 S1.n34 5.08443
R504 S1.n50 S1.n49 5.08443
R505 S1.n9 S1.n8 5.08443
R506 S1.n16 S1.n15 4.69336
R507 S1.n31 S1.n30 4.69336
R508 S1.n46 S1.n45 4.69336
R509 S1.n5 S1.n4 4.69336
R510 S1.n13 S1.n12 3.52014
R511 S1.n28 S1.n27 3.52014
R512 S1.n43 S1.n42 3.52014
R513 S1.n2 S1.n1 3.52014
R514 S1.n61 S1.n60 3.38979
R515 S1.n24 S1.n23 3.38979
R516 S1.n39 S1.n38 3.38979
R517 S1.n54 S1.n53 3.38979
R518 S1.n25 S1.n21 2.3797
R519 S1.n40 S1.n36 2.3797
R520 S1.n55 S1.n51 2.3797
R521 S1.n58 S1.n10 2.3797
R522 S1.n21 S1.n17 2.13953
R523 S1.n36 S1.n32 2.13953
R524 S1.n51 S1.n47 2.13953
R525 S1.n10 S1.n6 2.13953
R526 S1.n57 S1.n25 0.194156
R527 S1.n56 S1.n40 0.194156
R528 S1 S1.n62 0.00405263
R529 S0.n21 S0.n20 64.1999
R530 S0.n16 S0.n15 64.1999
R531 S0.n10 S0.n9 64.1999
R532 S0.n5 S0.n4 64.1999
R533 S0.n91 S0.n90 64.1999
R534 S0.n86 S0.n85 64.1999
R535 S0.n80 S0.n79 64.1999
R536 S0.n75 S0.n74 64.1999
R537 S0.n67 S0.n66 64.1999
R538 S0.n62 S0.n61 64.1999
R539 S0.n56 S0.n55 64.1999
R540 S0.n51 S0.n50 64.1999
R541 S0.n44 S0.n43 64.1999
R542 S0.n39 S0.n38 64.1999
R543 S0.n33 S0.n32 64.1999
R544 S0.n28 S0.n27 64.1999
R545 S0.n14 S0.n13 63.7944
R546 S0.n8 S0.n7 63.7944
R547 S0.n3 S0.n2 63.7944
R548 S0.n1 S0.n0 63.7944
R549 S0.n84 S0.n83 63.7944
R550 S0.n78 S0.n77 63.7944
R551 S0.n73 S0.n72 63.7944
R552 S0.n71 S0.n70 63.7944
R553 S0.n60 S0.n59 63.7944
R554 S0.n54 S0.n53 63.7944
R555 S0.n49 S0.n48 63.7944
R556 S0.n47 S0.n46 63.7944
R557 S0.n37 S0.n36 63.7944
R558 S0.n31 S0.n30 63.7944
R559 S0.n26 S0.n25 63.7944
R560 S0.n24 S0.n23 63.7944
R561 S0.n20 S0.t19 39.8898
R562 S0.n15 S0.t27 39.8898
R563 S0.n13 S0.t30 39.8898
R564 S0.n9 S0.t3 39.8898
R565 S0.n7 S0.t6 39.8898
R566 S0.n4 S0.t11 39.8898
R567 S0.n2 S0.t14 39.8898
R568 S0.n0 S0.t22 39.8898
R569 S0.n90 S0.t107 39.8898
R570 S0.n85 S0.t115 39.8898
R571 S0.n83 S0.t118 39.8898
R572 S0.n79 S0.t99 39.8898
R573 S0.n77 S0.t102 39.8898
R574 S0.n74 S0.t123 39.8898
R575 S0.n72 S0.t126 39.8898
R576 S0.n70 S0.t110 39.8898
R577 S0.n66 S0.t51 39.8898
R578 S0.n61 S0.t59 39.8898
R579 S0.n59 S0.t62 39.8898
R580 S0.n55 S0.t43 39.8898
R581 S0.n53 S0.t46 39.8898
R582 S0.n50 S0.t35 39.8898
R583 S0.n48 S0.t38 39.8898
R584 S0.n46 S0.t54 39.8898
R585 S0.n43 S0.t83 39.8898
R586 S0.n38 S0.t91 39.8898
R587 S0.n36 S0.t94 39.8898
R588 S0.n32 S0.t75 39.8898
R589 S0.n30 S0.t78 39.8898
R590 S0.n27 S0.t67 39.8898
R591 S0.n25 S0.t70 39.8898
R592 S0.n23 S0.t86 39.8898
R593 S0.n20 S0.t21 31.0255
R594 S0.n15 S0.t29 31.0255
R595 S0.n13 S0.t31 31.0255
R596 S0.n9 S0.t5 31.0255
R597 S0.n7 S0.t7 31.0255
R598 S0.n4 S0.t13 31.0255
R599 S0.n2 S0.t15 31.0255
R600 S0.n0 S0.t23 31.0255
R601 S0.n90 S0.t109 31.0255
R602 S0.n85 S0.t117 31.0255
R603 S0.n83 S0.t119 31.0255
R604 S0.n79 S0.t101 31.0255
R605 S0.n77 S0.t103 31.0255
R606 S0.n74 S0.t125 31.0255
R607 S0.n72 S0.t127 31.0255
R608 S0.n70 S0.t111 31.0255
R609 S0.n66 S0.t53 31.0255
R610 S0.n61 S0.t61 31.0255
R611 S0.n59 S0.t63 31.0255
R612 S0.n55 S0.t45 31.0255
R613 S0.n53 S0.t47 31.0255
R614 S0.n50 S0.t37 31.0255
R615 S0.n48 S0.t39 31.0255
R616 S0.n46 S0.t55 31.0255
R617 S0.n43 S0.t85 31.0255
R618 S0.n38 S0.t93 31.0255
R619 S0.n36 S0.t95 31.0255
R620 S0.n32 S0.t77 31.0255
R621 S0.n30 S0.t79 31.0255
R622 S0.n27 S0.t69 31.0255
R623 S0.n25 S0.t71 31.0255
R624 S0.n23 S0.t87 31.0255
R625 S0.n21 S0.t16 27.5059
R626 S0.n16 S0.t24 27.5059
R627 S0.n14 S0.t25 27.5059
R628 S0.n10 S0.t0 27.5059
R629 S0.n8 S0.t1 27.5059
R630 S0.n5 S0.t8 27.5059
R631 S0.n3 S0.t9 27.5059
R632 S0.n1 S0.t17 27.5059
R633 S0.n91 S0.t104 27.5059
R634 S0.n86 S0.t112 27.5059
R635 S0.n84 S0.t113 27.5059
R636 S0.n80 S0.t96 27.5059
R637 S0.n78 S0.t97 27.5059
R638 S0.n75 S0.t120 27.5059
R639 S0.n73 S0.t121 27.5059
R640 S0.n71 S0.t105 27.5059
R641 S0.n67 S0.t48 27.5059
R642 S0.n62 S0.t56 27.5059
R643 S0.n60 S0.t57 27.5059
R644 S0.n56 S0.t40 27.5059
R645 S0.n54 S0.t41 27.5059
R646 S0.n51 S0.t32 27.5059
R647 S0.n49 S0.t33 27.5059
R648 S0.n47 S0.t49 27.5059
R649 S0.n44 S0.t80 27.5059
R650 S0.n39 S0.t88 27.5059
R651 S0.n37 S0.t89 27.5059
R652 S0.n33 S0.t72 27.5059
R653 S0.n31 S0.t73 27.5059
R654 S0.n28 S0.t64 27.5059
R655 S0.n26 S0.t65 27.5059
R656 S0.n24 S0.t81 27.5059
R657 S0.n17 S0.n14 21.3785
R658 S0.n11 S0.n8 21.3785
R659 S0.n6 S0.n3 21.3785
R660 S0.n19 S0.n1 21.3785
R661 S0.n87 S0.n84 21.3785
R662 S0.n81 S0.n78 21.3785
R663 S0.n76 S0.n73 21.3785
R664 S0.n89 S0.n71 21.3785
R665 S0.n63 S0.n60 21.3785
R666 S0.n57 S0.n54 21.3785
R667 S0.n52 S0.n49 21.3785
R668 S0.n65 S0.n47 21.3785
R669 S0.n40 S0.n37 21.3785
R670 S0.n34 S0.n31 21.3785
R671 S0.n29 S0.n26 21.3785
R672 S0.n42 S0.n24 21.3785
R673 S0.n21 S0.t18 21.2487
R674 S0.n16 S0.t26 21.2487
R675 S0.n14 S0.t28 21.2487
R676 S0.n10 S0.t2 21.2487
R677 S0.n8 S0.t4 21.2487
R678 S0.n5 S0.t10 21.2487
R679 S0.n3 S0.t12 21.2487
R680 S0.n1 S0.t20 21.2487
R681 S0.n91 S0.t106 21.2487
R682 S0.n86 S0.t114 21.2487
R683 S0.n84 S0.t116 21.2487
R684 S0.n80 S0.t98 21.2487
R685 S0.n78 S0.t100 21.2487
R686 S0.n75 S0.t122 21.2487
R687 S0.n73 S0.t124 21.2487
R688 S0.n71 S0.t108 21.2487
R689 S0.n67 S0.t50 21.2487
R690 S0.n62 S0.t58 21.2487
R691 S0.n60 S0.t60 21.2487
R692 S0.n56 S0.t42 21.2487
R693 S0.n54 S0.t44 21.2487
R694 S0.n51 S0.t34 21.2487
R695 S0.n49 S0.t36 21.2487
R696 S0.n47 S0.t52 21.2487
R697 S0.n44 S0.t82 21.2487
R698 S0.n39 S0.t90 21.2487
R699 S0.n37 S0.t92 21.2487
R700 S0.n33 S0.t74 21.2487
R701 S0.n31 S0.t76 21.2487
R702 S0.n28 S0.t66 21.2487
R703 S0.n26 S0.t68 21.2487
R704 S0.n24 S0.t84 21.2487
R705 S0.n17 S0.n16 18.7055
R706 S0.n11 S0.n10 18.7055
R707 S0.n6 S0.n5 18.7055
R708 S0.n87 S0.n86 18.7055
R709 S0.n81 S0.n80 18.7055
R710 S0.n76 S0.n75 18.7055
R711 S0.n63 S0.n62 18.7055
R712 S0.n57 S0.n56 18.7055
R713 S0.n52 S0.n51 18.7055
R714 S0.n40 S0.n39 18.7055
R715 S0.n34 S0.n33 18.7055
R716 S0.n29 S0.n28 18.7055
R717 S0.n69 S0.n45 15.9664
R718 S0 S0.n93 15.6979
R719 S0.n22 S0.n21 14.2055
R720 S0.n92 S0.n91 14.2055
R721 S0.n68 S0.n67 14.2055
R722 S0.n45 S0.n44 14.2055
R723 S0.n69 S0.n68 9.21858
R724 S0.n93 S0.n92 9.20402
R725 S0.n12 S0.n6 6.78517
R726 S0.n82 S0.n76 6.78517
R727 S0.n58 S0.n52 6.78517
R728 S0.n35 S0.n29 6.78517
R729 S0.n93 S0.n69 6.76175
R730 S0.n19 S0.n18 6.75431
R731 S0.n89 S0.n88 6.75431
R732 S0.n65 S0.n64 6.75431
R733 S0.n42 S0.n41 6.75431
R734 S0.n12 S0.n11 4.5005
R735 S0.n18 S0.n17 4.5005
R736 S0.n82 S0.n81 4.5005
R737 S0.n88 S0.n87 4.5005
R738 S0.n92 S0.n89 4.5005
R739 S0.n58 S0.n57 4.5005
R740 S0.n64 S0.n63 4.5005
R741 S0.n68 S0.n65 4.5005
R742 S0.n35 S0.n34 4.5005
R743 S0.n41 S0.n40 4.5005
R744 S0.n45 S0.n42 4.5005
R745 S0.n22 S0.n19 4.5005
R746 S0.n18 S0.n12 2.2729
R747 S0.n88 S0.n82 2.2729
R748 S0.n64 S0.n58 2.2729
R749 S0.n41 S0.n35 2.2729
R750 S0 S0.n22 0.005
R751 A3.t1 A3.t0 464.651
R752 A3.t0 A3.t5 65.5701
R753 A3.n0 A3.t4 36.6922
R754 A3.n1 A3.t2 31.4779
R755 A3.n0 A3.t3 28.0886
R756 A3.n1 A3.t1 21.5708
R757 A3.n2 A3.n0 18.1154
R758 A3.n2 A3.n1 8.0005
R759 A3 A3.n2 0.003875
R760 B3.t3 B3.t4 326.356
R761 B3.t4 B3.t1 65.5701
R762 B3.n1 B3.n0 64.3344
R763 B3.n0 B3.t0 37.5434
R764 B3.n0 B3.t5 33.3719
R765 B3.n1 B3.t2 28.6791
R766 B3.n1 B3.t3 20.5969
R767 B3 B3.n1 14.3494
R768 A0.t1 A0.t0 464.651
R769 A0.t0 A0.t5 65.5701
R770 A0.n0 A0.t4 36.6922
R771 A0.n1 A0.t2 31.4779
R772 A0.n0 A0.t3 28.0886
R773 A0.n1 A0.t1 21.5708
R774 A0.n2 A0.n0 18.1154
R775 A0.n2 A0.n1 8.0005
R776 A0 A0.n2 0.005
R777 B0.t3 B0.t4 326.356
R778 B0.t4 B0.t1 65.5701
R779 B0.n1 B0.n0 64.3344
R780 B0.n0 B0.t0 37.5434
R781 B0.n0 B0.t5 33.3719
R782 B0.n1 B0.t2 28.6791
R783 B0.n1 B0.t3 20.5969
R784 B0 B0.n1 14.353
R785 Y0 Y0.n1 9.58433
R786 Y0 Y0.n0 8.79885
R787 A1.t1 A1.t0 464.651
R788 A1.t0 A1.t5 65.5701
R789 A1.n0 A1.t4 36.6922
R790 A1.n1 A1.t2 31.4779
R791 A1.n0 A1.t3 28.0886
R792 A1.n1 A1.t1 21.5708
R793 A1.n2 A1.n0 18.1154
R794 A1.n2 A1.n1 8.0005
R795 A1 A1.n2 0.005
R796 B1.t3 B1.t4 326.356
R797 B1.t4 B1.t1 65.5701
R798 B1.n1 B1.n0 64.3344
R799 B1.n0 B1.t0 37.5434
R800 B1.n0 B1.t5 33.3719
R801 B1.n1 B1.t2 28.6791
R802 B1.n1 B1.t3 20.5969
R803 B1 B1.n1 14.3494
R804 F.t0 F.t2 186.28
R805 F.t2 F.t3 64.7803
R806 F.n0 F.t1 31.4779
R807 F.n0 F.t0 21.5708
R808 F F.n0 21.3595
R809 A11.t1 A11.t0 464.651
R810 A11.t0 A11.t5 65.5701
R811 A11.n0 A11.t4 36.6922
R812 A11.n1 A11.t2 31.4779
R813 A11.n0 A11.t3 28.0886
R814 A11.n1 A11.t1 21.5708
R815 A11.n2 A11.n0 18.1154
R816 A11.n2 A11.n1 8.0005
R817 A11 A11.n2 0.008375
R818 B11.t3 B11.t4 326.356
R819 B11.t4 B11.t1 65.5701
R820 B11.n1 B11.n0 64.3344
R821 B11.n0 B11.t0 37.5434
R822 B11.n0 B11.t5 33.3719
R823 B11.n1 B11.t2 28.6791
R824 B11.n1 B11.t3 20.5969
R825 B11 B11.n1 14.3518
R826 A10.t1 A10.t0 464.651
R827 A10.t0 A10.t5 65.5701
R828 A10.n0 A10.t4 36.6922
R829 A10.n1 A10.t2 31.4779
R830 A10.n0 A10.t3 28.0886
R831 A10.n1 A10.t1 21.5708
R832 A10.n2 A10.n0 18.1154
R833 A10.n2 A10.n1 8.0005
R834 A10 A10.n2 0.0095
R835 B10.t3 B10.t4 326.356
R836 B10.t4 B10.t1 65.5701
R837 B10.n1 B10.n0 64.3344
R838 B10.n0 B10.t0 37.5434
R839 B10.n0 B10.t5 33.3719
R840 B10.n1 B10.t2 28.6791
R841 B10.n1 B10.t3 20.5969
R842 B10 B10.n1 14.3471
R843 BP2.n1 BP2.n0 61.6449
R844 BP2.n4 BP2.n3 46.2685
R845 BP2.n3 BP2.t5 43.7679
R846 BP2.n0 BP2.t1 39.8898
R847 BP2.n0 BP2.t2 31.0255
R848 BP2.n1 BP2.t0 25.8112
R849 BP2.n3 BP2.t4 25.2572
R850 BP2.n4 BP2.n2 25.1612
R851 BP2.n2 BP2.t3 22.6984
R852 BP2.n2 BP2.n1 4.96987
R853 BP2 BP2.n4 4.5814
R854 A8.t1 A8.t0 464.651
R855 A8.t0 A8.t5 65.5701
R856 A8.n0 A8.t4 36.6922
R857 A8.n1 A8.t2 31.4779
R858 A8.n0 A8.t3 28.0886
R859 A8.n1 A8.t1 21.5708
R860 A8.n2 A8.n0 18.1154
R861 A8.n2 A8.n1 8.0005
R862 A8 A8.n2 0.00725
R863 B8.t3 B8.t4 326.356
R864 B8.t4 B8.t1 65.5701
R865 B8.n1 B8.n0 64.3344
R866 B8.n0 B8.t0 37.5434
R867 B8.n0 B8.t5 33.3719
R868 B8.n1 B8.t2 28.6791
R869 B8.n1 B8.t3 20.5969
R870 B8 B8.n1 14.3566
R871 A9.t1 A9.t0 464.651
R872 A9.t0 A9.t5 65.5701
R873 A9.n0 A9.t4 36.6922
R874 A9.n1 A9.t2 31.4779
R875 A9.n0 A9.t3 28.0886
R876 A9.n1 A9.t1 21.5708
R877 A9.n2 A9.n0 18.1154
R878 A9.n2 A9.n1 8.0005
R879 A9 A9.n2 0.008375
R880 B9.t3 B9.t4 326.356
R881 B9.t4 B9.t1 65.5701
R882 B9.n1 B9.n0 64.3344
R883 B9.n0 B9.t0 37.5434
R884 B9.n0 B9.t5 33.3719
R885 B9.n1 B9.t2 28.6791
R886 B9.n1 B9.t3 20.5969
R887 B9 B9.n1 14.3506
R888 BP1.n2 BP1.n1 61.6449
R889 BP1.n0 BP1.t1 43.7679
R890 BP1.n1 BP1.t3 39.8898
R891 BP1.n4 BP1.n0 32.662
R892 BP1.n1 BP1.t4 31.0255
R893 BP1.n2 BP1.t2 25.8112
R894 BP1.n0 BP1.t0 25.2572
R895 BP1.n3 BP1.t5 22.6984
R896 BP1 BP1.n4 16.3224
R897 BP1.n4 BP1.n3 13.501
R898 BP1.n3 BP1.n2 4.96987
R899 BP3.n1 BP3.n0 61.6449
R900 BP3.n3 BP3.t1 43.7679
R901 BP3.n0 BP3.t3 39.8898
R902 BP3.n0 BP3.t4 31.0255
R903 BP3.n1 BP3.t2 25.8112
R904 BP3.n3 BP3.t0 25.2572
R905 BP3.n2 BP3.t5 22.6984
R906 BP3.n4 BP3.n3 19.0539
R907 BP3 BP3.n4 16.3556
R908 BP3.n4 BP3.n2 13.4677
R909 BP3.n2 BP3.n1 4.96987
R910 A15.t1 A15.t0 464.651
R911 A15.t0 A15.t5 65.5701
R912 A15.n0 A15.t4 36.6922
R913 A15.n1 A15.t2 31.4779
R914 A15.n0 A15.t3 28.0886
R915 A15.n1 A15.t1 21.5708
R916 A15.n2 A15.n0 18.1154
R917 A15.n2 A15.n1 8.0005
R918 A15 A15.n2 0.019625
R919 B15.t3 B15.t4 326.356
R920 B15.t4 B15.t1 65.5701
R921 B15.n1 B15.n0 64.3344
R922 B15.n0 B15.t0 37.5434
R923 B15.n0 B15.t5 33.3719
R924 B15.n1 B15.t2 28.6791
R925 B15.n1 B15.t3 20.5969
R926 B15 B15.n1 14.3459
R927 A14.t1 A14.t0 464.651
R928 A14.t0 A14.t5 65.5701
R929 A14.n0 A14.t4 36.6922
R930 A14.n1 A14.t2 31.4779
R931 A14.n0 A14.t3 28.0886
R932 A14.n1 A14.t1 21.5708
R933 A14.n2 A14.n0 18.1154
R934 A14.n2 A14.n1 8.0005
R935 A14 A14.n2 0.014
R936 B14.t3 B14.t4 326.356
R937 B14.t4 B14.t1 65.5701
R938 B14.n1 B14.n0 64.3344
R939 B14.n0 B14.t0 37.5434
R940 B14.n0 B14.t5 33.3719
R941 B14.n1 B14.t2 28.6791
R942 B14.n1 B14.t3 20.5969
R943 B14 B14.n1 14.3542
R944 A12.t1 A12.t0 464.651
R945 A12.t0 A12.t5 65.5701
R946 A12.n0 A12.t4 36.6922
R947 A12.n1 A12.t2 31.4779
R948 A12.n0 A12.t3 28.0886
R949 A12.n1 A12.t1 21.5708
R950 A12.n2 A12.n0 18.1154
R951 A12.n2 A12.n1 8.0005
R952 A12 A12.n2 0.00725
R953 B12.t3 B12.t4 326.356
R954 B12.t4 B12.t1 65.5701
R955 B12.n1 B12.n0 64.3344
R956 B12.n0 B12.t0 37.5434
R957 B12.n0 B12.t5 33.3719
R958 B12.n1 B12.t2 28.6791
R959 B12.n1 B12.t3 20.5969
R960 B12 B12.n1 14.3577
R961 A13.t1 A13.t0 464.651
R962 A13.t0 A13.t5 65.5701
R963 A13.n0 A13.t4 36.6922
R964 A13.n1 A13.t2 31.4779
R965 A13.n0 A13.t3 28.0886
R966 A13.n1 A13.t1 21.5708
R967 A13.n2 A13.n0 18.1154
R968 A13.n2 A13.n1 8.0005
R969 A13 A13.n2 0.014
R970 B13.t3 B13.t4 326.356
R971 B13.t4 B13.t1 65.5701
R972 B13.n1 B13.n0 64.3344
R973 B13.n0 B13.t0 37.5434
R974 B13.n0 B13.t5 33.3719
R975 B13.n1 B13.t2 28.6791
R976 B13.n1 B13.t3 20.5969
R977 B13 B13.n1 14.3577
R978 A6.t1 A6.t0 464.651
R979 A6.t0 A6.t5 65.5701
R980 A6.n0 A6.t4 36.6922
R981 A6.n1 A6.t2 31.4779
R982 A6.n0 A6.t3 28.0886
R983 A6.n1 A6.t1 21.5708
R984 A6.n2 A6.n0 18.1154
R985 A6.n2 A6.n1 8.0005
R986 A6 A6.n2 0.010625
R987 B6.t3 B6.t4 326.356
R988 B6.t4 B6.t1 65.5701
R989 B6.n1 B6.n0 64.3344
R990 B6.n0 B6.t0 37.5434
R991 B6.n0 B6.t5 33.3719
R992 B6.n1 B6.t2 28.6791
R993 B6.n1 B6.t3 20.5969
R994 B6 B6.n1 14.3483
R995 A4.t1 A4.t0 464.651
R996 A4.t0 A4.t5 65.5701
R997 A4.n0 A4.t4 36.6922
R998 A4.n1 A4.t2 31.4779
R999 A4.n0 A4.t3 28.0886
R1000 A4.n1 A4.t1 21.5708
R1001 A4.n2 A4.n0 18.1154
R1002 A4.n2 A4.n1 8.0005
R1003 A4 A4.n2 0.0095
R1004 B4.t3 B4.t4 326.356
R1005 B4.t4 B4.t1 65.5701
R1006 B4.n1 B4.n0 64.3344
R1007 B4.n0 B4.t0 37.5434
R1008 B4.n0 B4.t5 33.3719
R1009 B4.n1 B4.t2 28.6791
R1010 B4.n1 B4.t3 20.5969
R1011 B4 B4.n1 14.3483
R1012 A5.t1 A5.t0 464.651
R1013 A5.t0 A5.t5 65.5701
R1014 A5.n0 A5.t4 36.6922
R1015 A5.n1 A5.t2 31.4779
R1016 A5.n0 A5.t3 28.0886
R1017 A5.n1 A5.t1 21.5708
R1018 A5.n2 A5.n0 18.1154
R1019 A5.n2 A5.n1 8.0005
R1020 A5 A5.n2 0.0095
R1021 B5.t3 B5.t4 326.356
R1022 B5.t4 B5.t1 65.5701
R1023 B5.n1 B5.n0 64.3344
R1024 B5.n0 B5.t0 37.5434
R1025 B5.n0 B5.t5 33.3719
R1026 B5.n1 B5.t2 28.6791
R1027 B5.n1 B5.t3 20.5969
R1028 B5 B5.n1 14.3471
R1029 A7.t1 A7.t0 464.651
R1030 A7.t0 A7.t5 65.5701
R1031 A7.n0 A7.t4 36.6922
R1032 A7.n1 A7.t2 31.4779
R1033 A7.n0 A7.t3 28.0886
R1034 A7.n1 A7.t1 21.5708
R1035 A7.n2 A7.n0 18.1154
R1036 A7.n2 A7.n1 8.0005
R1037 A7 A7.n2 0.015125
R1038 B7.t3 B7.t4 326.356
R1039 B7.t4 B7.t1 65.5701
R1040 B7.n1 B7.n0 64.3344
R1041 B7.n0 B7.t0 37.5434
R1042 B7.n0 B7.t5 33.3719
R1043 B7.n1 B7.t2 28.6791
R1044 B7.n1 B7.t3 20.5969
R1045 B7 B7.n1 14.3471
C0 4bitblock$2_0/m1_13543_n1146# 4bitblock_LAST_0/1bitblock$7_0/a_11480_63# 0
C1 4bitblock$2_0/1bitblock$3$2_0/a_11480_63# 4bitblock_LAST_0/m1_14167_n1145# 0
C2 4bitblock_0/1bitblock$3_0/a_1845_466# VDD 0
C3 4bitblock_0/1bitblock$2_0/a_2419_63# S0 0.00273f
C4 4bitblock_0/1bitblock_0/a_8160_n37# S1 0
C5 VDD 4bitblock$1_0/1bitblock$4_0/a_10906_466# 0
C6 m1_17438_n9725# XOR$8_0/a_510_63# 0.01657f
C7 4bitblock$2_0/1bitblock$1$2_0/a_3498_3# S1 0.00338f
C8 B4 4bitblock_0/m1_13543_n1146# 0
C9 AND4$4_0/a_704_n441# m1_17790_n9717# 0
C10 4bitblock$2_0/1bitblock$2$2_0/a_5042_407# S0 0.05876f
C11 BP1 4bitblock$1_0/AND4$1_0/a_518_229# 0.00344f
C12 4bitblock_0/1bitblock$3_0/a_3498_3# S1 0.00544f
C13 m2_6320_n21444# 4bitblock_LAST_0/1bitblock$2$4_0/a_8160_n37# 0
C14 4bitblock$2_0/1bitblock$1$2_0/a_2419_63# S1 0.00146f
C15 BP0 4bitblock_0/AND4_0/a_704_n441# 0
C16 4bitblock_0/1bitblock_0/a_3940_63# S0 0.00263f
C17 4bitblock_0/1bitblock$3_0/a_5768_63# VDD 0
C18 4bitblock_0/1bitblock$3_0/a_2419_63# S0 0.00352f
C19 XOR$9_0/a_160_63# XOR$9_0/a_510_63# -0
C20 4bitblock_LAST_0/1bitblock$7_0/a_4290_63# 4bitblock_LAST_0/1bitblock$7_0/a_5042_407# 0
C21 S0 4bitblock$1_0/1bitblock$4_0/a_4290_63# 0.00973f
C22 4bitblock_0/1bitblock$3_0/a_9609_407# S1 0.00909f
C23 4bitblock_0/1bitblock$1_0/a_5243_407# S0 0.01524f
C24 4bitblock$2_0/1bitblock$1$2_0/m2_9431_79# S1 0.00105f
C25 F m2_6320_n21444# 0.07208f
C26 XOR$9_0/a_510_63# m1_17790_n9717# 0.00774f
C27 4bitblock_0/m1_13543_n1146# 4bitblock$1_0/1bitblock$4_0/a_10906_466# 0
C28 4bitblock$2_0/m1_12480_n3815# 4bitblock_LAST_0/m1_14167_n1145# 0.00355f
C29 B11 A12 0
C30 BP0 BP3 0.02752f
C31 4bitblock_0/MUX21_0/a_718_407# 4bitblock_0/m1_12480_n3815# -0
C32 Cin S0 0.04029f
C33 4bitblock$2_0/1bitblock$2$2_0/a_3940_63# S0 0.00362f
C34 4bitblock_0/1bitblock$1_0/a_5768_63# S0 0.002f
C35 4bitblock$2_0/1bitblock$5_0/a_5768_63# 4bitblock$2_0/1bitblock$5_0/a_5042_407# -0
C36 BP2 BP1 0.0717f
C37 AND4$4_0/a_1120_n441# BP2 0
C38 N F 0.00733f
C39 4bitblock$2_0/1bitblock$3$2_0/a_2861_3# 4bitblock_LAST_0/1bitblock$7_0/a_2419_63# 0
C40 F XOR$8_0/a_870_n37# 0.00251f
C41 XOR$9_0/a_160_63# AND4$4_0/a_518_229# 0
C42 VDD 4bitblock$1_0/1bitblock$4_0/a_2861_3# 0
C43 4bitblock_0/1bitblock$3_0/a_11480_63# 4bitblock$1_0/m1_14167_n1145# 0
C44 4bitblock_0/m1_14167_n1145# S1 0.00344f
C45 4bitblock_0/m1_12486_242# S0 0.04076f
C46 S1 4bitblock_LAST_0/1bitblock$7_0/a_3498_3# 0.00481f
C47 AND4$4_0/a_518_229# m1_17790_n9717# 0.00545f
C48 S1 4bitblock_LAST_0/1bitblock$7_0/a_2419_63# 0
C49 4bitblock_0/1bitblock_0/a_4650_n37# S0 0
C50 4bitblock_LAST_0/MUX21$4_0/a_157_63# m2_16192_n18174# 0.00188f
C51 B8 4bitblock$1_0/1bitblock$3$1_0/a_705_407# 0
C52 4bitblock$2_0/1bitblock$5_0/a_705_407# B7 0
C53 4bitblock_LAST_0/1bitblock$3$4_0/a_7410_63# m2_6320_n21444# 0.02393f
C54 B11 VDD 0.00238f
C55 4bitblock$2_0/MUX21$2_0/a_157_63# VDD 0.00135f
C56 S0 4bitblock$1_0/1bitblock$4_0/a_5042_n37# 0
C57 4bitblock$2_0/1bitblock$5_0/a_5768_63# 4bitblock$2_0/1bitblock$5_0/a_3940_63# -0
C58 4bitblock$2_0/1bitblock$3$2_0/a_9050_63# VDD 0
C59 BP0 4bitblock$2_0/MUX21$2_0/a_909_n37# 0.00131f
C60 4bitblock_0/1bitblock$3_0/a_11922_3# 4bitblock$1_0/1bitblock$4_0/a_2419_63# 0
C61 4bitblock$2_0/1bitblock$5_0/a_510_63# VDD 0
C62 4bitblock$2_0/1bitblock$5_0/a_3498_3# 4bitblock$2_0/m1_14167_n1145# -0
C63 XOR$9_0/a_705_407# XOR$8_0/a_510_63# 0
C64 S1 4bitblock$1_0/1bitblock$1$1_0/m2_7791_79# 0.01997f
C65 4bitblock_0/1bitblock$3_0/a_2419_63# VDD 0.00106f
C66 4bitblock$2_0/1bitblock$5_0/a_2861_3# 4bitblock$1_0/1bitblock$3$1_0/a_2861_3# 0
C67 4bitblock$2_0/1bitblock$5_0/a_2419_63# 4bitblock$2_0/m1_14167_n1145# 0
C68 S1 4bitblock_LAST_0/1bitblock$7_0/m2_9431_79# 0.00319f
C69 S0 4bitblock_LAST_0/m1_12486_242# 0
C70 4bitblock_0/m1_13543_n1146# 4bitblock$1_0/1bitblock$4_0/a_2861_3# 0
C71 BP2 4bitblock$2_0/m1_12484_n953# 0.34574f
C72 4bitblock_0/1bitblock$3_0/a_9050_63# S1 0.00379f
C73 VDD 4bitblock$1_0/1bitblock$4_0/a_4290_63# -0
C74 AND4$4_0/a_912_n441# m1_17790_n9717# 0.00139f
C75 F BP3 0
C76 4bitblock_0/1bitblock$3_0/a_10906_466# VDD 0
C77 4bitblock_0/m2_1701_n784# S0 0.0153f
C78 BP0 AND4$4_0/a_704_n441# 0.00201f
C79 BP1 4bitblock$1_0/m1_12480_n3815# 0.09387f
C80 4bitblock$2_0/m1_12480_n3815# BP3 0.00203f
C81 B8 4bitblock$1_0/1bitblock$3$1_0/a_160_63# 0
C82 S1 4bitblock$1_0/1bitblock$1$1_0/a_9609_407# 0
C83 BP1 4bitblock$1_0/MUX21$1_0/a_909_n37# 0
C84 VDD 4bitblock$1_0/1bitblock$4_0/a_7410_63# 0
C85 A8 VDD 0.00911f
C86 BP2 4bitblock$2_0/1bitblock$2$2_0/a_11922_3# 0
C87 S1 4bitblock$1_0/m1_12486_242# 0.04245f
C88 4bitblock_0/1bitblock$3_0/a_2419_63# 4bitblock_0/m1_13543_n1146# -0
C89 BP0 XOR$9_0/a_510_63# 0
C90 S0 4bitblock$1_0/1bitblock$3$1_0/a_5768_63# 0.00624f
C91 4bitblock$2_0/1bitblock$5_0/a_11480_63# 4bitblock$2_0/m1_14167_n1145# 0
C92 4bitblock_0/1bitblock$3_0/a_3940_63# S0 0.00495f
C93 S1 4bitblock_LAST_0/m1_13543_n1146# -0
C94 S0 4bitblock_LAST_0/m2_1701_n784# 0
C95 BP2 4bitblock$2_0/m2_2396_n2595# 0.13436f
C96 4bitblock$2_0/m1_12480_n3815# 4bitblock$2_0/m1_13543_n1146# -0
C97 4bitblock_0/m1_13543_n1146# 4bitblock_0/1bitblock$3_0/a_10906_466# -0
C98 XOR$9_0/a_160_63# m1_17438_n9725# 0
C99 S1 4bitblock$1_0/1bitblock$1$1_0/a_8361_407# 0.00847f
C100 S0 4bitblock$1_0/1bitblock$3$1_0/a_5243_407# 0.02703f
C101 S0 VDD 0.99321f
C102 m1_17790_n9717# m1_17438_n9725# 0.93044f
C103 BP0 4bitblock_0/1bitblock$1_0/a_2419_63# 0
C104 4bitblock_0/1bitblock$3_0/a_5243_407# S0 0.02725f
C105 S1 4bitblock$1_0/1bitblock$2$1_0/m2_7791_79# 0.01999f
C106 S1 4bitblock$1_0/1bitblock$1$1_0/a_7083_63# 0.04958f
C107 4bitblock_0/1bitblock$3_0/m2_9431_79# S1 0.00409f
C108 VDD 4bitblock_LAST_0/m1_12486_242# 0
C109 BP0 AND4$4_0/a_518_229# 0.06993f
C110 4bitblock$2_0/1bitblock$5_0/m2_7791_79# S1 0.02702f
C111 4bitblock$2_0/1bitblock$3$2_0/a_3498_3# S1 0.00552f
C112 S1 4bitblock$1_0/m2_1701_n784# 0.01456f
C113 XOR$9_0/a_160_63# BP1 0.04198f
C114 m1_17790_n9717# 4bitblock_LAST_0/m1_12484_n953# 0.04241f
C115 4bitblock$2_0/1bitblock$3$2_0/a_2419_63# S1 0.00276f
C116 m2_6320_n21444# 4bitblock_LAST_0/1bitblock$2$4_0/m2_6151_79# 0
C117 m1_17790_n9717# BP1 0.05692f
C118 4bitblock_0/1bitblock_0/m2_6151_79# S0 0.00141f
C119 AND4$4_0/a_1120_n441# m1_17790_n9717# 0.0018f
C120 S0 4bitblock$1_0/m2_10721_n3315# 0.04202f
C121 4bitblock$2_0/1bitblock$3$2_0/a_510_63# 4bitblock_LAST_0/1bitblock$7_0/a_705_407# 0
C122 VDD A12 0.00911f
C123 4bitblock$2_0/1bitblock$3$2_0/a_705_407# 4bitblock_LAST_0/1bitblock$7_0/a_510_63# 0
C124 BP2 4bitblock$2_0/1bitblock$2$2_0/a_10906_466# 0
C125 4bitblock$2_0/1bitblock$2$2_0/a_7768_n37# S1 0
C126 4bitblock_0/m1_13543_n1146# S0 0.06592f
C127 4bitblock_LAST_0/MUX21$4_0/a_157_63# BP3 0.02137f
C128 S1 4bitblock$1_0/1bitblock$2$1_0/a_9609_407# 0
C129 S1 4bitblock$1_0/1bitblock$1$1_0/a_8723_63# 0.04566f
C130 m2_6320_n21444# 4bitblock_LAST_0/1bitblock$2$4_0/a_3498_3# 0
C131 A8 4bitblock$1_0/1bitblock$3$1_0/a_1845_466# 0
C132 4bitblock_0/1bitblock$1_0/a_4650_n37# S0 0
C133 A8 4bitblock$1_0/m1_13543_n1146# 0
C134 4bitblock$2_0/1bitblock$3$2_0/m2_9431_79# S1 0.00412f
C135 m2_6320_n21444# 4bitblock_LAST_0/1bitblock$2$4_0/a_2419_63# 0.00578f
C136 S1 4bitblock$1_0/m1_12484_n953# 0.0426f
C137 F XOR$9_0/a_510_63# 0.00928f
C138 4bitblock_0/1bitblock_0/m2_9431_79# S1 0
C139 m1_17790_n9717# 4bitblock_LAST_0/1bitblock$2$4_0/a_11922_3# 0.00123f
C140 BP0 AND4$4_0/a_912_n441# 0.00201f
C141 VDD 4bitblock$1_0/1bitblock$3$1_0/a_5768_63# 0
C142 4bitblock_0/1bitblock$3_0/a_160_63# VDD 0
C143 m1_16199_n12176# S1 0.04272f
C144 4bitblock_0/1bitblock$3_0/a_3940_63# VDD 0
C145 S0 4bitblock$1_0/1bitblock$3$1_0/a_7083_63# 0
C146 4bitblock_LAST_0/MUX21$4_0/a_718_407# m1_17790_n9717# 0.04696f
C147 4bitblock$2_0/1bitblock$5_0/a_4290_63# 4bitblock$2_0/1bitblock$5_0/m2_6151_79# -0
C148 S0 4bitblock$2_0/1bitblock$1$2_0/a_5768_63# 0.00192f
C149 4bitblock_0/1bitblock_0/a_5768_63# 4bitblock_0/1bitblock_0/a_5042_407# -0
C150 m2_6320_n21444# 4bitblock_LAST_0/1bitblock$2$4_0/m2_9431_79# 0
C151 m1_17790_n9717# 4bitblock_LAST_0/m2_2396_n2595# 0.12841f
C152 Y8 S1 0
C153 S1 4bitblock$1_0/1bitblock$2$1_0/a_8361_407# 0.00847f
C154 m2_6320_n21444# 4bitblock_LAST_0/1bitblock$2$4_0/a_10906_n37# 0
C155 4bitblock$2_0/1bitblock$3$2_0/a_510_63# 4bitblock_LAST_0/1bitblock$7_0/a_160_63# 0
C156 S0 4bitblock$1_0/m1_13543_n1146# 0.06508f
C157 4bitblock_LAST_0/1bitblock$3$4_0/a_6520_n37# m1_17790_n9717# -0.00406f
C158 4bitblock$2_0/1bitblock$5_0/a_8361_407# S1 0.01661f
C159 S0 4bitblock$2_0/1bitblock$1$2_0/a_5243_407# 0.01502f
C160 F AND4$4_0/a_518_229# 0.00143f
C161 S1 4bitblock$1_0/1bitblock$2$1_0/a_7083_63# 0.0493f
C162 XOR$9_0/a_705_407# m1_17790_n9717# 0.02457f
C163 4bitblock$2_0/m1_12480_n3815# AND4$4_0/a_518_229# 0
C164 4bitblock$2_0/1bitblock$5_0/a_7083_63# S1 0.05134f
C165 4bitblock$2_0/MUX21$2_0/a_157_63# m2_16192_n18174# 0.00229f
C166 4bitblock$2_0/MUX21$2_0/m2_540_79# VDD 0.00589f
C167 S1 4bitblock$1_0/m2_2396_n2595# 0.06358f
C168 m2_6320_n21444# 4bitblock_LAST_0/1bitblock$2$4_0/a_11480_63# 0
C169 4bitblock_0/1bitblock_0/m2_6151_79# VDD -0
C170 VDD 4bitblock$1_0/m2_10721_n3315# 0
C171 4bitblock$2_0/m1_14167_n1145# S1 0.08067f
C172 BP0 m1_17438_n9725# 0.03959f
C173 m1_17790_n9717# 4bitblock_LAST_0/MUX21$4_0/m2_540_79# 0.0117f
C174 BP1 4bitblock$1_0/m2_1701_n784# 0
C175 4bitblock_0/m1_13543_n1146# VDD 0.07097f
C176 S0 4bitblock$2_0/m1_12486_242# 0.04019f
C177 A3 4bitblock$1_0/1bitblock$4_0/a_705_407# 0
C178 m1_16199_n12176# m1_17438_n9725# 0.00781f
C179 S1 4bitblock$1_0/1bitblock$2$1_0/a_8723_63# 0.0451f
C180 4bitblock_LAST_0/m1_13543_n1146# 4bitblock_LAST_0/m2_2396_n2595# -0.00235f
C181 A11 B12 0
C182 m1_17790_n9717# 4bitblock_LAST_0/1bitblock$2$4_0/a_10906_466# 0
C183 4bitblock$2_0/MUX21$2_0/a_718_407# VDD -0
C184 4bitblock_0/MUX21_0/a_718_407# BP0 0.04927f
C185 4bitblock$2_0/1bitblock$5_0/a_8723_63# S1 0.06115f
C186 S0 4bitblock_LAST_0/1bitblock$7_0/a_5768_63# 0.00524f
C187 VDD 4bitblock$1_0/1bitblock$3$1_0/a_11922_3# 0
C188 S1 4bitblock$1_0/1bitblock$3$1_0/a_9050_63# 0.0038f
C189 BP0 BP1 0.7122f
C190 4bitblock$2_0/1bitblock$5_0/a_4290_63# 4bitblock$2_0/1bitblock$5_0/a_5042_407# 0
C191 VDD 4bitblock$1_0/1bitblock$3$1_0/a_7083_63# 0
C192 B3 A4 0
C193 4bitblock_0/1bitblock$2_0/a_5042_n37# S0 0
C194 4bitblock$2_0/m1_13543_n1146# B12 0
C195 B11 4bitblock_LAST_0/m1_14167_n1145# 0
C196 S0 4bitblock_LAST_0/1bitblock$7_0/a_5243_407# 0.0277f
C197 m1_16199_n12176# BP1 0.06447f
C198 4bitblock$2_0/1bitblock$2$2_0/a_8160_n37# S1 0
C199 VDD 4bitblock$1_0/1bitblock$3$1_0/a_1845_466# 0
C200 VDD 4bitblock$1_0/m1_13543_n1146# 0.07885f
C201 4bitblock_0/1bitblock$1_0/a_5042_n37# S0 0
C202 S0 4bitblock_LAST_0/1bitblock$3$4_0/m2_6151_79# -0.00104f
C203 S0 4bitblock$2_0/m2_1701_n784# 0.01512f
C204 A3 4bitblock$1_0/1bitblock$4_0/a_160_63# 0
C205 S1 4bitblock$1_0/1bitblock$4_0/m2_7791_79# 0.02648f
C206 S0 4bitblock$1_0/1bitblock$3$1_0/a_4650_n37# 0
C207 BP0 4bitblock_0/1bitblock$2_0/a_11922_3# 0
C208 4bitblock_LAST_0/1bitblock$3$4_0/a_7768_n37# m2_6320_n21444# 0.00134f
C209 VDD 4bitblock$1_0/1bitblock$3$1_0/a_8723_63# 0
C210 4bitblock$2_0/MUX21$2_0/a_517_n37# BP1 0
C211 F m1_17438_n9725# 0.04002f
C212 BP0 4bitblock_0/m2_10721_n3315# 0.01343f
C213 S0 m2_16192_n18174# 0.00243f
C214 4bitblock_0/1bitblock$3_0/a_11480_63# VDD 0
C215 VDD XOR$8_0/a_705_407# -0.00404f
C216 BP1 4bitblock$1_0/m2_2396_n2595# 0.02276f
C217 S0 4bitblock$1_0/1bitblock$1$1_0/m2_6151_79# 0.00108f
C218 4bitblock$2_0/m1_14167_n1145# BP1 0.06053f
C219 S1 4bitblock$1_0/1bitblock$1$1_0/a_7410_63# 0.00332f
C220 4bitblock$1_0/1bitblock$4_0/a_5768_63# 4bitblock$1_0/1bitblock$4_0/a_5042_407# -0
C221 VDD 4bitblock$1_0/1bitblock$3$1_0/a_10906_466# 0
C222 VDD 4bitblock_LAST_0/1bitblock$7_0/a_5768_63# 0
C223 F BP1 0.01942f
C224 S0 4bitblock$1_0/1bitblock$1$1_0/a_3498_3# 0.04718f
C225 S0 4bitblock_LAST_0/1bitblock$7_0/a_7083_63# 0
C226 4bitblock$2_0/m1_12480_n3815# BP1 0.00292f
C227 4bitblock$1_0/1bitblock$4_0/a_5243_407# 4bitblock$1_0/1bitblock$4_0/a_5042_407# -0
C228 4bitblock_0/m1_12484_n953# S1 0.04181f
C229 S1 m1_16451_n989# 0.04276f
C230 S0 4bitblock$1_0/1bitblock$1$1_0/a_2419_63# 0.00142f
C231 4bitblock_0/1bitblock$3_0/a_705_407# 4bitblock$1_0/1bitblock$4_0/a_705_407# 0.03896f
C232 m1_18541_n9769# VDD 0.01156f
C233 A3 4bitblock$1_0/1bitblock$4_0/a_510_63# 0
C234 BP1 4bitblock$1_0/MUX21$1_0/a_718_407# 0.0234f
C235 S0 4bitblock_LAST_0/m1_14167_n1145# 0.06972f
C236 BP1 4bitblock$1_0/MUX21$1_0/a_157_63# 0.04391f
C237 S0 m2_6320_n21444# 0.17115f
C238 S1 Y4 0
C239 BP2 4bitblock$2_0/1bitblock$1$2_0/a_2419_63# 0
C240 S0 4bitblock$1_0/1bitblock$3$1_0/a_4290_63# 0.00698f
C241 S1 4bitblock$1_0/1bitblock$4_0/a_8361_407# 0.01651f
C242 4bitblock$2_0/1bitblock$3$2_0/a_5768_63# S0 0.00624f
C243 4bitblock$1_0/1bitblock$4_0/a_2419_63# 4bitblock$1_0/m1_14167_n1145# 0
C244 S1 4bitblock$1_0/1bitblock$4_0/a_7083_63# 0.05134f
C245 VDD m2_16192_n18174# 0.3066f
C246 Z VDD -0
C247 S0 4bitblock$2_0/1bitblock$1$2_0/a_4650_n37# 0
C248 4bitblock$2_0/1bitblock$3$2_0/a_5243_407# S0 0.02703f
C249 S1 4bitblock$1_0/m1_14167_n1145# 0.07912f
C250 VDD 4bitblock$1_0/1bitblock$3$1_0/a_2861_3# 0
C251 S0 4bitblock$1_0/1bitblock$1$1_0/a_5042_407# 0.05877f
C252 4bitblock_0/1bitblock$3_0/a_705_407# 4bitblock$1_0/1bitblock$4_0/a_160_63# 0
C253 XOR$9_0/a_705_407# F 0.071f
C254 S0 4bitblock$1_0/1bitblock$2$1_0/m2_6151_79# 0.00108f
C255 S1 4bitblock$1_0/1bitblock$2$1_0/a_7410_63# 0.00332f
C256 VDD 4bitblock_LAST_0/1bitblock$7_0/a_11922_3# 0
C257 4bitblock$2_0/MUX21$2_0/m2_540_79# m2_16192_n18174# 0.02506f
C258 S0 4bitblock$2_0/1bitblock$5_0/m2_6151_79# 0.00478f
C259 4bitblock$2_0/1bitblock$5_0/a_7410_63# S1 0.00515f
C260 S1 4bitblock_LAST_0/1bitblock$7_0/a_9050_63# 0.0038f
C261 S1 4bitblock$1_0/1bitblock$4_0/a_8723_63# 0.061f
C262 S0 4bitblock$1_0/1bitblock$3$1_0/a_5042_n37# 0
C263 4bitblock_0/1bitblock$3_0/a_7410_63# VDD 0
C264 4bitblock_LAST_0/1bitblock$3$4_0/a_8160_n37# m2_6320_n21444# 0.0026f
C265 VDD 4bitblock_LAST_0/1bitblock$7_0/a_7083_63# 0
C266 S0 4bitblock$1_0/1bitblock$2$1_0/a_3498_3# 0.04813f
C267 4bitblock$2_0/m2_10721_n3315# S0 0.04202f
C268 S0 4bitblock$2_0/1bitblock$5_0/a_3498_3# 0.06927f
C269 4bitblock_0/MUX21_0/a_718_407# m1_16451_n989# 0
C270 S0 4bitblock$1_0/1bitblock$2$1_0/a_2419_63# 0.00267f
C271 S0 4bitblock$1_0/1bitblock$1$1_0/a_3940_63# 0.00362f
C272 4bitblock$2_0/1bitblock$5_0/a_510_63# 4bitblock$1_0/1bitblock$3$1_0/a_510_63# 0
C273 4bitblock_0/m2_2396_n2595# BP0 0.15584f
C274 VDD 4bitblock_LAST_0/1bitblock$7_0/a_1845_466# 0
C275 m1_17790_n9717# XOR$8_0/a_510_63# 0.03602f
C276 4bitblock_0/1bitblock_0/a_2419_63# S1 0.0027f
C277 VDD 4bitblock_LAST_0/m1_14167_n1145# 0.08612f
C278 4bitblock$2_0/1bitblock$5_0/a_2419_63# S0 0.00365f
C279 m2_6320_n21444# VDD 0.52612f
C280 4bitblock$2_0/MUX21$2_0/a_718_407# m2_16192_n18174# 0.01376f
C281 BP1 m1_16451_n989# 0.01808f
C282 VDD 4bitblock$1_0/1bitblock$3$1_0/a_4290_63# 0
C283 4bitblock$2_0/m1_14167_n1145# A7 0
C284 4bitblock$2_0/1bitblock$5_0/a_1845_466# A7 0
C285 S0 4bitblock$2_0/1bitblock$5_0/a_6721_407# 0.00776f
C286 4bitblock_0/1bitblock$3_0/a_510_63# A4 0
C287 4bitblock$2_0/1bitblock$3$2_0/a_5768_63# VDD 0
C288 BP2 m1_17790_n9717# 0
C289 S0 4bitblock$2_0/1bitblock$1$2_0/a_4290_63# 0.00441f
C290 N VDD -0
C291 VDD 4bitblock_LAST_0/1bitblock$7_0/a_8723_63# 0
C292 B8 B7 0.00216f
C293 4bitblock$1_0/1bitblock$4_0/a_510_63# 4bitblock_0/1bitblock$3_0/a_705_407# 0
C294 4bitblock$2_0/1bitblock$3$2_0/a_7083_63# S0 0
C295 VDD 4bitblock$1_0/1bitblock$3$1_0/a_7410_63# 0
C296 4bitblock$2_0/MUX21$2_0/m2_540_79# m2_6320_n21444# 0.001f
C297 XOR$9_0/a_1262_n37# m2_6320_n21444# 0
C298 4bitblock$2_0/1bitblock$5_0/a_705_407# VDD 0.00595f
C299 4bitblock_0/1bitblock$2_0/a_3498_3# S1 0.0033f
C300 m1_18541_n9769# XOR$8_0/a_705_407# 0
C301 4bitblock$2_0/m1_13543_n1146# S0 0.06508f
C302 A8 4bitblock$1_0/1bitblock$3$1_0/a_510_63# 0
C303 4bitblock$2_0/1bitblock$2$2_0/a_3498_3# S1 0.00338f
C304 S0 4bitblock$1_0/1bitblock$2$1_0/a_5042_407# 0.05876f
C305 4bitblock_0/1bitblock$3_0/a_4290_63# S0 0.00705f
C306 4bitblock_0/1bitblock_0/a_5042_407# S0 0.0684f
C307 4bitblock_0/1bitblock$2_0/a_5042_407# S0 0.05987f
C308 S0 4bitblock$2_0/1bitblock$5_0/a_5042_407# 0.07501f
C309 VDD 4bitblock_LAST_0/1bitblock$7_0/a_10906_466# 0
C310 A11 A12 0.02261f
C311 4bitblock$2_0/1bitblock$2$2_0/a_2419_63# S1 0.00274f
C312 BP1 4bitblock$1_0/m1_14167_n1145# 0.02489f
C313 4bitblock$2_0/m1_13543_n1146# 4bitblock_LAST_0/m1_12486_242# 0
C314 4bitblock$2_0/1bitblock$5_0/m2_6151_79# VDD -0
C315 4bitblock$2_0/MUX21$2_0/a_157_63# AND4$4_0/a_518_229# 0
C316 BP0 4bitblock$1_0/MUX21$1_0/m2_540_79# 0.02774f
C317 4bitblock$2_0/m2_10721_n3315# VDD -0.00101f
C318 4bitblock$2_0/1bitblock$5_0/a_3498_3# VDD 0.01293f
C319 S0 4bitblock$2_0/1bitblock$1$2_0/a_5042_n37# 0
C320 4bitblock$2_0/1bitblock$3$2_0/a_1845_466# A12 0
C321 4bitblock$2_0/1bitblock$2$2_0/m2_9431_79# S1 0.00105f
C322 4bitblock_0/1bitblock$2_0/m2_9431_79# S1 0.00102f
C323 4bitblock$2_0/m1_13543_n1146# A12 0
C324 4bitblock$2_0/1bitblock$5_0/a_2419_63# VDD 0.00103f
C325 S0 4bitblock$1_0/1bitblock$2$1_0/a_3940_63# 0.00362f
C326 VDD BP3 0.0498f
C327 4bitblock$2_0/1bitblock$5_0/a_160_63# VDD 0
C328 m1_16199_n12176# 4bitblock$1_0/MUX21$1_0/m2_540_79# 0.00976f
C329 4bitblock_0/MUX21_0/a_157_63# 4bitblock_0/m1_12480_n3815# 0
C330 4bitblock_LAST_0/MUX21$4_0/m2_540_79# 4bitblock_LAST_0/MUX21$4_0/a_157_63# -0
C331 4bitblock_0/1bitblock$2_0/a_2419_63# S1 0.0027f
C332 4bitblock_0/1bitblock_0/a_7768_n37# S1 0
C333 S0 4bitblock_LAST_0/1bitblock$7_0/a_4290_63# 0.00635f
C334 S0 4bitblock$2_0/1bitblock$5_0/a_3940_63# 0.00523f
C335 A11 VDD 0.00918f
C336 4bitblock_0/m2_10721_n3315# 4bitblock$1_0/m1_14167_n1145# 0
C337 4bitblock_0/1bitblock$3_0/a_2419_63# 4bitblock$1_0/1bitblock$4_0/a_2419_63# 0.0017f
C338 4bitblock$2_0/1bitblock$3$2_0/a_11922_3# VDD 0
C339 4bitblock$2_0/1bitblock$3$2_0/a_9050_63# S1 0.00379f
C340 4bitblock_0/1bitblock$2_0/m2_6151_79# S0 0.00113f
C341 BP0 4bitblock_0/1bitblock$2_0/a_10906_466# 0
C342 Y3 S1 0
C343 4bitblock$2_0/1bitblock$3$2_0/a_7083_63# VDD 0
C344 B3 4bitblock$1_0/m1_14167_n1145# 0
C345 4bitblock$2_0/MUX21$2_0/m2_540_79# BP3 0
C346 4bitblock_0/1bitblock$1_0/m2_7791_79# S1 0.01954f
C347 4bitblock_0/1bitblock$3_0/a_2419_63# S1 0.00273f
C348 4bitblock_LAST_0/MUX21$4_0/a_517_n37# BP3 0.00191f
C349 VDD 4bitblock_LAST_0/1bitblock$7_0/a_2861_3# 0
C350 4bitblock$2_0/1bitblock$3$2_0/a_1845_466# VDD 0
C351 4bitblock$2_0/m1_14167_n1145# 4bitblock$1_0/1bitblock$3$1_0/a_705_407# 0
C352 4bitblock$2_0/1bitblock$5_0/a_705_407# 4bitblock$1_0/m1_13543_n1146# 0.00102f
C353 4bitblock$2_0/m1_13543_n1146# VDD 0.07039f
C354 4bitblock_LAST_0/1bitblock$3$4_0/a_5768_63# m1_17790_n9717# -0.00536f
C355 4bitblock_0/1bitblock$3_0/a_4290_63# VDD 0
C356 B4 B3 0.00216f
C357 4bitblock_0/1bitblock_0/a_5042_407# VDD -0.00656f
C358 m2_6320_n21444# 4bitblock_LAST_0/1bitblock$2$4_0/a_9050_63# 0
C359 4bitblock$2_0/1bitblock$5_0/a_5042_407# VDD -0.00634f
C360 4bitblock_0/1bitblock$3_0/a_2861_3# 4bitblock$1_0/m1_14167_n1145# 0
C361 4bitblock$2_0/1bitblock$5_0/a_11480_63# VDD 0
C362 4bitblock$2_0/MUX21$2_0/a_718_407# BP3 0
C363 BP0 BP2 0.029f
C364 4bitblock_0/1bitblock$1_0/a_2419_63# S0 0.00147f
C365 Cin S1 0.042f
C366 BP0 4bitblock_0/m1_12480_n3815# 0.09129f
C367 4bitblock_LAST_0/1bitblock$7_0/a_5768_63# 4bitblock_LAST_0/m1_14167_n1145# -0
C368 4bitblock$2_0/1bitblock$3$2_0/a_4650_n37# S0 0
C369 4bitblock$2_0/1bitblock$3$2_0/a_8723_63# VDD 0
C370 4bitblock$2_0/1bitblock$5_0/a_2419_63# 4bitblock$1_0/1bitblock$3$1_0/a_11922_3# 0
C371 S0 4bitblock$1_0/1bitblock$4_0/m2_6151_79# 0.00466f
C372 4bitblock_LAST_0/1bitblock$7_0/a_5042_407# 4bitblock_LAST_0/1bitblock$7_0/m2_6151_79# -0
C373 S1 4bitblock$1_0/1bitblock$4_0/a_7410_63# 0.00511f
C374 4bitblock$2_0/1bitblock$3$2_0/a_510_63# B12 0
C375 B11 4bitblock_LAST_0/1bitblock$7_0/a_510_63# 0
C376 BP1 4bitblock$1_0/MUX21$1_0/a_517_n37# 0
C377 4bitblock$2_0/1bitblock$3$2_0/a_705_407# 4bitblock_LAST_0/1bitblock$7_0/a_705_407# 0.03896f
C378 BP2 m1_16199_n12176# 0
C379 4bitblock_0/1bitblock$1_0/a_9609_407# S1 0
C380 S1 4bitblock_LAST_0/1bitblock$1$4_0/m2_7791_79# 0
C381 4bitblock$1_0/AND4$1_0/a_518_229# 4bitblock$1_0/m2_2396_n2595# 0
C382 VDD 4bitblock$1_0/1bitblock$3$1_0/a_510_63# 0
C383 4bitblock$2_0/m1_14167_n1145# 4bitblock$1_0/1bitblock$3$1_0/a_3498_3# 0.00115f
C384 4bitblock$2_0/1bitblock$5_0/a_3498_3# 4bitblock$1_0/m1_13543_n1146# 0.00106f
C385 4bitblock_LAST_0/1bitblock$3$4_0/a_5768_63# 4bitblock_LAST_0/1bitblock$3$4_0/a_7083_63# -0
C386 4bitblock$1_0/1bitblock$4_0/a_4290_63# 4bitblock$1_0/1bitblock$4_0/a_5042_407# 0
C387 S0 4bitblock$1_0/1bitblock$4_0/a_3498_3# 0.07038f
C388 4bitblock_LAST_0/1bitblock$7_0/a_3498_3# 4bitblock_LAST_0/1bitblock$7_0/a_5042_407# -0.00373f
C389 4bitblock_0/1bitblock_0/m2_6151_79# 4bitblock_0/1bitblock_0/a_5042_407# -0
C390 S1 4bitblock$1_0/1bitblock$1$1_0/a_7768_n37# 0
C391 4bitblock_0/m1_12486_242# S1 0.0417f
C392 XOR$9_0/a_160_63# m1_17790_n9717# 0.00184f
C393 4bitblock$1_0/MUX21$1_0/m2_540_79# 4bitblock$1_0/MUX21$1_0/a_157_63# -0
C394 VDD 4bitblock_LAST_0/1bitblock$7_0/a_4290_63# -0
C395 4bitblock$2_0/1bitblock$5_0/a_160_63# 4bitblock$1_0/m1_13543_n1146# 0
C396 4bitblock$2_0/1bitblock$5_0/a_3940_63# VDD 0
C397 4bitblock$2_0/1bitblock$5_0/a_2419_63# 4bitblock$1_0/m1_13543_n1146# 0
C398 4bitblock$2_0/m1_14167_n1145# 4bitblock$1_0/1bitblock$3$1_0/a_2419_63# 0
C399 S0 4bitblock$1_0/1bitblock$4_0/a_2419_63# 0.00368f
C400 4bitblock$2_0/1bitblock$3$2_0/a_10906_466# VDD 0
C401 XOR$9_0/a_870_n37# m2_6320_n21444# 0.00201f
C402 4bitblock_0/1bitblock_0/a_7083_63# S1 0.04817f
C403 m2_6320_n21444# 4bitblock_LAST_0/1bitblock$3$4_0/m2_6151_79# 0.11082f
C404 4bitblock_0/m2_2396_n2595# 4bitblock_0/m1_12484_n953# -0.00927f
C405 m1_17790_n9717# 4bitblock_LAST_0/AND4$5_0/a_518_229# 0
C406 F XOR$8_0/a_1262_n37# 0.00247f
C407 S0 4bitblock$1_0/1bitblock$4_0/a_6721_407# 0.00779f
C408 S0 S1 0.03088f
C409 4bitblock_0/1bitblock$3_0/a_160_63# 4bitblock$1_0/1bitblock$4_0/a_705_407# 0
C410 4bitblock_0/1bitblock$1_0/a_8361_407# S1 0.00836f
C411 4bitblock_LAST_0/1bitblock$3$4_0/a_3498_3# m2_6320_n21444# 0.13744f
C412 VDD 4bitblock_LAST_0/1bitblock$7_0/a_7410_63# 0
C413 F XOR$8_0/a_510_63# 0.01627f
C414 4bitblock$1_0/MUX21$1_0/a_718_407# 4bitblock$1_0/AND4$1_0/a_518_229# -0
C415 4bitblock_LAST_0/m1_14167_n1145# m2_16192_n18174# 0
C416 4bitblock$2_0/MUX21$2_0/a_157_63# BP1 0.00859f
C417 4bitblock$2_0/1bitblock$3$2_0/a_160_63# 4bitblock_LAST_0/1bitblock$7_0/a_705_407# 0
C418 4bitblock$2_0/1bitblock$3$2_0/a_705_407# 4bitblock_LAST_0/1bitblock$7_0/a_160_63# 0
C419 m2_6320_n21444# m2_16192_n18174# 0.00954f
C420 4bitblock_LAST_0/1bitblock$3$4_0/a_2419_63# m2_6320_n21444# 0.0175f
C421 S1 4bitblock_LAST_0/m1_12486_242# 0
C422 Z m2_6320_n21444# 0.00526f
C423 4bitblock_0/1bitblock$1_0/a_7083_63# S1 0.04857f
C424 BP2 4bitblock$2_0/m1_14167_n1145# 0
C425 VDD 4bitblock$1_0/1bitblock$4_0/a_705_407# 0.00595f
C426 BP0 4bitblock$1_0/m1_12480_n3815# 0.03397f
C427 4bitblock$2_0/1bitblock$3$2_0/a_4290_63# S0 0.00698f
C428 m2_6320_n21444# 4bitblock_LAST_0/1bitblock$3$4_0/a_6721_407# 0.02772f
C429 F BP2 0.00142f
C430 4bitblock_0/m2_1701_n784# S1 0.01438f
C431 BP0 4bitblock$1_0/MUX21$1_0/a_909_n37# 0
C432 4bitblock$2_0/m1_12480_n3815# BP2 0.14561f
C433 m1_16199_n12176# 4bitblock$1_0/m1_12480_n3815# 0.17322f
C434 4bitblock$2_0/1bitblock$5_0/a_11480_63# 4bitblock$1_0/m1_13543_n1146# 0
C435 4bitblock$2_0/m1_14167_n1145# 4bitblock$1_0/1bitblock$3$1_0/a_11480_63# 0
C436 S0 4bitblock$1_0/1bitblock$4_0/a_5042_407# 0.07637f
C437 4bitblock_0/1bitblock$2_0/a_5768_63# S0 0.002f
C438 4bitblock$2_0/1bitblock$3$2_0/a_3498_3# 4bitblock_LAST_0/1bitblock$7_0/a_3498_3# 0.00641f
C439 m2_6320_n21444# 4bitblock_LAST_0/1bitblock$3$4_0/m2_9431_79# 0.02549f
C440 4bitblock_LAST_0/m1_13543_n1146# m1_17790_n9717# 0.07448f
C441 4bitblock_LAST_0/1bitblock$7_0/a_11922_3# 4bitblock_LAST_0/m1_14167_n1145# -0
C442 4bitblock_LAST_0/1bitblock$3$4_0/a_10906_n37# m2_6320_n21444# 0.00203f
C443 AND4$4_0/a_518_229# VDD 0.00113f
C444 4bitblock_0/1bitblock$3_0/a_160_63# 4bitblock$1_0/1bitblock$4_0/a_160_63# 0
C445 4bitblock_0/1bitblock$2_0/a_4290_63# S0 0.00449f
C446 4bitblock_0/1bitblock$1_0/a_8723_63# S1 0.04437f
C447 S1 4bitblock_LAST_0/1bitblock$1$4_0/a_7083_63# 0
C448 VDD 4bitblock$1_0/1bitblock$4_0/a_3498_3# 0.01273f
C449 4bitblock$2_0/1bitblock$3$2_0/a_2861_3# VDD 0
C450 4bitblock$2_0/1bitblock$3$2_0/a_2419_63# 4bitblock_LAST_0/1bitblock$7_0/a_2419_63# 0.0017f
C451 4bitblock$1_0/1bitblock$4_0/a_9609_407# S1 0.00898f
C452 4bitblock_0/1bitblock$3_0/a_8723_63# VDD 0
C453 4bitblock_0/m1_13543_n1146# 4bitblock$1_0/1bitblock$4_0/a_705_407# 0.00102f
C454 4bitblock$2_0/1bitblock$3$2_0/a_160_63# 4bitblock_LAST_0/1bitblock$7_0/a_160_63# 0
C455 S1 4bitblock$1_0/1bitblock$2$1_0/a_7768_n37# 0
C456 BP0 4bitblock_0/m1_14167_n1145# 0.00723f
C457 VDD 4bitblock$1_0/1bitblock$4_0/a_2419_63# 0.00103f
C458 S1 4bitblock_LAST_0/m2_1701_n784# 0.001f
C459 4bitblock_LAST_0/m1_12480_n3815# m2_16192_n18174# 0.00175f
C460 VDD 4bitblock$1_0/1bitblock$4_0/a_160_63# 0
C461 S1 4bitblock$1_0/1bitblock$3$1_0/m2_7791_79# 0.02215f
C462 4bitblock_0/1bitblock$3_0/a_2861_3# 4bitblock$1_0/1bitblock$4_0/a_2861_3# 0
C463 4bitblock_LAST_0/1bitblock$3$4_0/a_11480_63# m2_6320_n21444# 0.01385f
C464 4bitblock$2_0/1bitblock$5_0/a_7768_n37# S1 0
C465 S0 4bitblock$1_0/1bitblock$4_0/a_3940_63# 0.0052f
C466 4bitblock_0/1bitblock$2_0/a_8723_63# S1 0.04377f
C467 S1 VDD 0.76923f
C468 4bitblock$2_0/1bitblock$3$2_0/a_5042_n37# S0 0
C469 N m2_6320_n21444# 0.00355f
C470 4bitblock$2_0/m1_14167_n1145# 4bitblock$1_0/m1_12480_n3815# 0.00355f
C471 S1 4bitblock_LAST_0/1bitblock$1$4_0/a_8723_63# 0.00129f
C472 m2_16192_n18174# BP3 0.60815f
C473 Z BP3 0
C474 BP0 XOR$9_0/a_160_63# 0.00968f
C475 4bitblock_0/m1_13543_n1146# 4bitblock$1_0/1bitblock$4_0/a_3498_3# 0.00106f
C476 S1 4bitblock$1_0/1bitblock$1$1_0/a_8160_n37# 0
C477 4bitblock$2_0/1bitblock$5_0/a_2419_63# 4bitblock$1_0/1bitblock$3$1_0/a_2861_3# 0
C478 S1 4bitblock$1_0/1bitblock$3$1_0/a_9609_407# 0.00916f
C479 4bitblock$2_0/1bitblock$2$2_0/a_5768_63# S0 0.00192f
C480 BP0 m1_17790_n9717# 0
C481 4bitblock$2_0/1bitblock$3$2_0/a_4290_63# VDD 0
C482 4bitblock_0/m1_13543_n1146# 4bitblock$1_0/1bitblock$4_0/a_160_63# 0
C483 4bitblock_0/m1_13543_n1146# 4bitblock$1_0/1bitblock$4_0/a_2419_63# 0
C484 S1 4bitblock$1_0/m2_10721_n3315# 0.0426f
C485 VDD 4bitblock$1_0/1bitblock$4_0/a_5042_407# -0.00689f
C486 4bitblock$2_0/AND4$2_0/a_518_229# 4bitblock$2_0/m1_12484_n953# -0.00634f
C487 4bitblock$1_0/MUX21$1_0/m2_540_79# 4bitblock$1_0/m1_14167_n1145# -0.01316f
C488 4bitblock_0/MUX21_0/m2_540_79# BP0 0.01095f
C489 4bitblock_LAST_0/m1_12480_n3815# m2_6320_n21444# 0.05044f
C490 m1_16199_n12176# m1_17790_n9717# 0
C491 VDD 4bitblock$1_0/1bitblock$4_0/a_11480_63# 0
C492 4bitblock$2_0/1bitblock$2$2_0/a_5243_407# S0 0.01502f
C493 4bitblock_0/m1_13543_n1146# S1 0.07245f
C494 4bitblock$2_0/1bitblock$3$2_0/a_7410_63# VDD 0
C495 4bitblock_LAST_0/1bitblock$7_0/a_4290_63# 4bitblock_LAST_0/1bitblock$7_0/a_5768_63# -0
C496 VDD 4bitblock_LAST_0/1bitblock$7_0/a_510_63# 0
C497 4bitblock$1_0/1bitblock$4_0/a_510_63# VDD 0
C498 4bitblock$2_0/m1_13543_n1146# m2_16192_n18174# 0
C499 4bitblock$2_0/m2_10721_n3315# 4bitblock_LAST_0/m1_14167_n1145# 0
C500 S1 Y7 0
C501 B4 4bitblock_0/1bitblock$3_0/a_510_63# 0
C502 4bitblock_0/1bitblock$3_0/a_5042_407# S0 0.06393f
C503 4bitblock_0/m1_12480_n3815# m1_16451_n989# 0.09845f
C504 4bitblock_0/1bitblock$2_0/a_7768_n37# S1 0
C505 S1 4bitblock$1_0/1bitblock$3$1_0/a_8361_407# 0.01631f
C506 4bitblock$2_0/1bitblock$3$2_0/a_11922_3# 4bitblock_LAST_0/1bitblock$7_0/a_11922_3# 0
C507 4bitblock$2_0/1bitblock$5_0/a_510_63# A7 0
C508 4bitblock_0/m2_10721_n3315# S0 0.04261f
C509 VDD m1_17438_n9725# 0.44741f
C510 m2_6320_n21444# BP3 0.06626f
C511 4bitblock_0/m2_2396_n2595# 4bitblock_0/AND4_0/a_518_229# -0
C512 VDD 4bitblock$1_0/1bitblock$4_0/a_3940_63# 0
C513 S1 4bitblock$1_0/1bitblock$3$1_0/a_7083_63# 0.04986f
C514 A11 4bitblock_LAST_0/m1_14167_n1145# 0
C515 A11 4bitblock_LAST_0/1bitblock$7_0/a_1845_466# 0
C516 4bitblock$2_0/m1_12484_n953# S0 0.0407f
C517 4bitblock$2_0/1bitblock$1$2_0/m2_7791_79# S1 0.02042f
C518 4bitblock_0/m1_13543_n1146# 4bitblock$1_0/1bitblock$4_0/a_11480_63# 0
C519 4bitblock$2_0/m1_13543_n1146# 4bitblock_LAST_0/1bitblock$7_0/a_11922_3# 0
C520 4bitblock$2_0/1bitblock$3$2_0/a_11922_3# 4bitblock_LAST_0/m1_14167_n1145# 0
C521 S1 4bitblock$1_0/m1_13543_n1146# 0.07395f
C522 4bitblock$2_0/1bitblock$3$2_0/a_11480_63# 4bitblock_LAST_0/1bitblock$7_0/a_11480_63# 0
C523 4bitblock_0/MUX21_0/a_157_63# BP0 0.00276f
C524 XOR$9_0/a_160_63# F 0.0508f
C525 VDD BP1 0.40522f
C526 4bitblock$2_0/1bitblock$3$2_0/a_1845_466# 4bitblock_LAST_0/1bitblock$7_0/a_1845_466# 0
C527 F m1_17790_n9717# 0.31238f
C528 4bitblock$2_0/1bitblock$3$2_0/a_1845_466# 4bitblock_LAST_0/m1_14167_n1145# 0
C529 4bitblock$2_0/m1_13543_n1146# 4bitblock_LAST_0/1bitblock$7_0/a_1845_466# 0
C530 4bitblock$2_0/m1_13543_n1146# 4bitblock_LAST_0/m1_14167_n1145# 2.61413f
C531 S1 4bitblock$1_0/1bitblock$2$1_0/a_8160_n37# 0
C532 4bitblock_0/m1_12480_n3815# 4bitblock$1_0/m1_14167_n1145# 0.00355f
C533 A8 A7 0.02261f
C534 S1 4bitblock$1_0/1bitblock$3$1_0/a_8723_63# 0.04779f
C535 4bitblock$2_0/1bitblock$5_0/a_8160_n37# S1 0
C536 4bitblock$2_0/1bitblock$1$2_0/a_9609_407# S1 0
C537 4bitblock_LAST_0/m1_12480_n3815# BP3 0.00584f
C538 4bitblock$2_0/m2_2396_n2595# S0 0.04514f
C539 4bitblock$2_0/m1_12486_242# S1 0.04241f
C540 4bitblock$2_0/MUX21$2_0/m2_540_79# BP1 0.0119f
C541 4bitblock$2_0/1bitblock$3$2_0/a_510_63# A12 0
C542 4bitblock_0/1bitblock_0/a_5042_n37# S0 0
C543 4bitblock_0/1bitblock$3_0/a_5042_407# VDD 0
C544 4bitblock_0/1bitblock$1_0/m2_6151_79# S0 0.00113f
C545 4bitblock_0/m2_10721_n3315# VDD -0.00101f
C546 AND4$4_0/a_704_n441# m2_6320_n21444# 0.00601f
C547 4bitblock_0/1bitblock_0/a_5768_63# 4bitblock_0/m1_14167_n1145# -0
C548 S1 4bitblock_LAST_0/1bitblock$7_0/m2_7791_79# 0.02405f
C549 B3 VDD 0.00238f
C550 4bitblock_0/1bitblock$1_0/a_3498_3# S0 0.04803f
C551 4bitblock$2_0/1bitblock$1$2_0/a_8361_407# S1 0.00856f
C552 4bitblock$2_0/MUX21$2_0/a_718_407# BP1 0.00415f
C553 BP0 m1_16199_n12176# 0.6636f
C554 4bitblock$2_0/m1_13543_n1146# 4bitblock_LAST_0/1bitblock$7_0/a_10906_466# 0
C555 4bitblock$2_0/1bitblock$3$2_0/a_10906_466# 4bitblock_LAST_0/m1_14167_n1145# 0
C556 4bitblock$2_0/m1_12484_n953# VDD -0.02411f
C557 S1 4bitblock$1_0/1bitblock$4_0/a_7768_n37# 0
C558 4bitblock_0/1bitblock$3_0/a_11480_63# 4bitblock$1_0/1bitblock$4_0/a_11480_63# 0
C559 AND4$4_0/a_518_229# m2_16192_n18174# 0.00321f
C560 XOR$9_0/a_705_407# VDD -0.00187f
C561 4bitblock_0/1bitblock$3_0/a_3498_3# 4bitblock$1_0/m1_14167_n1145# 0.00115f
C562 4bitblock$2_0/1bitblock$1$2_0/a_7083_63# S1 0.04959f
C563 4bitblock$2_0/1bitblock$5_0/a_5768_63# 4bitblock$2_0/m1_14167_n1145# -0
C564 4bitblock$2_0/1bitblock$5_0/a_5042_407# 4bitblock$2_0/1bitblock$5_0/m2_6151_79# -0
C565 4bitblock$2_0/1bitblock$5_0/a_510_63# 4bitblock$1_0/1bitblock$3$1_0/a_705_407# 0
C566 4bitblock$2_0/1bitblock$5_0/a_705_407# 4bitblock$1_0/1bitblock$3$1_0/a_510_63# 0
C567 4bitblock$1_0/m1_14167_n1145# 4bitblock$1_0/m1_12480_n3815# -0
C568 4bitblock_0/1bitblock_0/a_3498_3# S0 0.00838f
C569 4bitblock$2_0/1bitblock$3$2_0/a_510_63# VDD 0
C570 4bitblock$2_0/m1_13543_n1146# 4bitblock$2_0/m2_10721_n3315# -0
C571 4bitblock_0/1bitblock$3_0/a_2861_3# VDD 0
C572 m2_6320_n21444# 4bitblock_LAST_0/1bitblock$2$4_0/a_9408_n37# 0
C573 4bitblock$2_0/m2_1701_n784# S1 0.01459f
C574 4bitblock_0/m1_13543_n1146# 4bitblock_0/1bitblock$2_0/a_11922_3# -0
C575 XOR$9_0/a_510_63# m2_6320_n21444# 0.01068f
C576 BP0 4bitblock$2_0/MUX21$2_0/a_517_n37# 0
C577 4bitblock$2_0/1bitblock$5_0/a_3498_3# 4bitblock$2_0/1bitblock$5_0/a_5042_407# -0.00373f
C578 BP1 4bitblock$1_0/m1_13543_n1146# 0.09607f
C579 4bitblock$2_0/1bitblock$2$2_0/a_11922_3# VDD -0
C580 m1_17438_n9725# XOR$8_0/a_705_407# 0.02314f
C581 4bitblock_0/m2_2396_n2595# S0 0.04577f
C582 S1 m2_16192_n18174# 0.0012f
C583 m1_17790_n9717# 4bitblock_LAST_0/MUX21$4_0/a_157_63# 0
C584 S0 4bitblock_LAST_0/1bitblock$1$4_0/a_2419_63# 0
C585 4bitblock$2_0/1bitblock$1$2_0/a_8723_63# S1 0.04471f
C586 4bitblock_0/1bitblock_0/a_4290_63# 4bitblock_0/1bitblock_0/a_5768_63# -0
C587 4bitblock$2_0/1bitblock$2$2_0/a_2419_63# BP2 0
C588 4bitblock_0/1bitblock$3_0/a_7083_63# S0 0
C589 4bitblock$2_0/1bitblock$3$2_0/a_10906_466# 4bitblock_LAST_0/1bitblock$7_0/a_10906_466# 0
C590 B8 VDD 0.0024f
C591 4bitblock$1_0/MUX21$1_0/a_718_407# 4bitblock$1_0/m2_1701_n784# -0
C592 4bitblock_0/1bitblock$1_0/a_5042_407# S0 0.05987f
C593 S1 Y12 0
C594 AND4$4_0/a_518_229# m2_6320_n21444# 0.03817f
C595 4bitblock$2_0/1bitblock$5_0/a_9050_63# VDD 0
C596 A8 4bitblock$1_0/1bitblock$3$1_0/a_705_407# 0
C597 BP0 F 0.06751f
C598 4bitblock_0/MUX21_0/m2_540_79# m1_16451_n989# 0.00607f
C599 S1 4bitblock_LAST_0/1bitblock$7_0/a_8361_407# 0.0167f
C600 4bitblock$2_0/1bitblock$5_0/a_160_63# 4bitblock$1_0/1bitblock$3$1_0/a_510_63# 0
C601 4bitblock_0/1bitblock_0/a_7410_63# S1 0.00259f
C602 BP0 4bitblock$2_0/m1_12480_n3815# 0
C603 VDD A7 0.00918f
C604 4bitblock$2_0/m1_13543_n1146# 4bitblock_LAST_0/1bitblock$7_0/a_2861_3# 0
C605 4bitblock$2_0/1bitblock$3$2_0/a_2861_3# 4bitblock_LAST_0/m1_14167_n1145# 0
C606 S1 4bitblock$1_0/1bitblock$1$1_0/a_3498_3# 0.00335f
C607 4bitblock$2_0/1bitblock$2$2_0/a_4650_n37# S0 0
C608 AND4$4_0/a_704_n441# BP3 0.0108f
C609 4bitblock_0/1bitblock$3_0/a_7410_63# S1 0.005f
C610 m1_18541_n9769# m1_17438_n9725# 0.04081f
C611 A3 A4 0.02261f
C612 F m1_16199_n12176# 0
C613 S1 4bitblock_LAST_0/1bitblock$7_0/a_7083_63# 0.00474f
C614 4bitblock_0/1bitblock$3_0/a_11922_3# 4bitblock$1_0/1bitblock$4_0/a_11922_3# 0
C615 BP0 4bitblock$1_0/MUX21$1_0/a_718_407# 0.00585f
C616 S1 4bitblock$1_0/1bitblock$1$1_0/a_2419_63# 0.00147f
C617 BP0 4bitblock$1_0/MUX21$1_0/a_157_63# 0.0024f
C618 BP2 4bitblock$2_0/MUX21$2_0/a_157_63# 0.00174f
C619 S1 4bitblock_LAST_0/m1_14167_n1145# 0.07919f
C620 S1 m2_6320_n21444# 0.02844f
C621 S0 4bitblock_LAST_0/1bitblock$1$4_0/a_5042_407# 0
C622 4bitblock_0/1bitblock$1_0/a_3940_63# S0 0.00363f
C623 m1_16199_n12176# 4bitblock$1_0/MUX21$1_0/a_718_407# 0
C624 m1_16199_n12176# 4bitblock$1_0/MUX21$1_0/a_157_63# 0
C625 4bitblock_0/1bitblock_0/a_3498_3# VDD -0.00181f
C626 4bitblock_0/1bitblock$2_0/m2_7791_79# S1 0.01955f
C627 4bitblock_0/1bitblock$3_0/a_11922_3# 4bitblock$1_0/m1_14167_n1145# 0
C628 AND4$4_0/a_912_n441# m2_6320_n21444# 0.01056f
C629 S1 4bitblock$1_0/1bitblock$1$1_0/m2_9431_79# 0.00107f
C630 A8 4bitblock$1_0/1bitblock$3$1_0/a_160_63# 0
C631 4bitblock_0/MUX21_0/a_157_63# m1_16451_n989# 0
C632 S1 4bitblock_LAST_0/1bitblock$7_0/a_8723_63# 0.03742f
C633 4bitblock$2_0/1bitblock$3$2_0/m2_7791_79# S1 0.02257f
C634 XOR$9_0/a_870_n37# BP1 0.00129f
C635 4bitblock_0/1bitblock$2_0/a_3940_63# S0 0.00363f
C636 4bitblock_0/1bitblock_0/m2_7791_79# S1 0.0191f
C637 S0 4bitblock$1_0/1bitblock$3$1_0/m2_6151_79# 0.00468f
C638 S1 4bitblock$1_0/1bitblock$3$1_0/a_7410_63# 0.00503f
C639 S1 4bitblock$1_0/1bitblock$4_0/a_8160_n37# 0
C640 4bitblock_LAST_0/1bitblock$3$4_0/a_6128_n37# m2_6320_n21444# 0
C641 4bitblock_0/1bitblock$3_0/a_7083_63# VDD 0
C642 S0 4bitblock$1_0/1bitblock$3$1_0/a_3498_3# 0.06346f
C643 4bitblock$2_0/AND4$2_0/a_518_229# BP2 0.01187f
C644 BP1 m2_16192_n18174# 0.00556f
C645 4bitblock$2_0/m1_14167_n1145# B7 0
C646 B8 4bitblock$1_0/m1_13543_n1146# 0
C647 4bitblock$1_0/MUX21$1_0/a_718_407# 4bitblock$1_0/m2_2396_n2595# -0.00276f
C648 m2_6320_n21444# 4bitblock_LAST_0/1bitblock$2$4_0/m2_7791_79# 0
C649 4bitblock$2_0/1bitblock$2$2_0/a_4290_63# S0 0.00441f
C650 AND4$4_0/a_518_229# BP3 0.01098f
C651 Z BP1 0.0269f
C652 4bitblock$1_0/MUX21$1_0/a_157_63# 4bitblock$1_0/m2_2396_n2595# -0
C653 m2_6320_n21444# 4bitblock_LAST_0/1bitblock$2$4_0/a_9800_n37# 0
C654 S0 4bitblock$1_0/1bitblock$3$1_0/a_2419_63# 0.00346f
C655 4bitblock$2_0/1bitblock$3$2_0/a_9609_407# S1 0.0091f
C656 S0 4bitblock$1_0/1bitblock$3$1_0/a_6721_407# 0.00785f
C657 S1 4bitblock$1_0/1bitblock$2$1_0/a_3498_3# 0.00335f
C658 m2_6320_n21444# m1_17438_n9725# 0.04218f
C659 4bitblock_0/1bitblock$3_0/m2_6151_79# S0 0.00473f
C660 4bitblock_0/m2_2396_n2595# 4bitblock_0/m1_13543_n1146# -0.0028f
C661 4bitblock$2_0/1bitblock$5_0/a_3498_3# S1 0.00559f
C662 4bitblock$2_0/m2_10721_n3315# S1 0.04253f
C663 S1 4bitblock$1_0/1bitblock$2$1_0/a_2419_63# 0.00275f
C664 BP0 4bitblock_0/m1_12484_n953# 0.3142f
C665 BP0 m1_16451_n989# 0.33519f
C666 4bitblock$2_0/1bitblock$3$2_0/a_705_407# B12 0
C667 B11 4bitblock_LAST_0/1bitblock$7_0/a_705_407# 0
C668 XOR$9_0/a_705_407# m1_18541_n9769# 0
C669 4bitblock$2_0/1bitblock$5_0/a_2419_63# S1 0.00299f
C670 VDD 4bitblock$1_0/1bitblock$3$1_0/a_705_407# 0.00599f
C671 4bitblock_LAST_0/1bitblock$3$4_0/a_9050_63# m2_6320_n21444# 0.0142f
C672 4bitblock$2_0/m1_12484_n953# 4bitblock$2_0/m2_1701_n784# -0.00165f
C673 Y11 S1 0
C674 4bitblock$2_0/1bitblock$5_0/a_4290_63# 4bitblock$2_0/1bitblock$5_0/a_5768_63# -0
C675 m1_16199_n12176# m1_16451_n989# 0.00976f
C676 4bitblock_LAST_0/MUX21$4_0/a_718_407# m2_16192_n18174# -0
C677 m1_17438_n9725# XOR$8_0/a_870_n37# 0
C678 4bitblock_0/1bitblock$3_0/a_705_407# A4 0
C679 AND4$4_0/a_912_n441# BP3 0.00808f
C680 m2_6320_n21444# 4bitblock_LAST_0/m1_12484_n953# 0.00954f
C681 4bitblock$2_0/1bitblock$3$2_0/a_2861_3# 4bitblock_LAST_0/1bitblock$7_0/a_2861_3# 0
C682 4bitblock$2_0/1bitblock$3$2_0/a_8361_407# S1 0.01639f
C683 S1 4bitblock$1_0/1bitblock$2$1_0/m2_9431_79# 0.00107f
C684 VDD 4bitblock$1_0/MUX21$1_0/m2_540_79# -0.00518f
C685 4bitblock_0/1bitblock$3_0/a_510_63# VDD 0
C686 m2_6320_n21444# BP1 0.26267f
C687 AND4$4_0/a_1120_n441# m2_6320_n21444# 0.00561f
C688 S0 4bitblock$1_0/1bitblock$3$1_0/a_5042_407# 0.06283f
C689 4bitblock$2_0/1bitblock$2$2_0/a_5042_n37# S0 0
C690 4bitblock$2_0/1bitblock$5_0/m2_9431_79# S1 0.00411f
C691 4bitblock$2_0/1bitblock$3$2_0/a_7083_63# S1 0.04986f
C692 m2_6320_n21444# Y14 0
C693 N BP1 0
C694 S0 4bitblock$2_0/1bitblock$1$2_0/m2_6151_79# 0.00108f
C695 4bitblock$2_0/1bitblock$1$2_0/a_7410_63# S1 0.00336f
C696 VDD 4bitblock$1_0/1bitblock$3$1_0/a_3498_3# 0.01473f
C697 4bitblock$2_0/m1_13543_n1146# S1 0.0736f
C698 4bitblock_0/1bitblock$3_0/a_1845_466# A4 0
C699 m2_6320_n21444# 4bitblock_LAST_0/1bitblock$2$4_0/a_11922_3# 0
C700 4bitblock$2_0/1bitblock$3$2_0/a_160_63# B12 0
C701 VDD 4bitblock$1_0/1bitblock$3$1_0/a_2419_63# 0.00106f
C702 m2_6320_n21444# 4bitblock_LAST_0/1bitblock$2$4_0/a_7083_63# 0.003f
C703 S0 4bitblock$2_0/1bitblock$1$2_0/a_3498_3# 0.04718f
C704 VDD 4bitblock$1_0/1bitblock$3$1_0/a_160_63# 0
C705 VDD 4bitblock$1_0/1bitblock$4_0/a_9050_63# 0
C706 4bitblock_LAST_0/MUX21$4_0/m2_540_79# m2_16192_n18174# -0.00178f
C707 4bitblock_0/1bitblock$3_0/a_6721_407# S0 0.00789f
C708 S0 4bitblock$1_0/1bitblock$3$1_0/a_3940_63# 0.00494f
C709 S0 4bitblock$2_0/1bitblock$1$2_0/a_2419_63# 0.00142f
C710 VDD XOR$8_0/a_510_63# 0
C711 4bitblock_0/1bitblock$3_0/a_3498_3# S0 0.06446f
C712 4bitblock$2_0/1bitblock$3$2_0/a_8723_63# S1 0.04674f
C713 A11 4bitblock_LAST_0/1bitblock$7_0/a_510_63# 0
C714 m2_6320_n21444# 4bitblock_LAST_0/m2_2396_n2595# 0
C715 m1_17438_n9725# BP3 0.03114f
C716 4bitblock_0/1bitblock_0/a_8723_63# S1 0.0494f
C717 4bitblock_0/1bitblock$3_0/a_5042_n37# S0 0
C718 4bitblock_LAST_0/1bitblock$3$4_0/a_6520_n37# m2_6320_n21444# 0.00712f
C719 XOR$9_0/a_510_63# AND4$4_0/a_518_229# 0
C720 BP2 VDD 0.39411f
C721 4bitblock_0/m1_12480_n3815# VDD 0.00119f
C722 4bitblock_0/1bitblock$1_0/a_7768_n37# S1 0
C723 m2_6320_n21444# 4bitblock_LAST_0/1bitblock$2$4_0/a_8723_63# 0
C724 4bitblock$1_0/1bitblock$4_0/a_5768_63# 4bitblock$1_0/1bitblock$4_0/a_5243_407# -0
C725 4bitblock_0/1bitblock$2_0/a_5243_407# S0 0.01524f
C726 BP0 4bitblock_0/AND4_0/a_912_n441# 0
C727 VDD 4bitblock$1_0/1bitblock$3$1_0/a_5042_407# 0
C728 AND4$4_0/a_1120_n441# BP3 0.00537f
C729 BP1 BP3 0.02544f
C730 4bitblock$1_0/m2_2396_n2595# 4bitblock$1_0/m1_14167_n1145# 0
C731 VDD 4bitblock$1_0/1bitblock$3$1_0/a_11480_63# 0
C732 S0 4bitblock_LAST_0/1bitblock$3$4_0/a_5768_63# -0
C733 m2_6320_n21444# 4bitblock_LAST_0/MUX21$4_0/m2_540_79# 0.00171f
C734 S0 4bitblock_LAST_0/1bitblock$7_0/m2_6151_79# 0.00364f
C735 S1 4bitblock_LAST_0/1bitblock$7_0/a_7410_63# 0.00259f
C736 4bitblock$2_0/MUX21$2_0/m2_540_79# BP2 0.00966f
C737 S0 4bitblock$2_0/1bitblock$1$2_0/a_5042_407# 0.05876f
C738 4bitblock_LAST_0/MUX21$4_0/a_718_407# 4bitblock_LAST_0/m1_12480_n3815# -0.00102f
C739 4bitblock_0/m1_14167_n1145# S0 0.00373f
C740 m2_6320_n21444# 4bitblock_LAST_0/1bitblock$2$4_0/a_10906_466# 0
C741 4bitblock_0/1bitblock_0/a_4290_63# Cin 0
C742 S0 4bitblock_LAST_0/1bitblock$7_0/a_3498_3# 0.0693f
C743 4bitblock$1_0/1bitblock$3$1_0/a_3498_3# 4bitblock$1_0/m1_13543_n1146# -0
C744 4bitblock_0/m1_12480_n3815# 4bitblock_0/m1_13543_n1146# -0
C745 S0 4bitblock_LAST_0/1bitblock$7_0/a_2419_63# 0.00152f
C746 4bitblock_0/1bitblock$1_0/a_2419_63# S1 0.00144f
C747 VDD 4bitblock$1_0/1bitblock$3$1_0/a_3940_63# 0
C748 BP2 4bitblock$2_0/MUX21$2_0/a_718_407# 0.04382f
C749 BP0 4bitblock$1_0/MUX21$1_0/a_517_n37# 0
C750 4bitblock$1_0/MUX21$1_0/a_718_407# 4bitblock$1_0/m1_14167_n1145# -0
C751 4bitblock_0/1bitblock$3_0/a_3498_3# VDD 0.01473f
C752 4bitblock_LAST_0/MUX21$4_0/a_718_407# BP3 0.01237f
C753 S0 4bitblock_LAST_0/1bitblock$7_0/a_6721_407# 0.00776f
C754 S0 4bitblock$1_0/1bitblock$1$1_0/a_5768_63# 0.00192f
C755 4bitblock$1_0/MUX21$1_0/a_157_63# 4bitblock$1_0/m1_14167_n1145# -0.00152f
C756 S0 4bitblock$2_0/1bitblock$1$2_0/a_3940_63# 0.00362f
C757 4bitblock$2_0/MUX21$2_0/a_909_n37# BP1 0.00254f
C758 4bitblock_0/AND4_0/a_518_229# BP0 0.01455f
C759 VDD 4bitblock$1_0/m1_12480_n3815# 0.00674f
C760 4bitblock_0/1bitblock$2_0/a_4650_n37# S0 0
C761 S1 4bitblock$1_0/1bitblock$4_0/a_3498_3# 0.00554f
C762 4bitblock_LAST_0/m1_12480_n3815# 4bitblock_LAST_0/MUX21$4_0/m2_540_79# -0
C763 S0 4bitblock$1_0/1bitblock$1$1_0/a_5243_407# 0.01502f
C764 VDD 4bitblock_LAST_0/1bitblock$7_0/a_705_407# 0.00595f
C765 4bitblock_0/1bitblock$3_0/a_8723_63# S1 0.0464f
C766 4bitblock_0/1bitblock_0/a_4290_63# S0 0.00631f
C767 S1 4bitblock$1_0/1bitblock$4_0/a_2419_63# 0.00297f
C768 4bitblock_0/1bitblock$2_0/a_2419_63# BP0 0
C769 4bitblock$2_0/1bitblock$5_0/a_705_407# A7 0
C770 S0 4bitblock_LAST_0/1bitblock$7_0/a_5042_407# 0.02425f
C771 AND4$4_0/a_704_n441# BP1 0.00114f
C772 XOR$9_0/a_510_63# m1_17438_n9725# 0
C773 BP0 4bitblock$2_0/MUX21$2_0/a_157_63# 0.00226f
C774 4bitblock_0/m1_13543_n1146# 4bitblock_0/1bitblock$3_0/a_3498_3# -0
C775 A3 4bitblock$1_0/1bitblock$4_0/a_1845_466# 0
C776 A3 4bitblock$1_0/m1_14167_n1145# 0
C777 VDD 4bitblock_LAST_0/1bitblock$7_0/m2_6151_79# -0
C778 4bitblock_LAST_0/MUX21$4_0/m2_540_79# BP3 0.09768f
C779 4bitblock$1_0/1bitblock$4_0/a_3498_3# 4bitblock$1_0/1bitblock$4_0/a_5042_407# -0.00373f
C780 S1 4bitblock$1_0/1bitblock$4_0/m2_9431_79# 0.00411f
C781 S0 4bitblock_LAST_0/1bitblock$3$4_0/a_7083_63# -0.00109f
C782 S0 4bitblock$1_0/m1_12486_242# 0.0402f
C783 4bitblock_0/m1_14167_n1145# VDD -0
C784 4bitblock$2_0/m2_10721_n3315# 4bitblock$2_0/m2_2396_n2595# -0.00332f
C785 4bitblock$2_0/m1_13543_n1146# 4bitblock$2_0/m1_12484_n953# -0.07155f
C786 VDD 4bitblock_LAST_0/1bitblock$7_0/a_3498_3# 0.0129f
C787 A3 B4 0
C788 4bitblock_0/1bitblock$1_0/a_8160_n37# S1 0
C789 VDD 4bitblock_LAST_0/1bitblock$7_0/a_2419_63# 0.00103f
C790 VDD 4bitblock_LAST_0/1bitblock$7_0/a_160_63# 0
C791 XOR$9_0/a_510_63# BP1 0
C792 AND4$4_0/a_518_229# m1_17438_n9725# 0
C793 S0 4bitblock_LAST_0/1bitblock$7_0/a_3940_63# 0.00296f
C794 m1_17790_n9717# 4bitblock_LAST_0/m2_1701_n784# 0
C795 S1 4bitblock$1_0/1bitblock$3$1_0/a_7768_n37# 0
C796 4bitblock$2_0/1bitblock$5_0/a_160_63# A7 0
C797 4bitblock$2_0/m1_13543_n1146# 4bitblock$2_0/1bitblock$2$2_0/a_11922_3# -0
C798 m1_18541_n9769# XOR$8_0/a_510_63# 0
C799 4bitblock$1_0/m1_14167_n1145# m1_16451_n989# -0
C800 BP0 Cin 0
C801 S0 4bitblock$1_0/1bitblock$2$1_0/a_5768_63# 0.00192f
C802 4bitblock$2_0/1bitblock$3$2_0/m2_6151_79# S0 0.00468f
C803 XOR$9_0/a_160_63# VDD 0.01181f
C804 4bitblock$2_0/1bitblock$3$2_0/a_7410_63# S1 0.00507f
C805 4bitblock$2_0/1bitblock$5_0/a_5768_63# S0 0.0065f
C806 m1_17790_n9717# VDD 0.48625f
C807 4bitblock_0/1bitblock$3_0/a_11922_3# VDD 0
C808 4bitblock$1_0/m1_12480_n3815# 4bitblock$1_0/m1_13543_n1146# -0
C809 BP2 4bitblock$2_0/1bitblock$1$2_0/a_11922_3# 0
C810 4bitblock_0/1bitblock$3_0/a_9050_63# VDD 0
C811 4bitblock$2_0/1bitblock$3$2_0/a_3498_3# S0 0.06346f
C812 4bitblock$2_0/1bitblock$3$2_0/a_705_407# A12 0
C813 S0 4bitblock$1_0/1bitblock$2$1_0/a_5243_407# 0.01502f
C814 S0 4bitblock$1_0/m2_1701_n784# 0.01514f
C815 4bitblock_LAST_0/1bitblock$7_0/a_9609_407# S1 0.009f
C816 AND4$4_0/a_518_229# BP1 0.13929f
C817 4bitblock_0/1bitblock_0/a_4290_63# VDD -0
C818 4bitblock$2_0/m1_13543_n1146# 4bitblock$2_0/m2_2396_n2595# -0.00238f
C819 AND4$4_0/a_1120_n441# AND4$4_0/a_518_229# 0
C820 4bitblock_0/MUX21_0/m2_540_79# VDD -0
C821 S0 4bitblock$2_0/1bitblock$5_0/a_5243_407# 0.0277f
C822 4bitblock$2_0/1bitblock$3$2_0/a_2419_63# S0 0.00346f
C823 m2_6320_n21444# 4bitblock_LAST_0/1bitblock$2$4_0/a_7410_63# 0
C824 VDD 4bitblock_LAST_0/1bitblock$7_0/a_5042_407# -0.00638f
C825 BP2 4bitblock$2_0/m2_1701_n784# 0.00245f
C826 VDD 4bitblock_LAST_0/1bitblock$7_0/a_11480_63# 0
C827 4bitblock$2_0/1bitblock$3$2_0/a_6721_407# S0 0.00785f
C828 4bitblock$2_0/m1_12480_n3815# 4bitblock$2_0/MUX21$2_0/a_157_63# -0
C829 XOR$9_0/a_1262_n37# m1_17790_n9717# 0.00107f
C830 VDD 4bitblock$1_0/m1_12486_242# 0
C831 B3 4bitblock$1_0/1bitblock$4_0/a_705_407# 0
C832 S0 4bitblock$1_0/m1_12484_n953# 0.0407f
C833 BP2 m2_16192_n18174# 0.14646f
C834 BP0 4bitblock_0/1bitblock$1_0/a_11922_3# 0
C835 4bitblock_0/1bitblock_0/a_4290_63# 4bitblock_0/1bitblock_0/m2_6151_79# -0
C836 B8 4bitblock$1_0/1bitblock$3$1_0/a_510_63# 0
C837 4bitblock$2_0/1bitblock$5_0/a_705_407# 4bitblock$1_0/1bitblock$3$1_0/a_705_407# 0.03896f
C838 4bitblock$2_0/1bitblock$5_0/a_510_63# B7 0
C839 4bitblock_0/1bitblock$3_0/a_160_63# A4 0
C840 4bitblock_LAST_0/m1_13543_n1146# VDD -0
C841 4bitblock$2_0/1bitblock$3$2_0/a_705_407# VDD 0.00599f
C842 S0 m1_16199_n12176# 0.04156f
C843 4bitblock$2_0/1bitblock$2$2_0/m2_7791_79# S1 0.02043f
C844 4bitblock$2_0/1bitblock$3$2_0/a_160_63# A12 0
C845 AND4$4_0/a_912_n441# BP1 0.00649f
C846 4bitblock_0/1bitblock$3_0/m2_7791_79# S1 0.02171f
C847 4bitblock_LAST_0/MUX21$4_0/a_909_n37# BP3 0.00431f
C848 4bitblock_0/1bitblock$3_0/a_705_407# 4bitblock$1_0/m1_14167_n1145# 0
C849 VDD 4bitblock_LAST_0/1bitblock$7_0/a_3940_63# 0
C850 4bitblock$2_0/1bitblock$5_0/a_9609_407# S1 0.00905f
C851 4bitblock_0/1bitblock_0/a_5042_407# 4bitblock_0/1bitblock_0/a_3498_3# -0.00373f
C852 VDD A4 0.00911f
C853 BP0 4bitblock_0/m2_1701_n784# 0.00923f
C854 4bitblock$2_0/1bitblock$3$2_0/a_5042_407# S0 0.06283f
C855 4bitblock_0/1bitblock$2_0/a_9609_407# S1 0
C856 B4 4bitblock_0/1bitblock$3_0/a_705_407# 0
C857 BP2 4bitblock$2_0/1bitblock$1$2_0/a_10906_466# 0
C858 4bitblock$2_0/1bitblock$1$2_0/a_7768_n37# S1 0
C859 4bitblock$2_0/1bitblock$5_0/a_5768_63# VDD -0
C860 4bitblock_LAST_0/1bitblock$3$4_0/a_9408_n37# m2_6320_n21444# 0
C861 4bitblock_0/m1_13543_n1146# 4bitblock$1_0/m1_12486_242# 0
C862 4bitblock$2_0/1bitblock$3$2_0/a_3498_3# VDD 0.01473f
C863 S0 4bitblock$2_0/1bitblock$5_0/a_7083_63# 0
C864 4bitblock_0/1bitblock$3_0/a_1845_466# 4bitblock$1_0/1bitblock$4_0/a_1845_466# 0
C865 4bitblock_0/1bitblock$3_0/a_1845_466# 4bitblock$1_0/m1_14167_n1145# 0
C866 4bitblock$2_0/1bitblock$2$2_0/a_9609_407# S1 0
C867 A8 B7 0
C868 4bitblock_0/m2_10721_n3315# S1 0.04181f
C869 S0 4bitblock$1_0/m2_2396_n2595# 0.04514f
C870 4bitblock_0/AND4_0/a_518_229# 4bitblock_0/m1_12484_n953# -0.00634f
C871 4bitblock$2_0/1bitblock$3$2_0/a_2419_63# VDD 0.00106f
C872 BP2 m2_6320_n21444# 0.0724f
C873 4bitblock$2_0/1bitblock$5_0/a_160_63# 4bitblock$1_0/1bitblock$3$1_0/a_705_407# 0
C874 4bitblock$2_0/1bitblock$5_0/a_705_407# 4bitblock$1_0/1bitblock$3$1_0/a_160_63# 0
C875 4bitblock$2_0/1bitblock$3$2_0/a_160_63# VDD 0
C876 S0 4bitblock$2_0/m1_14167_n1145# 0.07119f
C877 4bitblock$2_0/1bitblock$3$2_0/a_3940_63# S0 0.00494f
C878 4bitblock$2_0/m1_12484_n953# S1 0.04253f
C879 4bitblock_0/1bitblock$3_0/a_2861_3# 4bitblock$1_0/1bitblock$4_0/a_2419_63# 0
C880 4bitblock_0/1bitblock$2_0/a_7083_63# S1 0.04829f
C881 S1 4bitblock$1_0/1bitblock$3$1_0/a_8160_n37# 0
C882 4bitblock$1_0/1bitblock$4_0/a_4290_63# 4bitblock$1_0/1bitblock$4_0/a_5768_63# -0
C883 4bitblock_0/m1_13543_n1146# A4 0
C884 S0 4bitblock$1_0/1bitblock$1$1_0/a_4650_n37# 0
C885 m1_17438_n9725# BP1 0
C886 BP0 4bitblock_0/1bitblock$1_0/a_10906_466# 0
C887 BP0 VDD 0.74363f
C888 4bitblock$2_0/1bitblock$5_0/a_3498_3# 4bitblock$1_0/1bitblock$3$1_0/a_3498_3# 0.00641f
C889 m1_17790_n9717# XOR$8_0/a_705_407# 0.16337f
C890 4bitblock_LAST_0/1bitblock$3$4_0/a_5768_63# 4bitblock_LAST_0/1bitblock$3$4_0/m2_6151_79# -0
C891 4bitblock$2_0/1bitblock$2$2_0/a_8361_407# S1 0.00856f
C892 4bitblock_0/1bitblock_0/a_5768_63# 4bitblock_0/1bitblock_0/a_3940_63# -0
C893 m1_16199_n12176# VDD 0.38302f
C894 4bitblock$1_0/MUX21$1_0/a_517_n37# 4bitblock$1_0/m1_14167_n1145# -0
C895 4bitblock$2_0/1bitblock$2$2_0/a_7083_63# S1 0.0493f
C896 4bitblock$2_0/1bitblock$5_0/a_2419_63# 4bitblock$1_0/1bitblock$3$1_0/a_2419_63# 0.0017f
C897 4bitblock$2_0/1bitblock$5_0/a_160_63# 4bitblock$1_0/1bitblock$3$1_0/a_160_63# 0
C898 AND4$4_0/a_1120_n441# BP1 0.01199f
C899 BP0 4bitblock$2_0/MUX21$2_0/m2_540_79# 0.02131f
C900 4bitblock$2_0/1bitblock$3$2_0/a_5042_407# VDD 0
C901 4bitblock$2_0/1bitblock$3$2_0/a_11480_63# VDD 0
C902 4bitblock$1_0/1bitblock$4_0/a_510_63# B3 0
C903 4bitblock_0/1bitblock$2_0/a_7410_63# S1 0.0033f
C904 4bitblock$2_0/m2_2396_n2595# S1 0.06337f
C905 XOR$9_0/a_160_63# m1_18541_n9769# 0
C906 4bitblock$2_0/MUX21$2_0/m2_540_79# m1_16199_n12176# 0.00146f
C907 4bitblock$2_0/1bitblock$5_0/a_11922_3# VDD 0
C908 BP0 4bitblock_0/m1_13543_n1146# 0.14941f
C909 4bitblock$2_0/1bitblock$5_0/a_9050_63# S1 0.0038f
C910 m1_18541_n9769# m1_17790_n9717# 0.07437f
C911 4bitblock_0/1bitblock$3_0/a_4650_n37# S0 0
C912 4bitblock$2_0/m2_10721_n3315# BP2 0.0239f
C913 4bitblock$2_0/1bitblock$5_0/a_7083_63# VDD 0
C914 S0 4bitblock$1_0/1bitblock$4_0/a_5768_63# 0.00807f
C915 4bitblock_LAST_0/1bitblock$7_0/a_5768_63# 4bitblock_LAST_0/1bitblock$7_0/a_5042_407# -0
C916 Cin m1_16451_n989# 0
C917 VDD 4bitblock$1_0/m2_2396_n2595# -0.00316f
C918 4bitblock$2_0/1bitblock$3$2_0/a_510_63# 4bitblock_LAST_0/1bitblock$7_0/a_510_63# 0
C919 XOR$9_0/a_870_n37# m1_17790_n9717# 0
C920 XOR$9_0/a_705_407# m1_17438_n9725# 0
C921 4bitblock_LAST_0/1bitblock$3$4_0/m2_6151_79# m1_17790_n9717# -0.03321f
C922 4bitblock$2_0/1bitblock$2$2_0/a_8723_63# S1 0.04411f
C923 BP2 BP3 0.11058f
C924 S0 4bitblock$1_0/1bitblock$1$1_0/a_4290_63# 0.00441f
C925 4bitblock_0/1bitblock$1_0/a_3498_3# S1 0.0033f
C926 4bitblock$2_0/1bitblock$5_0/a_1845_466# VDD 0
C927 4bitblock$2_0/m1_14167_n1145# VDD 0.0861f
C928 4bitblock$2_0/1bitblock$3$2_0/a_3940_63# VDD 0
C929 S0 4bitblock$1_0/1bitblock$4_0/a_5243_407# 0.02819f
C930 XOR$9_0/a_160_63# Z 0
C931 F VDD 0.25413f
C932 S0 4bitblock$1_0/1bitblock$2$1_0/a_4650_n37# 0
C933 m1_17790_n9717# m2_16192_n18174# 0
C934 4bitblock_LAST_0/1bitblock$3$4_0/a_5768_63# m2_6320_n21444# 0.02027f
C935 Z m1_17790_n9717# 0.00561f
C936 4bitblock_0/1bitblock$3_0/a_2419_63# 4bitblock$1_0/m1_14167_n1145# 0
C937 4bitblock_0/1bitblock_0/a_3498_3# S1 0
C938 m1_17438_n9725# 4bitblock_LAST_0/MUX21$4_0/m2_540_79# 0
C939 B11 B12 0.00216f
C940 4bitblock$2_0/m1_12480_n3815# VDD 0.00601f
C941 m2_6320_n21444# 4bitblock_LAST_0/1bitblock$3$4_0/m2_7791_79# 0.03179f
C942 S0 4bitblock$2_0/1bitblock$5_0/a_4650_n37# 0
C943 4bitblock$2_0/1bitblock$1$2_0/a_8160_n37# S1 0
C944 4bitblock_0/1bitblock_0/a_5768_63# S0 0.00213f
C945 4bitblock_LAST_0/1bitblock$3$4_0/a_9800_n37# m2_6320_n21444# 0.00153f
C946 4bitblock$2_0/1bitblock$5_0/a_8723_63# VDD 0
C947 4bitblock_LAST_0/1bitblock$7_0/a_5768_63# 4bitblock_LAST_0/1bitblock$7_0/a_3940_63# -0
C948 4bitblock_0/1bitblock$2_0/a_8160_n37# S1 0
C949 VDD B7 0.00238f
C950 4bitblock_LAST_0/1bitblock$7_0/a_3498_3# 4bitblock_LAST_0/m1_14167_n1145# -0
C951 VDD 4bitblock$1_0/1bitblock$3$1_0/a_9050_63# 0
C952 VDD 4bitblock$1_0/MUX21$1_0/a_718_407# -0.00589f
C953 4bitblock_0/1bitblock$1_0/m2_9431_79# S1 0.00102f
C954 4bitblock_LAST_0/1bitblock$3$4_0/a_5243_407# m2_6320_n21444# 0
C955 m1_16199_n12176# 4bitblock$1_0/m1_13543_n1146# 0
C956 4bitblock$2_0/m1_14167_n1145# 4bitblock$1_0/m2_10721_n3315# 0
C957 VDD 4bitblock$1_0/MUX21$1_0/a_157_63# 0
C958 4bitblock_0/1bitblock$1_0/a_4290_63# S0 0.00449f
C959 4bitblock$2_0/m1_13543_n1146# BP2 0.15727f
C960 4bitblock_0/1bitblock$3_0/a_10906_466# 4bitblock$1_0/m1_14167_n1145# 0
C961 4bitblock_0/m1_12484_n953# S0 0.04129f
C962 S0 m1_16451_n989# 0.04158f
C963 4bitblock_0/m2_2396_n2595# S1 0.06197f
C964 4bitblock_LAST_0/1bitblock$7_0/a_2419_63# 4bitblock_LAST_0/m1_14167_n1145# 0
C965 4bitblock$2_0/1bitblock$5_0/a_11922_3# 4bitblock$1_0/1bitblock$3$1_0/a_11922_3# 0
C966 S1 4bitblock_LAST_0/1bitblock$1$4_0/a_2419_63# 0
C967 4bitblock_0/1bitblock$3_0/a_7083_63# S1 0.04884f
C968 4bitblock_0/1bitblock$3_0/a_510_63# 4bitblock$1_0/1bitblock$4_0/a_705_407# 0
C969 S0 4bitblock$1_0/1bitblock$1$1_0/a_5042_n37# 0
C970 4bitblock$2_0/1bitblock$5_0/a_10906_466# VDD 0
C971 m2_6320_n21444# 4bitblock_LAST_0/1bitblock$3$4_0/a_9609_407# 0.06203f
C972 XOR$9_0/a_160_63# m2_6320_n21444# 0.08149f
C973 4bitblock$2_0/1bitblock$5_0/a_11922_3# 4bitblock$1_0/m1_13543_n1146# 0
C974 4bitblock$2_0/m1_14167_n1145# 4bitblock$1_0/1bitblock$3$1_0/a_11922_3# 0
C975 4bitblock_0/m1_12484_n953# 4bitblock_0/m2_1701_n784# -0.00165f
C976 4bitblock_LAST_0/m1_13543_n1146# m2_16192_n18174# -0
C977 m1_17790_n9717# 4bitblock_LAST_0/m1_14167_n1145# 0
C978 VDD 4bitblock$1_0/1bitblock$4_0/a_5768_63# -0
C979 4bitblock$2_0/1bitblock$5_0/a_11480_63# 4bitblock$1_0/1bitblock$3$1_0/a_11480_63# 0
C980 m2_6320_n21444# m1_17790_n9717# 0.30681f
C981 4bitblock$2_0/m1_12480_n3815# 4bitblock$2_0/MUX21$2_0/a_718_407# -0
C982 S0 4bitblock$1_0/1bitblock$4_0/a_7083_63# 0
C983 AND4$4_0/a_704_n441# BP2 0.01084f
C984 A3 VDD 0.00918f
C985 N XOR$9_0/a_160_63# -0
C986 S0 4bitblock$1_0/1bitblock$2$1_0/a_4290_63# 0.00441f
C987 4bitblock$2_0/1bitblock$5_0/a_1845_466# 4bitblock$1_0/1bitblock$3$1_0/a_1845_466# 0
C988 4bitblock$2_0/m1_14167_n1145# 4bitblock$1_0/1bitblock$3$1_0/a_1845_466# 0
C989 4bitblock$2_0/1bitblock$5_0/a_1845_466# 4bitblock$1_0/m1_13543_n1146# 0
C990 4bitblock$2_0/m1_14167_n1145# 4bitblock$1_0/m1_13543_n1146# 2.61413f
C991 Y15 m2_6320_n21444# 0.00774f
C992 N m1_17790_n9717# 0.05001f
C993 A11 4bitblock_LAST_0/1bitblock$7_0/a_705_407# 0
C994 4bitblock$2_0/1bitblock$5_0/a_4290_63# S0 0.00965f
C995 XOR$9_0/a_510_63# XOR$8_0/a_510_63# 0
C996 S0 4bitblock$1_0/m1_14167_n1145# 0.07191f
C997 4bitblock_0/1bitblock$3_0/a_10906_466# 4bitblock$1_0/1bitblock$4_0/a_10906_466# 0
C998 4bitblock$2_0/1bitblock$3$2_0/a_7768_n37# S1 0
C999 m2_6320_n21444# 4bitblock_LAST_0/1bitblock$3$4_0/a_8361_407# 0.06892f
C1000 4bitblock_0/1bitblock$3_0/a_510_63# 4bitblock$1_0/1bitblock$4_0/a_160_63# 0
C1001 4bitblock_LAST_0/1bitblock$3$4_0/a_11922_3# m2_6320_n21444# 0.01748f
C1002 BP0 m1_18541_n9769# 0.00428f
C1003 4bitblock_0/1bitblock_0/a_5768_63# VDD -0
C1004 m2_6320_n21444# 4bitblock_LAST_0/1bitblock$3$4_0/a_7083_63# 0.06357f
C1005 BP0 XOR$9_0/a_870_n37# 0
C1006 4bitblock_0/1bitblock$3_0/a_8361_407# S1 0.0162f
C1007 m1_18541_n9769# m1_16199_n12176# 0
C1008 m2_6320_n21444# 4bitblock_LAST_0/1bitblock$2$4_0/a_7768_n37# 0
C1009 4bitblock$2_0/1bitblock$3$2_0/a_705_407# 4bitblock_LAST_0/m1_14167_n1145# 0
C1010 4bitblock$2_0/m1_13543_n1146# 4bitblock_LAST_0/1bitblock$7_0/a_705_407# 0.00102f
C1011 4bitblock_0/m1_12484_n953# VDD -0.02411f
C1012 VDD m1_16451_n989# 0.07721f
C1013 4bitblock_LAST_0/m1_13543_n1146# m2_6320_n21444# 0.32518f
C1014 4bitblock_LAST_0/m1_12480_n3815# m1_17790_n9717# 0.13491f
C1015 4bitblock$2_0/1bitblock$5_0/a_2861_3# VDD 0
C1016 4bitblock_0/1bitblock$3_0/a_7768_n37# S1 0
C1017 4bitblock_0/1bitblock$1_0/a_7410_63# S1 0.0033f
C1018 4bitblock$2_0/m2_2396_n2595# 4bitblock$2_0/m1_12484_n953# -0.00927f
C1019 4bitblock_0/1bitblock_0/a_2419_63# S0 0.00271f
C1020 BP0 m2_16192_n18174# 0.07743f
C1021 4bitblock_LAST_0/1bitblock$3$4_0/a_11922_391# m2_6320_n21444# 0.00603f
C1022 S1 4bitblock$1_0/1bitblock$3$1_0/a_3498_3# 0.00549f
C1023 A11 4bitblock_LAST_0/1bitblock$7_0/a_160_63# 0
C1024 S0 4bitblock$1_0/1bitblock$2$1_0/a_5042_n37# 0
C1025 F XOR$8_0/a_705_407# 0.01248f
C1026 4bitblock$2_0/1bitblock$5_0/a_10906_466# 4bitblock$1_0/m1_13543_n1146# 0
C1027 4bitblock$2_0/m1_14167_n1145# 4bitblock$1_0/1bitblock$3$1_0/a_10906_466# 0
C1028 m2_6320_n21444# 4bitblock_LAST_0/1bitblock$3$4_0/a_8723_63# 0.01484f
C1029 4bitblock$2_0/1bitblock$3$2_0/a_11922_3# 4bitblock_LAST_0/1bitblock$7_0/a_2419_63# 0
C1030 S0 4bitblock$2_0/1bitblock$5_0/a_5042_n37# 0
C1031 m1_16199_n12176# m2_16192_n18174# 0
C1032 BP2 AND4$4_0/a_518_229# 0.0152f
C1033 S1 4bitblock$1_0/1bitblock$3$1_0/a_2419_63# 0.00277f
C1034 VDD 4bitblock$1_0/1bitblock$4_0/a_11922_3# 0
C1035 S1 4bitblock$1_0/1bitblock$4_0/a_9050_63# 0.00379f
C1036 m1_17790_n9717# BP3 0.02723f
C1037 4bitblock$2_0/1bitblock$3$2_0/a_3498_3# 4bitblock_LAST_0/m1_14167_n1145# 0.00115f
C1038 4bitblock$2_0/m1_13543_n1146# 4bitblock_LAST_0/1bitblock$7_0/a_3498_3# 0.00106f
C1039 VDD 4bitblock$1_0/1bitblock$4_0/a_7083_63# 0
C1040 4bitblock_0/m1_13543_n1146# m1_16451_n989# 0
C1041 4bitblock_0/m1_13543_n1146# 4bitblock_0/m1_12484_n953# -0.06492f
C1042 4bitblock$2_0/m1_13543_n1146# 4bitblock_LAST_0/1bitblock$7_0/a_2419_63# 0
C1043 4bitblock$2_0/1bitblock$2$2_0/m2_6151_79# S0 0.00108f
C1044 4bitblock$2_0/1bitblock$3$2_0/a_2419_63# 4bitblock_LAST_0/m1_14167_n1145# 0
C1045 4bitblock$2_0/1bitblock$2$2_0/a_7410_63# S1 0.00336f
C1046 4bitblock$2_0/m1_13543_n1146# 4bitblock_LAST_0/1bitblock$7_0/a_160_63# 0
C1047 4bitblock$1_0/1bitblock$4_0/a_510_63# 4bitblock_0/1bitblock$3_0/a_510_63# 0
C1048 VDD 4bitblock$1_0/1bitblock$4_0/a_1845_466# 0
C1049 4bitblock_0/1bitblock$3_0/a_5768_63# S0 0.00633f
C1050 4bitblock$2_0/1bitblock$5_0/a_4290_63# VDD -0
C1051 VDD 4bitblock$1_0/m1_14167_n1145# 0.08326f
C1052 S1 4bitblock$1_0/1bitblock$3$1_0/m2_9431_79# 0.00415f
C1053 B4 4bitblock_0/1bitblock$3_0/a_160_63# 0
C1054 4bitblock_0/1bitblock$2_0/a_3498_3# S0 0.04902f
C1055 4bitblock_LAST_0/1bitblock$3$4_0/a_10906_466# m2_6320_n21444# 0.01633f
C1056 4bitblock_LAST_0/m1_12480_n3815# 4bitblock_LAST_0/m1_13543_n1146# -0
C1057 4bitblock$2_0/1bitblock$2$2_0/a_3498_3# S0 0.04813f
C1058 F m1_18541_n9769# 0.08423f
C1059 4bitblock_0/m2_2396_n2595# 4bitblock_0/m2_10721_n3315# -0.00332f
C1060 4bitblock_LAST_0/1bitblock$7_0/a_4290_63# 4bitblock_LAST_0/1bitblock$7_0/m2_6151_79# -0
C1061 BP0 m2_6320_n21444# 0.09339f
C1062 4bitblock_0/1bitblock$3_0/a_705_407# VDD 0.00599f
C1063 VDD B12 0.0024f
C1064 4bitblock$2_0/1bitblock$2$2_0/a_2419_63# S0 0.00267f
C1065 B4 VDD 0.0024f
C1066 BP2 AND4$4_0/a_912_n441# 0
C1067 S0 4bitblock$1_0/1bitblock$4_0/a_4650_n37# 0
C1068 4bitblock$2_0/1bitblock$5_0/a_7410_63# VDD 0
C1069 4bitblock$2_0/1bitblock$5_0/a_10906_466# 4bitblock$1_0/1bitblock$3$1_0/a_10906_466# 0
C1070 4bitblock_0/m1_13543_n1146# 4bitblock$1_0/1bitblock$4_0/a_11922_3# 0
C1071 VDD 4bitblock_LAST_0/1bitblock$7_0/a_9050_63# 0
C1072 VDD 4bitblock$1_0/1bitblock$4_0/a_8723_63# 0
C1073 4bitblock_0/1bitblock$2_0/a_8361_407# S1 0.00836f
C1074 m1_16199_n12176# m2_6320_n21444# 0
C1075 B8 A7 0
C1076 4bitblock_0/1bitblock$3_0/a_8160_n37# S1 0
C1077 N BP0 0
C1078 4bitblock_0/1bitblock_0/a_4290_63# 4bitblock_0/1bitblock_0/a_5042_407# 0
C1079 4bitblock$2_0/1bitblock$5_0/a_2861_3# 4bitblock$1_0/m1_13543_n1146# 0
C1080 4bitblock$2_0/m1_14167_n1145# 4bitblock$1_0/1bitblock$3$1_0/a_2861_3# 0
C1081 BP1 4bitblock$1_0/MUX21$1_0/m2_540_79# 0.04147f
C1082 4bitblock_0/1bitblock$3_0/a_3498_3# 4bitblock$1_0/1bitblock$4_0/a_3498_3# 0.00641f
C1083 4bitblock_0/m1_13543_n1146# 4bitblock$1_0/1bitblock$4_0/a_1845_466# 0
C1084 4bitblock_0/m1_13543_n1146# 4bitblock$1_0/m1_14167_n1145# 2.61413f
C1085 4bitblock$2_0/1bitblock$3$2_0/a_8160_n37# S1 0
C1086 4bitblock$2_0/m1_12480_n3815# m2_16192_n18174# 0.01143f
C1087 XOR$8_0/a_1262_n37# m1_17438_n9725# 0
C1088 4bitblock_0/1bitblock_0/a_8361_407# S1 0
C1089 A10.t4 GND -0.0491f
C1090 A10.t3 GND -0.02512f
C1091 A10.n0 GND -0.16082f
C1092 A10.t2 GND -0.02836f
C1093 A10.t5 GND -0.05056f
C1094 A10.t0 GND -0.20718f
C1095 A10.t1 GND -0.18263f
C1096 A10.n1 GND -0.0621f
C1097 A10.n2 GND -0.22522f
C1098 S0.t20 GND -0.01262f
C1099 S0.t17 GND -0.00199f
C1100 S0.t23 GND 0.04936f
C1101 S0.t22 GND 0.03531f
C1102 S0.n0 GND 0.07095f
C1103 S0.n1 GND 0.13572f
C1104 S0.t9 GND -0.00199f
C1105 S0.t12 GND -0.01262f
C1106 S0.t14 GND 0.03531f
C1107 S0.t15 GND 0.04936f
C1108 S0.n2 GND 0.07095f
C1109 S0.n3 GND 0.13572f
C1110 S0.t8 GND -0.00199f
C1111 S0.t10 GND -0.01262f
C1112 S0.t11 GND 0.02582f
C1113 S0.t13 GND 0.04936f
C1114 S0.n4 GND 0.07107f
C1115 S0.n5 GND 0.0886f
C1116 S0.n6 GND 0.76315f
C1117 S0.t4 GND -0.01262f
C1118 S0.t1 GND -0.00199f
C1119 S0.t7 GND 0.04936f
C1120 S0.t6 GND 0.03531f
C1121 S0.n7 GND 0.07095f
C1122 S0.n8 GND 0.13572f
C1123 S0.t2 GND -0.01262f
C1124 S0.t0 GND -0.00199f
C1125 S0.t5 GND 0.04936f
C1126 S0.t3 GND 0.02582f
C1127 S0.n9 GND 0.07107f
C1128 S0.n10 GND 0.0886f
C1129 S0.n11 GND 0.70845f
C1130 S0.n12 GND 0.40656f
C1131 S0.t25 GND -0.00199f
C1132 S0.t28 GND -0.01262f
C1133 S0.t30 GND 0.03531f
C1134 S0.t31 GND 0.04936f
C1135 S0.n13 GND 0.07095f
C1136 S0.n14 GND 0.13572f
C1137 S0.t24 GND -0.00199f
C1138 S0.t26 GND -0.01262f
C1139 S0.t27 GND 0.02582f
C1140 S0.t29 GND 0.04936f
C1141 S0.n15 GND 0.07107f
C1142 S0.n16 GND 0.0886f
C1143 S0.n17 GND 0.70845f
C1144 S0.n18 GND 0.40345f
C1145 S0.n19 GND 0.73866f
C1146 S0.t18 GND -0.01262f
C1147 S0.t16 GND -0.00199f
C1148 S0.t21 GND 0.04936f
C1149 S0.t19 GND 0.02582f
C1150 S0.n20 GND 0.07107f
C1151 S0.n21 GND 0.08127f
C1152 S0.n22 GND 0.02016f
C1153 S0.t84 GND -0.01262f
C1154 S0.t81 GND -0.00199f
C1155 S0.t87 GND 0.04936f
C1156 S0.t86 GND 0.03531f
C1157 S0.n23 GND 0.07095f
C1158 S0.n24 GND 0.13572f
C1159 S0.t65 GND -0.00199f
C1160 S0.t68 GND -0.01262f
C1161 S0.t70 GND 0.03531f
C1162 S0.t71 GND 0.04936f
C1163 S0.n25 GND 0.07095f
C1164 S0.n26 GND 0.13572f
C1165 S0.t64 GND -0.00199f
C1166 S0.t66 GND -0.01262f
C1167 S0.t67 GND 0.02582f
C1168 S0.t69 GND 0.04936f
C1169 S0.n27 GND 0.07107f
C1170 S0.n28 GND 0.0886f
C1171 S0.n29 GND 0.76315f
C1172 S0.t76 GND -0.01262f
C1173 S0.t73 GND -0.00199f
C1174 S0.t79 GND 0.04936f
C1175 S0.t78 GND 0.03531f
C1176 S0.n30 GND 0.07095f
C1177 S0.n31 GND 0.13572f
C1178 S0.t74 GND -0.01262f
C1179 S0.t72 GND -0.00199f
C1180 S0.t77 GND 0.04936f
C1181 S0.t75 GND 0.02582f
C1182 S0.n32 GND 0.07107f
C1183 S0.n33 GND 0.0886f
C1184 S0.n34 GND 0.70845f
C1185 S0.n35 GND 0.40656f
C1186 S0.t89 GND -0.00199f
C1187 S0.t92 GND -0.01262f
C1188 S0.t94 GND 0.03531f
C1189 S0.t95 GND 0.04936f
C1190 S0.n36 GND 0.07095f
C1191 S0.n37 GND 0.13572f
C1192 S0.t88 GND -0.00199f
C1193 S0.t90 GND -0.01262f
C1194 S0.t91 GND 0.02582f
C1195 S0.t93 GND 0.04936f
C1196 S0.n38 GND 0.07107f
C1197 S0.n39 GND 0.0886f
C1198 S0.n40 GND 0.70845f
C1199 S0.n41 GND 0.40345f
C1200 S0.n42 GND 0.73866f
C1201 S0.t82 GND -0.01262f
C1202 S0.t80 GND -0.00199f
C1203 S0.t85 GND 0.04936f
C1204 S0.t83 GND 0.02582f
C1205 S0.n43 GND 0.07107f
C1206 S0.n44 GND 0.08127f
C1207 S0.n45 GND 0.43763f
C1208 S0.t52 GND -0.01262f
C1209 S0.t49 GND -0.00199f
C1210 S0.t55 GND 0.04936f
C1211 S0.t54 GND 0.03531f
C1212 S0.n46 GND 0.07095f
C1213 S0.n47 GND 0.13572f
C1214 S0.t33 GND -0.00199f
C1215 S0.t36 GND -0.01262f
C1216 S0.t38 GND 0.03531f
C1217 S0.t39 GND 0.04936f
C1218 S0.n48 GND 0.07095f
C1219 S0.n49 GND 0.13572f
C1220 S0.t32 GND -0.00199f
C1221 S0.t34 GND -0.01262f
C1222 S0.t35 GND 0.02582f
C1223 S0.t37 GND 0.04936f
C1224 S0.n50 GND 0.07107f
C1225 S0.n51 GND 0.0886f
C1226 S0.n52 GND 0.76315f
C1227 S0.t44 GND -0.01262f
C1228 S0.t41 GND -0.00199f
C1229 S0.t47 GND 0.04936f
C1230 S0.t46 GND 0.03531f
C1231 S0.n53 GND 0.07095f
C1232 S0.n54 GND 0.13572f
C1233 S0.t42 GND -0.01262f
C1234 S0.t40 GND -0.00199f
C1235 S0.t45 GND 0.04936f
C1236 S0.t43 GND 0.02582f
C1237 S0.n55 GND 0.07107f
C1238 S0.n56 GND 0.0886f
C1239 S0.n57 GND 0.70845f
C1240 S0.n58 GND 0.40656f
C1241 S0.t57 GND -0.00199f
C1242 S0.t60 GND -0.01262f
C1243 S0.t62 GND 0.03531f
C1244 S0.t63 GND 0.04936f
C1245 S0.n59 GND 0.07095f
C1246 S0.n60 GND 0.13572f
C1247 S0.t56 GND -0.00199f
C1248 S0.t58 GND -0.01262f
C1249 S0.t59 GND 0.02582f
C1250 S0.t61 GND 0.04936f
C1251 S0.n61 GND 0.07107f
C1252 S0.n62 GND 0.0886f
C1253 S0.n63 GND 0.70845f
C1254 S0.n64 GND 0.40345f
C1255 S0.n65 GND 0.73866f
C1256 S0.t50 GND -0.01262f
C1257 S0.t48 GND -0.00199f
C1258 S0.t53 GND 0.04936f
C1259 S0.t51 GND 0.02582f
C1260 S0.n66 GND 0.07107f
C1261 S0.n67 GND 0.08127f
C1262 S0.n68 GND 0.09124f
C1263 S0.n69 GND 2.11251f
C1264 S0.t108 GND -0.01262f
C1265 S0.t105 GND -0.00199f
C1266 S0.t111 GND 0.04936f
C1267 S0.t110 GND 0.03531f
C1268 S0.n70 GND 0.07095f
C1269 S0.n71 GND 0.13572f
C1270 S0.t121 GND -0.00199f
C1271 S0.t124 GND -0.01262f
C1272 S0.t126 GND 0.03531f
C1273 S0.t127 GND 0.04936f
C1274 S0.n72 GND 0.07095f
C1275 S0.n73 GND 0.13572f
C1276 S0.t120 GND -0.00199f
C1277 S0.t122 GND -0.01262f
C1278 S0.t123 GND 0.02582f
C1279 S0.t125 GND 0.04936f
C1280 S0.n74 GND 0.07107f
C1281 S0.n75 GND 0.0886f
C1282 S0.n76 GND 0.76315f
C1283 S0.t100 GND -0.01262f
C1284 S0.t97 GND -0.00199f
C1285 S0.t103 GND 0.04936f
C1286 S0.t102 GND 0.03531f
C1287 S0.n77 GND 0.07095f
C1288 S0.n78 GND 0.13572f
C1289 S0.t98 GND -0.01262f
C1290 S0.t96 GND -0.00199f
C1291 S0.t101 GND 0.04936f
C1292 S0.t99 GND 0.02582f
C1293 S0.n79 GND 0.07107f
C1294 S0.n80 GND 0.0886f
C1295 S0.n81 GND 0.70845f
C1296 S0.n82 GND 0.40656f
C1297 S0.t113 GND -0.00199f
C1298 S0.t116 GND -0.01262f
C1299 S0.t118 GND 0.03531f
C1300 S0.t119 GND 0.04936f
C1301 S0.n83 GND 0.07095f
C1302 S0.n84 GND 0.13572f
C1303 S0.t112 GND -0.00199f
C1304 S0.t114 GND -0.01262f
C1305 S0.t115 GND 0.02582f
C1306 S0.t117 GND 0.04936f
C1307 S0.n85 GND 0.07107f
C1308 S0.n86 GND 0.0886f
C1309 S0.n87 GND 0.70845f
C1310 S0.n88 GND 0.40345f
C1311 S0.n89 GND 0.73866f
C1312 S0.t106 GND -0.01262f
C1313 S0.t104 GND -0.00199f
C1314 S0.t109 GND 0.04936f
C1315 S0.t107 GND 0.02582f
C1316 S0.n90 GND 0.07107f
C1317 S0.n91 GND 0.08127f
C1318 S0.n92 GND 0.09503f
C1319 S0.n93 GND 2.17609f
C1320 S1.t5 GND 0.02507f
C1321 S1.t7 GND 0.03504f
C1322 S1.n0 GND 0.04975f
C1323 S1.t4 GND 0.00162f
C1324 S1.n1 GND 0.03216f
C1325 S1.t6 GND 0.01692f
C1326 S1.n2 GND 0.04856f
C1327 S1.t2 GND 0.01631f
C1328 S1.t3 GND 0.03504f
C1329 S1.t1 GND 0.02507f
C1330 S1.n3 GND 0.04975f
C1331 S1.t0 GND 0.00162f
C1332 S1.n4 GND 0.03276f
C1333 S1.n5 GND 0.03441f
C1334 S1.n6 GND 0.35123f
C1335 S1.t13 GND 0.02507f
C1336 S1.t15 GND 0.03504f
C1337 S1.n7 GND 0.04975f
C1338 S1.t12 GND 0.00162f
C1339 S1.n8 GND 0.03297f
C1340 S1.t14 GND 0.01611f
C1341 S1.n9 GND 0.03441f
C1342 S1.n10 GND 0.22892f
C1343 S1.t61 GND 0.02507f
C1344 S1.t63 GND 0.03504f
C1345 S1.n11 GND 0.04975f
C1346 S1.t60 GND 0.00162f
C1347 S1.n12 GND 0.03216f
C1348 S1.t62 GND 0.01692f
C1349 S1.n13 GND 0.04856f
C1350 S1.t50 GND 0.01631f
C1351 S1.t51 GND 0.03504f
C1352 S1.t49 GND 0.02507f
C1353 S1.n14 GND 0.04975f
C1354 S1.t48 GND 0.00162f
C1355 S1.n15 GND 0.03276f
C1356 S1.n16 GND 0.03441f
C1357 S1.n17 GND 0.35123f
C1358 S1.t57 GND 0.02507f
C1359 S1.t59 GND 0.03504f
C1360 S1.n18 GND 0.04975f
C1361 S1.t56 GND 0.00162f
C1362 S1.n19 GND 0.03297f
C1363 S1.t58 GND 0.01611f
C1364 S1.n20 GND 0.03441f
C1365 S1.n21 GND 0.22892f
C1366 S1.t54 GND 0.01698f
C1367 S1.t55 GND 0.03504f
C1368 S1.t53 GND 0.02507f
C1369 S1.n22 GND 0.04975f
C1370 S1.t52 GND 0.00162f
C1371 S1.n23 GND 0.03209f
C1372 S1.n24 GND 0.03449f
C1373 S1.n25 GND 0.14196f
C1374 S1.t17 GND 0.02507f
C1375 S1.t19 GND 0.03504f
C1376 S1.n26 GND 0.04975f
C1377 S1.t16 GND 0.00162f
C1378 S1.n27 GND 0.03216f
C1379 S1.t18 GND 0.01692f
C1380 S1.n28 GND 0.04856f
C1381 S1.t22 GND 0.01631f
C1382 S1.t23 GND 0.03504f
C1383 S1.t21 GND 0.02507f
C1384 S1.n29 GND 0.04975f
C1385 S1.t20 GND 0.00162f
C1386 S1.n30 GND 0.03276f
C1387 S1.n31 GND 0.03441f
C1388 S1.n32 GND 0.35123f
C1389 S1.t29 GND 0.02507f
C1390 S1.t31 GND 0.03504f
C1391 S1.n33 GND 0.04975f
C1392 S1.t28 GND 0.00162f
C1393 S1.n34 GND 0.03297f
C1394 S1.t30 GND 0.01611f
C1395 S1.n35 GND 0.03441f
C1396 S1.n36 GND 0.22892f
C1397 S1.t26 GND 0.01698f
C1398 S1.t27 GND 0.03504f
C1399 S1.t25 GND 0.02507f
C1400 S1.n37 GND 0.04975f
C1401 S1.t24 GND 0.00162f
C1402 S1.n38 GND 0.03209f
C1403 S1.n39 GND 0.03449f
C1404 S1.n40 GND 0.14196f
C1405 S1.t33 GND 0.02507f
C1406 S1.t35 GND 0.03504f
C1407 S1.n41 GND 0.04975f
C1408 S1.t32 GND 0.00162f
C1409 S1.n42 GND 0.03216f
C1410 S1.t34 GND 0.01692f
C1411 S1.n43 GND 0.04856f
C1412 S1.t38 GND 0.01631f
C1413 S1.t39 GND 0.03504f
C1414 S1.t37 GND 0.02507f
C1415 S1.n44 GND 0.04975f
C1416 S1.t36 GND 0.00162f
C1417 S1.n45 GND 0.03276f
C1418 S1.n46 GND 0.03441f
C1419 S1.n47 GND 0.35123f
C1420 S1.t45 GND 0.02507f
C1421 S1.t47 GND 0.03504f
C1422 S1.n48 GND 0.04975f
C1423 S1.t44 GND 0.00162f
C1424 S1.n49 GND 0.03297f
C1425 S1.t46 GND 0.01611f
C1426 S1.n50 GND 0.03441f
C1427 S1.n51 GND 0.22892f
C1428 S1.t42 GND 0.01698f
C1429 S1.t43 GND 0.03504f
C1430 S1.t41 GND 0.02507f
C1431 S1.n52 GND 0.04975f
C1432 S1.t40 GND 0.00162f
C1433 S1.n53 GND 0.03209f
C1434 S1.n54 GND 0.03449f
C1435 S1.n55 GND 0.76175f
C1436 S1.n56 GND 1.27059f
C1437 S1.n57 GND 1.24846f
C1438 S1.n58 GND 0.72478f
C1439 S1.t10 GND 0.01698f
C1440 S1.t11 GND 0.03504f
C1441 S1.t9 GND 0.02507f
C1442 S1.n59 GND 0.04975f
C1443 S1.t8 GND 0.00162f
C1444 S1.n60 GND 0.03209f
C1445 S1.n61 GND 0.02398f
C1446 S1.n62 GND 0.01744f
C1447 Cin.t7 GND 0.01651f
C1448 Cin.t0 GND 0.04534f
C1449 Cin.t1 GND 0.14238f
C1450 Cin.t2 GND 0.02073f
C1451 Cin.t4 GND 0.00888f
C1452 Cin.n0 GND 0.03897f
C1453 Cin.n1 GND 1.66827f
C1454 Cin.t3 GND 0.10641f
C1455 Cin.t6 GND 0.03136f
C1456 Cin.t5 GND 0.01783f
C1457 Cin.n2 GND 0.04122f
C1458 Cin.n3 GND 0.04605f
C1459 VDD.n0 GND 0.00952f
C1460 VDD.n1 GND 0.0286f
C1461 VDD.n2 GND 0.15829f
C1462 VDD.t4 GND 0.00934f
C1463 VDD.n3 GND 0
C1464 VDD.n4 GND 0.01214f
C1465 VDD.n5 GND 0.03245f
C1466 VDD.n6 GND 0.0116f
C1467 VDD.n7 GND 0.03448f
C1468 VDD.n8 GND 0.02821f
C1469 VDD.n9 GND 0.03592f
C1470 VDD.n10 GND 0.00952f
C1471 VDD.n11 GND 0.04239f
C1472 VDD.t9 GND 0.02495f
C1473 VDD.n12 GND 0.0424f
C1474 VDD.t16 GND 0.00837f
C1475 VDD.n13 GND 0.00807f
C1476 VDD.n14 GND 0.01777f
C1477 VDD.n15 GND 0.00766f
C1478 VDD.t21 GND 0.00837f
C1479 VDD.n16 GND 0.00807f
C1480 VDD.n17 GND 0.01777f
C1481 VDD.n18 GND 0.00766f
C1482 VDD.t19 GND 0.00837f
C1483 VDD.n19 GND 0.00807f
C1484 VDD.n20 GND 0.01777f
C1485 VDD.n21 GND 0.03165f
C1486 VDD.n22 GND 0.16024f
C1487 VDD.n23 GND 0.12448f
C1488 VDD.t0 GND 0.12565f
C1489 VDD.n24 GND 0.15477f
C1490 VDD.n25 GND 0.11217f
C1491 VDD.t10 GND 0.13503f
C1492 VDD.t2 GND 0.10963f
C1493 VDD.n26 GND 0.0766f
C1494 VDD.t15 GND 0.0766f
C1495 VDD.n27 GND 0.11002f
C1496 VDD.n28 GND 0.13464f
C1497 VDD.n29 GND 0.13386f
C1498 VDD.t13 GND 0.10924f
C1499 VDD.n30 GND 0.0766f
C1500 VDD.t20 GND 0.0766f
C1501 VDD.n31 GND 0.11002f
C1502 VDD.n32 GND 0.13464f
C1503 VDD.n33 GND 0.13386f
C1504 VDD.t22 GND 0.10924f
C1505 VDD.n34 GND 0.0766f
C1506 VDD.t18 GND 0.0766f
C1507 VDD.n35 GND 0.11002f
C1508 VDD.n36 GND 0.08559f
C1509 VDD.n37 GND 0.11098f
C1510 VDD.n38 GND 0.0598f
C1511 VDD.n39 GND 0.03644f
C1512 VDD.n40 GND 0.03711f
C1513 VDD.n41 GND 0.03607f
C1514 VDD.n42 GND 0.03711f
C1515 VDD.n43 GND 0.03739f
C1516 VDD.n44 GND 0.02745f
C1517 VDD.n45 GND 0.09372f
C1518 VDD.n46 GND 0.05393f
C1519 VDD.t14 GND 0.0766f
C1520 VDD.n47 GND 0.0766f
C1521 VDD.t8 GND 0.10963f
C1522 VDD.n48 GND 0.13875f
C1523 VDD.n49 GND 0.15477f
C1524 VDD.n50 GND 0.17158f
C1525 VDD.n51 GND 0.12448f
C1526 VDD.t1 GND 0.12565f
C1527 VDD.n52 GND 0.15477f
C1528 VDD.n53 GND 0.11217f
C1529 VDD.t5 GND 0.07484f
C1530 VDD.n54 GND 0.07387f
C1531 VDD.n55 GND 0.07074f
C1532 VDD.n56 GND 0.03928f
C1533 VDD.t17 GND 0.04065f
C1534 VDD.n57 GND 0.07426f
C1535 VDD.t3 GND 0.07719f
C1536 VDD.n58 GND 0.07543f
C1537 VDD.n59 GND 0.10748f
C1538 VDD.n60 GND 0.16024f
C1539 VDD.n61 GND 0.15977f
C1540 4bitblock$1_0/m2_10721_n3315# GND 3.11409f
C1541 4bitblock$1_0/1bitblock$3$1_0/a_7083_63# GND 0.85222f
C1542 4bitblock$1_0/1bitblock$3$1_0/a_8723_63# GND 0.40578f
C1543 4bitblock$1_0/1bitblock$3$1_0/m2_9431_79# GND 0.62597f
C1544 4bitblock$1_0/1bitblock$3$1_0/m2_7791_79# GND 0.61991f
C1545 4bitblock$1_0/1bitblock$3$1_0/a_9609_407# GND 0.11896f
C1546 4bitblock$1_0/1bitblock$3$1_0/a_8361_407# GND 0.05045f
C1547 4bitblock$1_0/1bitblock$3$1_0/m2_6151_79# GND 0.6012f
C1548 4bitblock$1_0/1bitblock$3$1_0/a_6721_407# GND 0.01523f
C1549 4bitblock$1_0/1bitblock$3$1_0/a_5042_407# GND 0.79698f
C1550 4bitblock$1_0/1bitblock$3$1_0/a_3940_63# GND 0.46771f
C1551 4bitblock$1_0/m1_13543_n1146# GND 3.94827f
C1552 4bitblock$1_0/1bitblock$3$1_0/a_160_63# GND 0.59114f
C1553 4bitblock$1_0/1bitblock$3$1_0/a_5243_407# GND 0.01459f
C1554 4bitblock$1_0/1bitblock$3$1_0/a_705_407# GND 0.13647f
C1555 4bitblock$1_0/1bitblock$3$1_0/a_3498_3# GND 1.27913f
C1556 4bitblock$1_0/1bitblock$3$1_0/a_10906_n37# GND 0.02232f
C1557 4bitblock$1_0/1bitblock$3$1_0/a_9800_n37# GND 0.01742f
C1558 4bitblock$1_0/1bitblock$3$1_0/a_9408_n37# GND 0.01326f
C1559 4bitblock$1_0/1bitblock$3$1_0/a_8160_n37# GND 0.01743f
C1560 4bitblock$1_0/1bitblock$3$1_0/a_7768_n37# GND 0.01327f
C1561 4bitblock$1_0/1bitblock$3$1_0/a_6520_n37# GND 0.01743f
C1562 4bitblock$1_0/1bitblock$3$1_0/a_6128_n37# GND 0.01327f
C1563 4bitblock$1_0/1bitblock$3$1_0/a_5042_n37# GND 0.01422f
C1564 4bitblock$1_0/1bitblock$3$1_0/a_4650_n37# GND 0.01569f
C1565 4bitblock$1_0/m1_12480_n3815# GND 2.25461f
C1566 4bitblock$1_0/1bitblock$3$1_0/a_11922_3# GND 0.64569f
C1567 4bitblock$1_0/1bitblock$3$1_0/a_11922_391# GND 0.00119f
C1568 4bitblock$1_0/1bitblock$3$1_0/a_10906_466# GND 0.59827f
C1569 4bitblock$1_0/1bitblock$3$1_0/a_11480_63# GND 0.42359f
C1570 Y7 GND 0.13924f
C1571 4bitblock$1_0/1bitblock$3$1_0/a_9050_63# GND 0.55145f
C1572 4bitblock$1_0/1bitblock$3$1_0/a_7410_63# GND 0.55612f
C1573 4bitblock$1_0/1bitblock$3$1_0/a_5768_63# GND 0.55881f
C1574 4bitblock$1_0/1bitblock$3$1_0/a_1845_n37# GND 0.01974f
C1575 4bitblock$1_0/1bitblock$3$1_0/a_1262_n37# GND 0.0127f
C1576 4bitblock$1_0/1bitblock$3$1_0/a_870_n37# GND 0.01517f
C1577 4bitblock$1_0/1bitblock$3$1_0/a_4290_63# GND 0.59067f
C1578 4bitblock$1_0/1bitblock$3$1_0/a_2861_3# GND 0.62907f
C1579 4bitblock$1_0/1bitblock$3$1_0/a_1845_466# GND 0.59854f
C1580 4bitblock$1_0/1bitblock$3$1_0/a_2419_63# GND 6.65822f
C1581 4bitblock$1_0/1bitblock$3$1_0/a_510_63# GND 0.58003f
C1582 B7 GND 1.37287f
C1583 A7 GND 1.91221f
C1584 4bitblock$1_0/m1_12486_242# GND 3.09263f
C1585 4bitblock$1_0/1bitblock$1$1_0/a_7083_63# GND 0.85222f
C1586 4bitblock$1_0/1bitblock$1$1_0/a_8723_63# GND 0.40722f
C1587 4bitblock$1_0/1bitblock$1$1_0/m2_9431_79# GND 0.62597f
C1588 4bitblock$1_0/1bitblock$1$1_0/m2_7791_79# GND 0.61991f
C1589 4bitblock$1_0/1bitblock$1$1_0/a_9609_407# GND 0.11896f
C1590 4bitblock$1_0/1bitblock$1$1_0/a_8361_407# GND 0.05045f
C1591 4bitblock$1_0/1bitblock$1$1_0/m2_6151_79# GND 0.6012f
C1592 4bitblock$1_0/1bitblock$1$1_0/a_6721_407# GND 0.01523f
C1593 4bitblock$1_0/1bitblock$1$1_0/a_5042_407# GND 0.79698f
C1594 4bitblock$1_0/1bitblock$1$1_0/a_3940_63# GND 0.46771f
C1595 4bitblock$1_0/m2_1701_n784# GND 3.90084f
C1596 4bitblock$1_0/1bitblock$1$1_0/a_160_63# GND 0.59114f
C1597 4bitblock$1_0/1bitblock$1$1_0/a_5243_407# GND 0.01459f
C1598 4bitblock$1_0/1bitblock$1$1_0/a_705_407# GND 0.13647f
C1599 4bitblock$1_0/1bitblock$1$1_0/a_3498_3# GND 1.27913f
C1600 4bitblock$1_0/1bitblock$1$1_0/a_10906_n37# GND 0.02232f
C1601 4bitblock$1_0/1bitblock$1$1_0/a_9800_n37# GND 0.01742f
C1602 4bitblock$1_0/1bitblock$1$1_0/a_9408_n37# GND 0.01326f
C1603 4bitblock$1_0/1bitblock$1$1_0/a_8160_n37# GND 0.01743f
C1604 4bitblock$1_0/1bitblock$1$1_0/a_7768_n37# GND 0.01327f
C1605 4bitblock$1_0/1bitblock$1$1_0/a_6520_n37# GND 0.01743f
C1606 4bitblock$1_0/1bitblock$1$1_0/a_6128_n37# GND 0.01327f
C1607 4bitblock$1_0/1bitblock$1$1_0/a_5042_n37# GND 0.01422f
C1608 4bitblock$1_0/1bitblock$1$1_0/a_4650_n37# GND 0.01569f
C1609 4bitblock$1_0/1bitblock$1$1_0/a_11922_3# GND 0.64569f
C1610 4bitblock$1_0/1bitblock$1$1_0/a_11922_391# GND 0.00119f
C1611 4bitblock$1_0/1bitblock$1$1_0/a_10906_466# GND 0.59827f
C1612 4bitblock$1_0/1bitblock$1$1_0/a_11480_63# GND 0.42359f
C1613 Y5 GND 0.13924f
C1614 4bitblock$1_0/1bitblock$1$1_0/a_9050_63# GND 0.55145f
C1615 4bitblock$1_0/1bitblock$1$1_0/a_7410_63# GND 0.55612f
C1616 4bitblock$1_0/1bitblock$1$1_0/a_5768_63# GND 0.55881f
C1617 4bitblock$1_0/1bitblock$1$1_0/a_1845_n37# GND 0.01974f
C1618 4bitblock$1_0/1bitblock$1$1_0/a_1262_n37# GND 0.0127f
C1619 4bitblock$1_0/1bitblock$1$1_0/a_870_n37# GND 0.01517f
C1620 4bitblock$1_0/1bitblock$1$1_0/a_4290_63# GND 0.59067f
C1621 4bitblock$1_0/1bitblock$1$1_0/a_2861_3# GND 0.62907f
C1622 4bitblock$1_0/1bitblock$1$1_0/a_1845_466# GND 0.59854f
C1623 4bitblock$1_0/1bitblock$1$1_0/a_2419_63# GND 6.65832f
C1624 4bitblock$1_0/1bitblock$1$1_0/a_510_63# GND 0.58003f
C1625 B5 GND 1.37769f
C1626 A5 GND 1.95649f
C1627 m1_16451_n989# GND 5.4248f
C1628 4bitblock$1_0/1bitblock$4_0/a_7083_63# GND 0.85222f
C1629 4bitblock$1_0/1bitblock$4_0/a_8723_63# GND 0.40569f
C1630 4bitblock$1_0/1bitblock$4_0/m2_9431_79# GND 0.62597f
C1631 4bitblock$1_0/1bitblock$4_0/m2_7791_79# GND 0.61991f
C1632 4bitblock$1_0/1bitblock$4_0/a_8361_407# GND 0.05045f
C1633 4bitblock$1_0/1bitblock$4_0/m2_6151_79# GND 0.6012f
C1634 4bitblock$1_0/1bitblock$4_0/a_6721_407# GND 0.01523f
C1635 4bitblock$1_0/1bitblock$4_0/a_5042_407# GND 0.79698f
C1636 4bitblock$1_0/1bitblock$4_0/a_3940_63# GND 0.46771f
C1637 4bitblock$1_0/m1_14167_n1145# GND 3.85556f
C1638 4bitblock$1_0/1bitblock$4_0/a_160_63# GND 0.60235f
C1639 4bitblock$1_0/1bitblock$4_0/a_5243_407# GND 0.01459f
C1640 4bitblock$1_0/1bitblock$4_0/a_705_407# GND 0.14103f
C1641 4bitblock$1_0/1bitblock$4_0/a_3498_3# GND 1.27846f
C1642 4bitblock$1_0/1bitblock$4_0/a_10906_n37# GND 0.02232f
C1643 4bitblock$1_0/1bitblock$4_0/a_9800_n37# GND 0.01742f
C1644 4bitblock$1_0/1bitblock$4_0/a_9408_n37# GND 0.01326f
C1645 4bitblock$1_0/1bitblock$4_0/a_8160_n37# GND 0.01743f
C1646 4bitblock$1_0/1bitblock$4_0/a_7768_n37# GND 0.01327f
C1647 4bitblock$1_0/1bitblock$4_0/a_6520_n37# GND 0.01743f
C1648 4bitblock$1_0/1bitblock$4_0/a_6128_n37# GND 0.01327f
C1649 4bitblock$1_0/1bitblock$4_0/a_5042_n37# GND 0.01422f
C1650 4bitblock$1_0/1bitblock$4_0/a_4650_n37# GND 0.01569f
C1651 4bitblock$1_0/1bitblock$4_0/a_11922_3# GND 0.64569f
C1652 4bitblock$1_0/1bitblock$4_0/a_11922_391# GND 0.00119f
C1653 4bitblock$1_0/1bitblock$4_0/a_10906_466# GND 0.59827f
C1654 4bitblock$1_0/1bitblock$4_0/a_11480_63# GND 0.42359f
C1655 Y4 GND 0.13924f
C1656 4bitblock$1_0/1bitblock$4_0/a_9050_63# GND 0.55145f
C1657 4bitblock$1_0/1bitblock$4_0/a_7410_63# GND 0.55612f
C1658 4bitblock$1_0/1bitblock$4_0/a_5768_63# GND 0.55881f
C1659 4bitblock$1_0/1bitblock$4_0/a_1845_n37# GND 0.01974f
C1660 4bitblock$1_0/1bitblock$4_0/a_1262_n37# GND 0.0127f
C1661 4bitblock$1_0/1bitblock$4_0/a_870_n37# GND 0.01586f
C1662 4bitblock$1_0/1bitblock$4_0/a_4290_63# GND 0.59067f
C1663 4bitblock$1_0/1bitblock$4_0/a_2861_3# GND 0.62907f
C1664 4bitblock$1_0/1bitblock$4_0/a_1845_466# GND 0.59854f
C1665 4bitblock$1_0/1bitblock$4_0/a_2419_63# GND 6.65822f
C1666 4bitblock$1_0/1bitblock$4_0/a_510_63# GND 0.58161f
C1667 B4 GND 1.3764f
C1668 4bitblock$1_0/1bitblock$4_0/a_9609_407# GND 0.11896f
C1669 A4 GND 1.91874f
C1670 4bitblock$1_0/MUX21$1_0/m2_540_79# GND 0.81279f
C1671 4bitblock$1_0/MUX21$1_0/a_718_407# GND 0.15145f
C1672 4bitblock$1_0/MUX21$1_0/a_909_n37# GND 0.01743f
C1673 4bitblock$1_0/MUX21$1_0/a_517_n37# GND 0.01327f
C1674 4bitblock$1_0/MUX21$1_0/a_157_63# GND 0.65278f
C1675 4bitblock$1_0/AND4$1_0/a_1120_n441# GND 0.02626f
C1676 4bitblock$1_0/AND4$1_0/a_912_n441# GND 0.02949f
C1677 4bitblock$1_0/AND4$1_0/a_704_n441# GND 0.03642f
C1678 BP1 GND 3.89522f
C1679 4bitblock$1_0/AND4$1_0/a_518_229# GND 0.81795f
C1680 4bitblock$1_0/m1_12484_n953# GND 3.11369f
C1681 4bitblock$1_0/1bitblock$2$1_0/a_7083_63# GND 0.85222f
C1682 4bitblock$1_0/1bitblock$2$1_0/a_8723_63# GND 0.40722f
C1683 4bitblock$1_0/1bitblock$2$1_0/m2_9431_79# GND 0.62597f
C1684 4bitblock$1_0/1bitblock$2$1_0/m2_7791_79# GND 0.61991f
C1685 4bitblock$1_0/1bitblock$2$1_0/a_9609_407# GND 0.11896f
C1686 4bitblock$1_0/1bitblock$2$1_0/a_8361_407# GND 0.05045f
C1687 4bitblock$1_0/1bitblock$2$1_0/m2_6151_79# GND 0.6012f
C1688 4bitblock$1_0/1bitblock$2$1_0/a_6721_407# GND 0.01523f
C1689 4bitblock$1_0/1bitblock$2$1_0/a_5042_407# GND 0.79698f
C1690 4bitblock$1_0/1bitblock$2$1_0/a_3940_63# GND 0.46771f
C1691 4bitblock$1_0/m2_2396_n2595# GND 3.94161f
C1692 4bitblock$1_0/1bitblock$2$1_0/a_160_63# GND 0.59114f
C1693 4bitblock$1_0/1bitblock$2$1_0/a_5243_407# GND 0.01459f
C1694 4bitblock$1_0/1bitblock$2$1_0/a_705_407# GND 0.13647f
C1695 4bitblock$1_0/1bitblock$2$1_0/a_3498_3# GND 1.27913f
C1696 4bitblock$1_0/1bitblock$2$1_0/a_10906_n37# GND 0.02232f
C1697 4bitblock$1_0/1bitblock$2$1_0/a_9800_n37# GND 0.01742f
C1698 4bitblock$1_0/1bitblock$2$1_0/a_9408_n37# GND 0.01326f
C1699 4bitblock$1_0/1bitblock$2$1_0/a_8160_n37# GND 0.01743f
C1700 4bitblock$1_0/1bitblock$2$1_0/a_7768_n37# GND 0.01327f
C1701 4bitblock$1_0/1bitblock$2$1_0/a_6520_n37# GND 0.01743f
C1702 4bitblock$1_0/1bitblock$2$1_0/a_6128_n37# GND 0.01327f
C1703 4bitblock$1_0/1bitblock$2$1_0/a_5042_n37# GND 0.01422f
C1704 4bitblock$1_0/1bitblock$2$1_0/a_4650_n37# GND 0.01569f
C1705 4bitblock$1_0/1bitblock$2$1_0/a_11922_3# GND 0.64569f
C1706 4bitblock$1_0/1bitblock$2$1_0/a_11922_391# GND 0.00119f
C1707 4bitblock$1_0/1bitblock$2$1_0/a_10906_466# GND 0.59827f
C1708 4bitblock$1_0/1bitblock$2$1_0/a_11480_63# GND 0.42359f
C1709 Y6 GND 0.13924f
C1710 4bitblock$1_0/1bitblock$2$1_0/a_9050_63# GND 0.55145f
C1711 4bitblock$1_0/1bitblock$2$1_0/a_7410_63# GND 0.55612f
C1712 4bitblock$1_0/1bitblock$2$1_0/a_5768_63# GND 0.55881f
C1713 4bitblock$1_0/1bitblock$2$1_0/a_1845_n37# GND 0.01974f
C1714 4bitblock$1_0/1bitblock$2$1_0/a_1262_n37# GND 0.0127f
C1715 4bitblock$1_0/1bitblock$2$1_0/a_870_n37# GND 0.01517f
C1716 4bitblock$1_0/1bitblock$2$1_0/a_4290_63# GND 0.59067f
C1717 4bitblock$1_0/1bitblock$2$1_0/a_2861_3# GND 0.62907f
C1718 4bitblock$1_0/1bitblock$2$1_0/a_1845_466# GND 0.59854f
C1719 4bitblock$1_0/1bitblock$2$1_0/a_2419_63# GND 6.65822f
C1720 4bitblock$1_0/1bitblock$2$1_0/a_510_63# GND 0.58003f
C1721 B6 GND 1.37769f
C1722 A6 GND 1.95649f
C1723 XOR$8_0/a_705_407# GND 0.19472f
C1724 XOR$8_0/a_1262_n37# GND 0.0127f
C1725 XOR$8_0/a_870_n37# GND 0.01517f
C1726 XOR$8_0/a_510_63# GND 0.62978f
C1727 m1_18541_n9769# GND 0.51715f
C1728 4bitblock_LAST_0/AND4$5_0/a_1120_n441# GND 0.02626f
C1729 4bitblock_LAST_0/AND4$5_0/a_912_n441# GND 0.02949f
C1730 4bitblock_LAST_0/AND4$5_0/a_704_n441# GND 0.03642f
C1731 BP3 GND 3.83843f
C1732 4bitblock_LAST_0/AND4$5_0/a_518_229# GND 0.81795f
C1733 4bitblock_LAST_0/m1_12486_242# GND 3.09263f
C1734 4bitblock_LAST_0/1bitblock$1$4_0/a_7083_63# GND 0.85222f
C1735 4bitblock_LAST_0/1bitblock$1$4_0/a_8723_63# GND 0.40722f
C1736 4bitblock_LAST_0/1bitblock$1$4_0/m2_9431_79# GND 0.62597f
C1737 4bitblock_LAST_0/1bitblock$1$4_0/m2_7791_79# GND 0.61991f
C1738 4bitblock_LAST_0/1bitblock$1$4_0/a_9609_407# GND 0.11896f
C1739 4bitblock_LAST_0/1bitblock$1$4_0/a_8361_407# GND 0.05045f
C1740 4bitblock_LAST_0/1bitblock$1$4_0/m2_6151_79# GND 0.6012f
C1741 4bitblock_LAST_0/1bitblock$1$4_0/a_6721_407# GND 0.01523f
C1742 4bitblock_LAST_0/1bitblock$1$4_0/a_5042_407# GND 0.79698f
C1743 4bitblock_LAST_0/1bitblock$1$4_0/a_3940_63# GND 0.46771f
C1744 4bitblock_LAST_0/m2_1701_n784# GND 3.90084f
C1745 4bitblock_LAST_0/1bitblock$1$4_0/a_160_63# GND 0.59114f
C1746 4bitblock_LAST_0/1bitblock$1$4_0/a_5243_407# GND 0.01459f
C1747 4bitblock_LAST_0/1bitblock$1$4_0/a_705_407# GND 0.13647f
C1748 4bitblock_LAST_0/1bitblock$1$4_0/a_3498_3# GND 1.27913f
C1749 4bitblock_LAST_0/1bitblock$1$4_0/a_10906_n37# GND 0.02232f
C1750 4bitblock_LAST_0/1bitblock$1$4_0/a_9800_n37# GND 0.01742f
C1751 4bitblock_LAST_0/1bitblock$1$4_0/a_9408_n37# GND 0.01326f
C1752 4bitblock_LAST_0/1bitblock$1$4_0/a_8160_n37# GND 0.01743f
C1753 4bitblock_LAST_0/1bitblock$1$4_0/a_7768_n37# GND 0.01327f
C1754 4bitblock_LAST_0/1bitblock$1$4_0/a_6520_n37# GND 0.01743f
C1755 4bitblock_LAST_0/1bitblock$1$4_0/a_6128_n37# GND 0.01327f
C1756 4bitblock_LAST_0/1bitblock$1$4_0/a_5042_n37# GND 0.01422f
C1757 4bitblock_LAST_0/1bitblock$1$4_0/a_4650_n37# GND 0.01569f
C1758 4bitblock_LAST_0/1bitblock$1$4_0/a_11922_3# GND 0.64569f
C1759 4bitblock_LAST_0/1bitblock$1$4_0/a_11922_391# GND 0.00119f
C1760 4bitblock_LAST_0/1bitblock$1$4_0/a_10906_466# GND 0.59827f
C1761 4bitblock_LAST_0/1bitblock$1$4_0/a_11480_63# GND 0.42359f
C1762 Y13 GND 0.13924f
C1763 4bitblock_LAST_0/1bitblock$1$4_0/a_9050_63# GND 0.55145f
C1764 4bitblock_LAST_0/1bitblock$1$4_0/a_7410_63# GND 0.55612f
C1765 4bitblock_LAST_0/1bitblock$1$4_0/a_5768_63# GND 0.55881f
C1766 4bitblock_LAST_0/1bitblock$1$4_0/a_1845_n37# GND 0.01974f
C1767 4bitblock_LAST_0/1bitblock$1$4_0/a_1262_n37# GND 0.0127f
C1768 4bitblock_LAST_0/1bitblock$1$4_0/a_870_n37# GND 0.01517f
C1769 4bitblock_LAST_0/1bitblock$1$4_0/a_4290_63# GND 0.59067f
C1770 4bitblock_LAST_0/1bitblock$1$4_0/a_2861_3# GND 0.62907f
C1771 4bitblock_LAST_0/1bitblock$1$4_0/a_1845_466# GND 0.59854f
C1772 4bitblock_LAST_0/1bitblock$1$4_0/a_2419_63# GND 6.65832f
C1773 4bitblock_LAST_0/1bitblock$1$4_0/a_510_63# GND 0.58003f
C1774 B13 GND 1.37769f
C1775 A13 GND 1.95649f
C1776 m2_16192_n18174# GND 5.94672f
C1777 4bitblock_LAST_0/1bitblock$7_0/a_7083_63# GND 0.85222f
C1778 4bitblock_LAST_0/1bitblock$7_0/a_8723_63# GND 0.40569f
C1779 4bitblock_LAST_0/1bitblock$7_0/m2_9431_79# GND 0.62597f
C1780 4bitblock_LAST_0/1bitblock$7_0/m2_7791_79# GND 0.61991f
C1781 4bitblock_LAST_0/1bitblock$7_0/a_8361_407# GND 0.05045f
C1782 4bitblock_LAST_0/1bitblock$7_0/m2_6151_79# GND 0.6012f
C1783 4bitblock_LAST_0/1bitblock$7_0/a_6721_407# GND 0.01523f
C1784 4bitblock_LAST_0/1bitblock$7_0/a_5042_407# GND 0.79698f
C1785 4bitblock_LAST_0/1bitblock$7_0/a_3940_63# GND 0.46771f
C1786 4bitblock_LAST_0/m1_14167_n1145# GND 3.92557f
C1787 4bitblock_LAST_0/1bitblock$7_0/a_160_63# GND 0.60235f
C1788 4bitblock_LAST_0/1bitblock$7_0/a_5243_407# GND 0.01459f
C1789 4bitblock_LAST_0/1bitblock$7_0/a_705_407# GND 0.14103f
C1790 4bitblock_LAST_0/1bitblock$7_0/a_3498_3# GND 1.27847f
C1791 4bitblock_LAST_0/1bitblock$7_0/a_10906_n37# GND 0.02232f
C1792 4bitblock_LAST_0/1bitblock$7_0/a_9800_n37# GND 0.01742f
C1793 4bitblock_LAST_0/1bitblock$7_0/a_9408_n37# GND 0.01326f
C1794 4bitblock_LAST_0/1bitblock$7_0/a_8160_n37# GND 0.01743f
C1795 4bitblock_LAST_0/1bitblock$7_0/a_7768_n37# GND 0.01327f
C1796 4bitblock_LAST_0/1bitblock$7_0/a_6520_n37# GND 0.01743f
C1797 4bitblock_LAST_0/1bitblock$7_0/a_6128_n37# GND 0.01327f
C1798 4bitblock_LAST_0/1bitblock$7_0/a_5042_n37# GND 0.01422f
C1799 4bitblock_LAST_0/1bitblock$7_0/a_4650_n37# GND 0.01569f
C1800 4bitblock_LAST_0/1bitblock$7_0/a_11922_3# GND 0.64569f
C1801 4bitblock_LAST_0/1bitblock$7_0/a_11922_391# GND 0.00119f
C1802 4bitblock_LAST_0/1bitblock$7_0/a_10906_466# GND 0.59827f
C1803 4bitblock_LAST_0/1bitblock$7_0/a_11480_63# GND 0.42359f
C1804 Y12 GND 0.13924f
C1805 4bitblock_LAST_0/1bitblock$7_0/a_9050_63# GND 0.55145f
C1806 4bitblock_LAST_0/1bitblock$7_0/a_7410_63# GND 0.55612f
C1807 4bitblock_LAST_0/1bitblock$7_0/a_5768_63# GND 0.55881f
C1808 4bitblock_LAST_0/1bitblock$7_0/a_1845_n37# GND 0.01974f
C1809 4bitblock_LAST_0/1bitblock$7_0/a_1262_n37# GND 0.0127f
C1810 4bitblock_LAST_0/1bitblock$7_0/a_870_n37# GND 0.01586f
C1811 4bitblock_LAST_0/1bitblock$7_0/a_4290_63# GND 0.59067f
C1812 4bitblock_LAST_0/1bitblock$7_0/a_2861_3# GND 0.62907f
C1813 4bitblock_LAST_0/1bitblock$7_0/a_1845_466# GND 0.59854f
C1814 4bitblock_LAST_0/1bitblock$7_0/a_2419_63# GND 6.65822f
C1815 4bitblock_LAST_0/1bitblock$7_0/a_510_63# GND 0.58161f
C1816 B12 GND 1.3764f
C1817 A12 GND 1.91875f
C1818 4bitblock_LAST_0/1bitblock$7_0/a_9609_407# GND 0.11896f
C1819 4bitblock_LAST_0/MUX21$4_0/m2_540_79# GND 0.81861f
C1820 4bitblock_LAST_0/MUX21$4_0/a_718_407# GND 0.15145f
C1821 4bitblock_LAST_0/MUX21$4_0/a_909_n37# GND 0.01743f
C1822 4bitblock_LAST_0/MUX21$4_0/a_517_n37# GND 0.01327f
C1823 m1_17438_n9725# GND 5.93449f
C1824 4bitblock_LAST_0/MUX21$4_0/a_157_63# GND 0.6534f
C1825 4bitblock_LAST_0/m1_12484_n953# GND 3.1136f
C1826 4bitblock_LAST_0/1bitblock$2$4_0/a_7083_63# GND 0.85222f
C1827 4bitblock_LAST_0/1bitblock$2$4_0/a_8723_63# GND 0.40722f
C1828 4bitblock_LAST_0/1bitblock$2$4_0/m2_9431_79# GND 0.62597f
C1829 4bitblock_LAST_0/1bitblock$2$4_0/m2_7791_79# GND 0.61991f
C1830 4bitblock_LAST_0/1bitblock$2$4_0/a_9609_407# GND 0.11896f
C1831 4bitblock_LAST_0/1bitblock$2$4_0/a_8361_407# GND 0.05045f
C1832 4bitblock_LAST_0/1bitblock$2$4_0/m2_6151_79# GND 0.6012f
C1833 4bitblock_LAST_0/1bitblock$2$4_0/a_6721_407# GND 0.01523f
C1834 4bitblock_LAST_0/1bitblock$2$4_0/a_5042_407# GND 0.79698f
C1835 4bitblock_LAST_0/1bitblock$2$4_0/a_3940_63# GND 0.46771f
C1836 4bitblock_LAST_0/m2_2396_n2595# GND 3.9416f
C1837 4bitblock_LAST_0/1bitblock$2$4_0/a_160_63# GND 0.59114f
C1838 4bitblock_LAST_0/1bitblock$2$4_0/a_5243_407# GND 0.01459f
C1839 4bitblock_LAST_0/1bitblock$2$4_0/a_705_407# GND 0.13647f
C1840 4bitblock_LAST_0/1bitblock$2$4_0/a_3498_3# GND 1.27913f
C1841 4bitblock_LAST_0/1bitblock$2$4_0/a_10906_n37# GND 0.02232f
C1842 4bitblock_LAST_0/1bitblock$2$4_0/a_9800_n37# GND 0.01742f
C1843 4bitblock_LAST_0/1bitblock$2$4_0/a_9408_n37# GND 0.01326f
C1844 4bitblock_LAST_0/1bitblock$2$4_0/a_8160_n37# GND 0.01743f
C1845 4bitblock_LAST_0/1bitblock$2$4_0/a_7768_n37# GND 0.01327f
C1846 4bitblock_LAST_0/1bitblock$2$4_0/a_6520_n37# GND 0.01743f
C1847 4bitblock_LAST_0/1bitblock$2$4_0/a_6128_n37# GND 0.01327f
C1848 4bitblock_LAST_0/1bitblock$2$4_0/a_5042_n37# GND 0.01422f
C1849 4bitblock_LAST_0/1bitblock$2$4_0/a_4650_n37# GND 0.01569f
C1850 4bitblock_LAST_0/1bitblock$2$4_0/a_11922_3# GND 0.64569f
C1851 4bitblock_LAST_0/1bitblock$2$4_0/a_11922_391# GND 0.00119f
C1852 4bitblock_LAST_0/1bitblock$2$4_0/a_10906_466# GND 0.59827f
C1853 4bitblock_LAST_0/1bitblock$2$4_0/a_11480_63# GND 0.42359f
C1854 Y14 GND 0.13924f
C1855 4bitblock_LAST_0/1bitblock$2$4_0/a_9050_63# GND 0.55145f
C1856 4bitblock_LAST_0/1bitblock$2$4_0/a_7410_63# GND 0.55612f
C1857 4bitblock_LAST_0/1bitblock$2$4_0/a_5768_63# GND 0.55881f
C1858 4bitblock_LAST_0/1bitblock$2$4_0/a_1845_n37# GND 0.01974f
C1859 4bitblock_LAST_0/1bitblock$2$4_0/a_1262_n37# GND 0.0127f
C1860 4bitblock_LAST_0/1bitblock$2$4_0/a_870_n37# GND 0.01517f
C1861 4bitblock_LAST_0/1bitblock$2$4_0/a_4290_63# GND 0.59067f
C1862 4bitblock_LAST_0/1bitblock$2$4_0/a_2861_3# GND 0.62907f
C1863 4bitblock_LAST_0/1bitblock$2$4_0/a_1845_466# GND 0.59854f
C1864 4bitblock_LAST_0/1bitblock$2$4_0/a_2419_63# GND 6.65822f
C1865 4bitblock_LAST_0/1bitblock$2$4_0/a_510_63# GND 0.58003f
C1866 B14 GND 1.37769f
C1867 VDD GND 0.56315p
C1868 A14 GND 1.95649f
C1869 m1_17790_n9717# GND 7.81537f
C1870 4bitblock_LAST_0/1bitblock$3$4_0/a_7083_63# GND 0.84982f
C1871 4bitblock_LAST_0/1bitblock$3$4_0/a_8723_63# GND 0.40578f
C1872 4bitblock_LAST_0/1bitblock$3$4_0/m2_9431_79# GND 0.62597f
C1873 4bitblock_LAST_0/1bitblock$3$4_0/m2_7791_79# GND 0.61991f
C1874 4bitblock_LAST_0/1bitblock$3$4_0/a_9609_407# GND 0.11896f
C1875 4bitblock_LAST_0/1bitblock$3$4_0/a_8361_407# GND 0.05045f
C1876 4bitblock_LAST_0/1bitblock$3$4_0/m2_6151_79# GND 0.60028f
C1877 4bitblock_LAST_0/1bitblock$3$4_0/a_6721_407# GND 0.01523f
C1878 m2_6320_n21444# GND 2.61511f
C1879 4bitblock_LAST_0/1bitblock$3$4_0/a_3940_63# GND 0.46771f
C1880 4bitblock_LAST_0/m1_13543_n1146# GND 3.88711f
C1881 4bitblock_LAST_0/1bitblock$3$4_0/a_160_63# GND 0.59114f
C1882 4bitblock_LAST_0/1bitblock$3$4_0/a_5243_407# GND 0.01459f
C1883 4bitblock_LAST_0/1bitblock$3$4_0/a_705_407# GND 0.13647f
C1884 4bitblock_LAST_0/1bitblock$3$4_0/a_3498_3# GND 1.27913f
C1885 4bitblock_LAST_0/1bitblock$3$4_0/a_10906_n37# GND 0.02232f
C1886 4bitblock_LAST_0/1bitblock$3$4_0/a_9800_n37# GND 0.01742f
C1887 4bitblock_LAST_0/1bitblock$3$4_0/a_9408_n37# GND 0.01326f
C1888 4bitblock_LAST_0/1bitblock$3$4_0/a_8160_n37# GND 0.01743f
C1889 4bitblock_LAST_0/1bitblock$3$4_0/a_7768_n37# GND 0.01327f
C1890 4bitblock_LAST_0/1bitblock$3$4_0/a_6520_n37# GND 0.01743f
C1891 4bitblock_LAST_0/1bitblock$3$4_0/a_6128_n37# GND 0.01327f
C1892 4bitblock_LAST_0/1bitblock$3$4_0/a_5042_n37# GND 0.01422f
C1893 4bitblock_LAST_0/1bitblock$3$4_0/a_4650_n37# GND 0.01569f
C1894 4bitblock_LAST_0/m1_12480_n3815# GND 2.89705f
C1895 4bitblock_LAST_0/1bitblock$3$4_0/a_11922_3# GND 0.64569f
C1896 4bitblock_LAST_0/1bitblock$3$4_0/a_11922_391# GND 0.00119f
C1897 4bitblock_LAST_0/1bitblock$3$4_0/a_10906_466# GND 0.59827f
C1898 4bitblock_LAST_0/1bitblock$3$4_0/a_11480_63# GND 0.42359f
C1899 Y15 GND 0.13924f
C1900 4bitblock_LAST_0/1bitblock$3$4_0/a_9050_63# GND 0.55145f
C1901 S1 GND 12.46222f
C1902 4bitblock_LAST_0/1bitblock$3$4_0/a_7410_63# GND 0.55612f
C1903 4bitblock_LAST_0/1bitblock$3$4_0/a_5768_63# GND 0.55881f
C1904 4bitblock_LAST_0/1bitblock$3$4_0/a_1845_n37# GND 0.01974f
C1905 4bitblock_LAST_0/1bitblock$3$4_0/a_1262_n37# GND 0.0127f
C1906 4bitblock_LAST_0/1bitblock$3$4_0/a_870_n37# GND 0.01517f
C1907 4bitblock_LAST_0/1bitblock$3$4_0/a_4290_63# GND 0.59067f
C1908 4bitblock_LAST_0/1bitblock$3$4_0/a_2861_3# GND 0.62907f
C1909 4bitblock_LAST_0/1bitblock$3$4_0/a_1845_466# GND 0.59854f
C1910 4bitblock_LAST_0/1bitblock$3$4_0/a_2419_63# GND 6.65822f
C1911 4bitblock_LAST_0/1bitblock$3$4_0/a_510_63# GND 0.58003f
C1912 B15 GND 1.37769f
C1913 S0 GND 22.33334f
C1914 A15 GND 1.95649f
C1915 AND4$4_0/a_1120_n441# GND 0.02626f
C1916 AND4$4_0/a_912_n441# GND 0.02949f
C1917 AND4$4_0/a_704_n441# GND 0.03642f
C1918 Z GND 0.21807f
C1919 AND4$4_0/a_518_229# GND 0.81612f
C1920 4bitblock$2_0/m1_12486_242# GND 3.08576f
C1921 4bitblock$2_0/1bitblock$1$2_0/a_7083_63# GND 0.85222f
C1922 4bitblock$2_0/1bitblock$1$2_0/a_8723_63# GND 0.40722f
C1923 4bitblock$2_0/1bitblock$1$2_0/m2_9431_79# GND 0.62597f
C1924 4bitblock$2_0/1bitblock$1$2_0/m2_7791_79# GND 0.61991f
C1925 4bitblock$2_0/1bitblock$1$2_0/a_9609_407# GND 0.11896f
C1926 4bitblock$2_0/1bitblock$1$2_0/a_8361_407# GND 0.05045f
C1927 4bitblock$2_0/1bitblock$1$2_0/m2_6151_79# GND 0.6012f
C1928 4bitblock$2_0/1bitblock$1$2_0/a_6721_407# GND 0.01523f
C1929 4bitblock$2_0/1bitblock$1$2_0/a_5042_407# GND 0.79698f
C1930 4bitblock$2_0/1bitblock$1$2_0/a_3940_63# GND 0.46771f
C1931 4bitblock$2_0/m2_1701_n784# GND 3.90084f
C1932 4bitblock$2_0/1bitblock$1$2_0/a_160_63# GND 0.59114f
C1933 4bitblock$2_0/1bitblock$1$2_0/a_5243_407# GND 0.01459f
C1934 4bitblock$2_0/1bitblock$1$2_0/a_705_407# GND 0.13647f
C1935 4bitblock$2_0/1bitblock$1$2_0/a_3498_3# GND 1.27913f
C1936 4bitblock$2_0/1bitblock$1$2_0/a_10906_n37# GND 0.02232f
C1937 4bitblock$2_0/1bitblock$1$2_0/a_9800_n37# GND 0.01742f
C1938 4bitblock$2_0/1bitblock$1$2_0/a_9408_n37# GND 0.01326f
C1939 4bitblock$2_0/1bitblock$1$2_0/a_8160_n37# GND 0.01743f
C1940 4bitblock$2_0/1bitblock$1$2_0/a_7768_n37# GND 0.01327f
C1941 4bitblock$2_0/1bitblock$1$2_0/a_6520_n37# GND 0.01743f
C1942 4bitblock$2_0/1bitblock$1$2_0/a_6128_n37# GND 0.01327f
C1943 4bitblock$2_0/1bitblock$1$2_0/a_5042_n37# GND 0.01422f
C1944 4bitblock$2_0/1bitblock$1$2_0/a_4650_n37# GND 0.01569f
C1945 4bitblock$2_0/1bitblock$1$2_0/a_11922_3# GND 0.64569f
C1946 4bitblock$2_0/1bitblock$1$2_0/a_11922_391# GND 0.00119f
C1947 4bitblock$2_0/1bitblock$1$2_0/a_10906_466# GND 0.59827f
C1948 4bitblock$2_0/1bitblock$1$2_0/a_11480_63# GND 0.42359f
C1949 Y9 GND 0.13924f
C1950 4bitblock$2_0/1bitblock$1$2_0/a_9050_63# GND 0.55145f
C1951 4bitblock$2_0/1bitblock$1$2_0/a_7410_63# GND 0.55612f
C1952 4bitblock$2_0/1bitblock$1$2_0/a_5768_63# GND 0.55881f
C1953 4bitblock$2_0/1bitblock$1$2_0/a_1845_n37# GND 0.01974f
C1954 4bitblock$2_0/1bitblock$1$2_0/a_1262_n37# GND 0.0127f
C1955 4bitblock$2_0/1bitblock$1$2_0/a_870_n37# GND 0.01517f
C1956 4bitblock$2_0/1bitblock$1$2_0/a_4290_63# GND 0.59067f
C1957 4bitblock$2_0/1bitblock$1$2_0/a_2861_3# GND 0.62907f
C1958 4bitblock$2_0/1bitblock$1$2_0/a_1845_466# GND 0.59854f
C1959 4bitblock$2_0/1bitblock$1$2_0/a_2419_63# GND 6.65832f
C1960 4bitblock$2_0/1bitblock$1$2_0/a_510_63# GND 0.58003f
C1961 B9 GND 1.37769f
C1962 A9 GND 1.95649f
C1963 m1_16199_n12176# GND 4.89724f
C1964 4bitblock$2_0/1bitblock$5_0/a_7083_63# GND 0.85222f
C1965 4bitblock$2_0/1bitblock$5_0/a_8723_63# GND 0.40569f
C1966 4bitblock$2_0/1bitblock$5_0/m2_9431_79# GND 0.62597f
C1967 4bitblock$2_0/1bitblock$5_0/m2_7791_79# GND 0.61991f
C1968 4bitblock$2_0/1bitblock$5_0/a_8361_407# GND 0.05045f
C1969 4bitblock$2_0/1bitblock$5_0/m2_6151_79# GND 0.6012f
C1970 4bitblock$2_0/1bitblock$5_0/a_6721_407# GND 0.01523f
C1971 4bitblock$2_0/1bitblock$5_0/a_5042_407# GND 0.79698f
C1972 4bitblock$2_0/1bitblock$5_0/a_3940_63# GND 0.46771f
C1973 4bitblock$2_0/m1_14167_n1145# GND 3.8578f
C1974 4bitblock$2_0/1bitblock$5_0/a_160_63# GND 0.60235f
C1975 4bitblock$2_0/1bitblock$5_0/a_5243_407# GND 0.01459f
C1976 4bitblock$2_0/1bitblock$5_0/a_705_407# GND 0.14103f
C1977 4bitblock$2_0/1bitblock$5_0/a_3498_3# GND 1.27846f
C1978 4bitblock$2_0/1bitblock$5_0/a_10906_n37# GND 0.02232f
C1979 4bitblock$2_0/1bitblock$5_0/a_9800_n37# GND 0.01742f
C1980 4bitblock$2_0/1bitblock$5_0/a_9408_n37# GND 0.01326f
C1981 4bitblock$2_0/1bitblock$5_0/a_8160_n37# GND 0.01743f
C1982 4bitblock$2_0/1bitblock$5_0/a_7768_n37# GND 0.01327f
C1983 4bitblock$2_0/1bitblock$5_0/a_6520_n37# GND 0.01743f
C1984 4bitblock$2_0/1bitblock$5_0/a_6128_n37# GND 0.01327f
C1985 4bitblock$2_0/1bitblock$5_0/a_5042_n37# GND 0.01422f
C1986 4bitblock$2_0/1bitblock$5_0/a_4650_n37# GND 0.01569f
C1987 4bitblock$2_0/1bitblock$5_0/a_11922_3# GND 0.64569f
C1988 4bitblock$2_0/1bitblock$5_0/a_11922_391# GND 0.00119f
C1989 4bitblock$2_0/1bitblock$5_0/a_10906_466# GND 0.59827f
C1990 4bitblock$2_0/1bitblock$5_0/a_11480_63# GND 0.42359f
C1991 Y8 GND 0.13924f
C1992 4bitblock$2_0/1bitblock$5_0/a_9050_63# GND 0.55145f
C1993 4bitblock$2_0/1bitblock$5_0/a_7410_63# GND 0.55612f
C1994 4bitblock$2_0/1bitblock$5_0/a_5768_63# GND 0.55881f
C1995 4bitblock$2_0/1bitblock$5_0/a_1845_n37# GND 0.01974f
C1996 4bitblock$2_0/1bitblock$5_0/a_1262_n37# GND 0.0127f
C1997 4bitblock$2_0/1bitblock$5_0/a_870_n37# GND 0.01586f
C1998 4bitblock$2_0/1bitblock$5_0/a_4290_63# GND 0.59067f
C1999 4bitblock$2_0/1bitblock$5_0/a_2861_3# GND 0.62907f
C2000 4bitblock$2_0/1bitblock$5_0/a_1845_466# GND 0.59854f
C2001 4bitblock$2_0/1bitblock$5_0/a_2419_63# GND 6.65822f
C2002 4bitblock$2_0/1bitblock$5_0/a_510_63# GND 0.58161f
C2003 B8 GND 1.3764f
C2004 A8 GND 1.91874f
C2005 4bitblock$2_0/1bitblock$5_0/a_9609_407# GND 0.11896f
C2006 4bitblock$2_0/AND4$2_0/a_1120_n441# GND 0.02626f
C2007 4bitblock$2_0/AND4$2_0/a_912_n441# GND 0.02949f
C2008 4bitblock$2_0/AND4$2_0/a_704_n441# GND 0.03642f
C2009 BP2 GND 3.35047f
C2010 4bitblock$2_0/AND4$2_0/a_518_229# GND 0.81795f
C2011 4bitblock$2_0/MUX21$2_0/m2_540_79# GND 0.8177f
C2012 4bitblock$2_0/MUX21$2_0/a_718_407# GND 0.15145f
C2013 4bitblock$2_0/MUX21$2_0/a_909_n37# GND 0.01743f
C2014 4bitblock$2_0/MUX21$2_0/a_517_n37# GND 0.01327f
C2015 4bitblock$2_0/MUX21$2_0/a_157_63# GND 0.65278f
C2016 4bitblock$2_0/m1_12484_n953# GND 3.11369f
C2017 4bitblock$2_0/1bitblock$2$2_0/a_7083_63# GND 0.85222f
C2018 4bitblock$2_0/1bitblock$2$2_0/a_8723_63# GND 0.40722f
C2019 4bitblock$2_0/1bitblock$2$2_0/m2_9431_79# GND 0.62597f
C2020 4bitblock$2_0/1bitblock$2$2_0/m2_7791_79# GND 0.61991f
C2021 4bitblock$2_0/1bitblock$2$2_0/a_9609_407# GND 0.11896f
C2022 4bitblock$2_0/1bitblock$2$2_0/a_8361_407# GND 0.05045f
C2023 4bitblock$2_0/1bitblock$2$2_0/m2_6151_79# GND 0.6012f
C2024 4bitblock$2_0/1bitblock$2$2_0/a_6721_407# GND 0.01523f
C2025 4bitblock$2_0/1bitblock$2$2_0/a_5042_407# GND 0.79698f
C2026 4bitblock$2_0/1bitblock$2$2_0/a_3940_63# GND 0.46771f
C2027 4bitblock$2_0/m2_2396_n2595# GND 3.94161f
C2028 4bitblock$2_0/1bitblock$2$2_0/a_160_63# GND 0.59114f
C2029 4bitblock$2_0/1bitblock$2$2_0/a_5243_407# GND 0.01459f
C2030 4bitblock$2_0/1bitblock$2$2_0/a_705_407# GND 0.13647f
C2031 4bitblock$2_0/1bitblock$2$2_0/a_3498_3# GND 1.27913f
C2032 4bitblock$2_0/1bitblock$2$2_0/a_10906_n37# GND 0.02232f
C2033 4bitblock$2_0/1bitblock$2$2_0/a_9800_n37# GND 0.01742f
C2034 4bitblock$2_0/1bitblock$2$2_0/a_9408_n37# GND 0.01326f
C2035 4bitblock$2_0/1bitblock$2$2_0/a_8160_n37# GND 0.01743f
C2036 4bitblock$2_0/1bitblock$2$2_0/a_7768_n37# GND 0.01327f
C2037 4bitblock$2_0/1bitblock$2$2_0/a_6520_n37# GND 0.01743f
C2038 4bitblock$2_0/1bitblock$2$2_0/a_6128_n37# GND 0.01327f
C2039 4bitblock$2_0/1bitblock$2$2_0/a_5042_n37# GND 0.01422f
C2040 4bitblock$2_0/1bitblock$2$2_0/a_4650_n37# GND 0.01569f
C2041 4bitblock$2_0/1bitblock$2$2_0/a_11922_3# GND 0.64569f
C2042 4bitblock$2_0/1bitblock$2$2_0/a_11922_391# GND 0.00119f
C2043 4bitblock$2_0/1bitblock$2$2_0/a_10906_466# GND 0.59827f
C2044 4bitblock$2_0/1bitblock$2$2_0/a_11480_63# GND 0.42359f
C2045 Y10 GND 0.13924f
C2046 4bitblock$2_0/1bitblock$2$2_0/a_9050_63# GND 0.55145f
C2047 4bitblock$2_0/1bitblock$2$2_0/a_7410_63# GND 0.55612f
C2048 4bitblock$2_0/1bitblock$2$2_0/a_5768_63# GND 0.55881f
C2049 4bitblock$2_0/1bitblock$2$2_0/a_1845_n37# GND 0.01974f
C2050 4bitblock$2_0/1bitblock$2$2_0/a_1262_n37# GND 0.0127f
C2051 4bitblock$2_0/1bitblock$2$2_0/a_870_n37# GND 0.01517f
C2052 4bitblock$2_0/1bitblock$2$2_0/a_4290_63# GND 0.59067f
C2053 4bitblock$2_0/1bitblock$2$2_0/a_2861_3# GND 0.62907f
C2054 4bitblock$2_0/1bitblock$2$2_0/a_1845_466# GND 0.59854f
C2055 4bitblock$2_0/1bitblock$2$2_0/a_2419_63# GND 6.65822f
C2056 4bitblock$2_0/1bitblock$2$2_0/a_510_63# GND 0.58003f
C2057 B10 GND 1.37769f
C2058 A10 GND 1.94757f
C2059 4bitblock$2_0/m2_10721_n3315# GND 3.11409f
C2060 4bitblock$2_0/1bitblock$3$2_0/a_7083_63# GND 0.85222f
C2061 4bitblock$2_0/1bitblock$3$2_0/a_8723_63# GND 0.40578f
C2062 4bitblock$2_0/1bitblock$3$2_0/m2_9431_79# GND 0.62597f
C2063 4bitblock$2_0/1bitblock$3$2_0/m2_7791_79# GND 0.61991f
C2064 4bitblock$2_0/1bitblock$3$2_0/a_9609_407# GND 0.11896f
C2065 4bitblock$2_0/1bitblock$3$2_0/a_8361_407# GND 0.05045f
C2066 4bitblock$2_0/1bitblock$3$2_0/m2_6151_79# GND 0.6012f
C2067 4bitblock$2_0/1bitblock$3$2_0/a_6721_407# GND 0.01523f
C2068 4bitblock$2_0/1bitblock$3$2_0/a_5042_407# GND 0.79698f
C2069 4bitblock$2_0/1bitblock$3$2_0/a_3940_63# GND 0.46771f
C2070 4bitblock$2_0/m1_13543_n1146# GND 3.94827f
C2071 4bitblock$2_0/1bitblock$3$2_0/a_160_63# GND 0.59114f
C2072 4bitblock$2_0/1bitblock$3$2_0/a_5243_407# GND 0.01459f
C2073 4bitblock$2_0/1bitblock$3$2_0/a_705_407# GND 0.13647f
C2074 4bitblock$2_0/1bitblock$3$2_0/a_3498_3# GND 1.27913f
C2075 4bitblock$2_0/1bitblock$3$2_0/a_10906_n37# GND 0.02232f
C2076 4bitblock$2_0/1bitblock$3$2_0/a_9800_n37# GND 0.01742f
C2077 4bitblock$2_0/1bitblock$3$2_0/a_9408_n37# GND 0.01326f
C2078 4bitblock$2_0/1bitblock$3$2_0/a_8160_n37# GND 0.01743f
C2079 4bitblock$2_0/1bitblock$3$2_0/a_7768_n37# GND 0.01327f
C2080 4bitblock$2_0/1bitblock$3$2_0/a_6520_n37# GND 0.01743f
C2081 4bitblock$2_0/1bitblock$3$2_0/a_6128_n37# GND 0.01327f
C2082 4bitblock$2_0/1bitblock$3$2_0/a_5042_n37# GND 0.01422f
C2083 4bitblock$2_0/1bitblock$3$2_0/a_4650_n37# GND 0.01569f
C2084 4bitblock$2_0/m1_12480_n3815# GND 2.34517f
C2085 4bitblock$2_0/1bitblock$3$2_0/a_11922_3# GND 0.64569f
C2086 4bitblock$2_0/1bitblock$3$2_0/a_11922_391# GND 0.00119f
C2087 4bitblock$2_0/1bitblock$3$2_0/a_10906_466# GND 0.59827f
C2088 4bitblock$2_0/1bitblock$3$2_0/a_11480_63# GND 0.42359f
C2089 Y11 GND 0.13924f
C2090 4bitblock$2_0/1bitblock$3$2_0/a_9050_63# GND 0.55145f
C2091 4bitblock$2_0/1bitblock$3$2_0/a_7410_63# GND 0.55612f
C2092 4bitblock$2_0/1bitblock$3$2_0/a_5768_63# GND 0.55881f
C2093 4bitblock$2_0/1bitblock$3$2_0/a_1845_n37# GND 0.01974f
C2094 4bitblock$2_0/1bitblock$3$2_0/a_1262_n37# GND 0.0127f
C2095 4bitblock$2_0/1bitblock$3$2_0/a_870_n37# GND 0.01517f
C2096 4bitblock$2_0/1bitblock$3$2_0/a_4290_63# GND 0.59067f
C2097 4bitblock$2_0/1bitblock$3$2_0/a_2861_3# GND 0.62907f
C2098 4bitblock$2_0/1bitblock$3$2_0/a_1845_466# GND 0.59854f
C2099 4bitblock$2_0/1bitblock$3$2_0/a_2419_63# GND 6.65822f
C2100 4bitblock$2_0/1bitblock$3$2_0/a_510_63# GND 0.58003f
C2101 B11 GND 1.37287f
C2102 A11 GND 1.91221f
C2103 N GND 0.34168f
C2104 XOR$9_0/a_160_63# GND 0.65112f
C2105 XOR$9_0/a_705_407# GND 0.23897f
C2106 XOR$9_0/a_1262_n37# GND 0.01349f
C2107 XOR$9_0/a_870_n37# GND 0.01548f
C2108 XOR$9_0/a_510_63# GND 0.65179f
C2109 F GND 2.24107f
C2110 4bitblock_0/m1_12486_242# GND 3.09263f
C2111 4bitblock_0/1bitblock$1_0/a_7083_63# GND 0.85222f
C2112 4bitblock_0/1bitblock$1_0/a_8723_63# GND 0.40722f
C2113 4bitblock_0/1bitblock$1_0/m2_9431_79# GND 0.62597f
C2114 4bitblock_0/1bitblock$1_0/m2_7791_79# GND 0.61991f
C2115 4bitblock_0/1bitblock$1_0/a_9609_407# GND 0.11896f
C2116 4bitblock_0/1bitblock$1_0/a_8361_407# GND 0.05045f
C2117 4bitblock_0/1bitblock$1_0/m2_6151_79# GND 0.6012f
C2118 4bitblock_0/1bitblock$1_0/a_6721_407# GND 0.01523f
C2119 4bitblock_0/1bitblock$1_0/a_5042_407# GND 0.79698f
C2120 4bitblock_0/1bitblock$1_0/a_3940_63# GND 0.46771f
C2121 4bitblock_0/m2_1701_n784# GND 3.90084f
C2122 4bitblock_0/1bitblock$1_0/a_160_63# GND 0.59114f
C2123 4bitblock_0/1bitblock$1_0/a_5243_407# GND 0.01459f
C2124 4bitblock_0/1bitblock$1_0/a_705_407# GND 0.13647f
C2125 4bitblock_0/1bitblock$1_0/a_3498_3# GND 1.27913f
C2126 4bitblock_0/1bitblock$1_0/a_10906_n37# GND 0.02232f
C2127 4bitblock_0/1bitblock$1_0/a_9800_n37# GND 0.01742f
C2128 4bitblock_0/1bitblock$1_0/a_9408_n37# GND 0.01326f
C2129 4bitblock_0/1bitblock$1_0/a_8160_n37# GND 0.01743f
C2130 4bitblock_0/1bitblock$1_0/a_7768_n37# GND 0.01327f
C2131 4bitblock_0/1bitblock$1_0/a_6520_n37# GND 0.01743f
C2132 4bitblock_0/1bitblock$1_0/a_6128_n37# GND 0.01327f
C2133 4bitblock_0/1bitblock$1_0/a_5042_n37# GND 0.01422f
C2134 4bitblock_0/1bitblock$1_0/a_4650_n37# GND 0.01569f
C2135 4bitblock_0/1bitblock$1_0/a_11922_3# GND 0.64569f
C2136 4bitblock_0/1bitblock$1_0/a_11922_391# GND 0.00119f
C2137 4bitblock_0/1bitblock$1_0/a_10906_466# GND 0.59827f
C2138 4bitblock_0/1bitblock$1_0/a_11480_63# GND 0.42359f
C2139 Y1 GND 0.13924f
C2140 4bitblock_0/1bitblock$1_0/a_9050_63# GND 0.55145f
C2141 4bitblock_0/1bitblock$1_0/a_7410_63# GND 0.55612f
C2142 4bitblock_0/1bitblock$1_0/a_5768_63# GND 0.55881f
C2143 4bitblock_0/1bitblock$1_0/a_1845_n37# GND 0.01974f
C2144 4bitblock_0/1bitblock$1_0/a_1262_n37# GND 0.0127f
C2145 4bitblock_0/1bitblock$1_0/a_870_n37# GND 0.01517f
C2146 4bitblock_0/1bitblock$1_0/a_4290_63# GND 0.59067f
C2147 4bitblock_0/1bitblock$1_0/a_2861_3# GND 0.62907f
C2148 4bitblock_0/1bitblock$1_0/a_1845_466# GND 0.59854f
C2149 4bitblock_0/1bitblock$1_0/a_2419_63# GND 6.65832f
C2150 4bitblock_0/1bitblock$1_0/a_510_63# GND 0.58003f
C2151 B1 GND 1.37769f
C2152 A1 GND 1.95649f
C2153 Cin GND 3.8408f
C2154 4bitblock_0/1bitblock_0/a_7083_63# GND 0.85222f
C2155 4bitblock_0/1bitblock_0/a_8723_63# GND 0.40569f
C2156 4bitblock_0/1bitblock_0/m2_9431_79# GND 0.62597f
C2157 4bitblock_0/1bitblock_0/m2_7791_79# GND 0.61991f
C2158 4bitblock_0/1bitblock_0/a_8361_407# GND 0.05045f
C2159 4bitblock_0/1bitblock_0/m2_6151_79# GND 0.6012f
C2160 4bitblock_0/1bitblock_0/a_6721_407# GND 0.01523f
C2161 4bitblock_0/1bitblock_0/a_5042_407# GND 0.79698f
C2162 4bitblock_0/1bitblock_0/a_3940_63# GND 0.46771f
C2163 4bitblock_0/m1_14167_n1145# GND 3.85587f
C2164 4bitblock_0/1bitblock_0/a_160_63# GND 0.59114f
C2165 4bitblock_0/1bitblock_0/a_5243_407# GND 0.01459f
C2166 4bitblock_0/1bitblock_0/a_705_407# GND 0.13647f
C2167 4bitblock_0/1bitblock_0/a_3498_3# GND 1.27845f
C2168 4bitblock_0/1bitblock_0/a_10906_n37# GND 0.02232f
C2169 4bitblock_0/1bitblock_0/a_9800_n37# GND 0.01742f
C2170 4bitblock_0/1bitblock_0/a_9408_n37# GND 0.01326f
C2171 4bitblock_0/1bitblock_0/a_8160_n37# GND 0.01743f
C2172 4bitblock_0/1bitblock_0/a_7768_n37# GND 0.01327f
C2173 4bitblock_0/1bitblock_0/a_6520_n37# GND 0.01743f
C2174 4bitblock_0/1bitblock_0/a_6128_n37# GND 0.01327f
C2175 4bitblock_0/1bitblock_0/a_5042_n37# GND 0.01422f
C2176 4bitblock_0/1bitblock_0/a_4650_n37# GND 0.01569f
C2177 4bitblock_0/1bitblock_0/a_11922_3# GND 0.64569f
C2178 4bitblock_0/1bitblock_0/a_11922_391# GND 0.00119f
C2179 4bitblock_0/1bitblock_0/a_10906_466# GND 0.59827f
C2180 4bitblock_0/1bitblock_0/a_11480_63# GND 0.42359f
C2181 Y0 GND 0.13924f
C2182 4bitblock_0/1bitblock_0/a_9050_63# GND 0.55145f
C2183 4bitblock_0/1bitblock_0/a_7410_63# GND 0.55612f
C2184 4bitblock_0/1bitblock_0/a_5768_63# GND 0.55881f
C2185 4bitblock_0/1bitblock_0/a_1845_n37# GND 0.01974f
C2186 4bitblock_0/1bitblock_0/a_1262_n37# GND 0.0127f
C2187 4bitblock_0/1bitblock_0/a_870_n37# GND 0.01517f
C2188 4bitblock_0/1bitblock_0/a_4290_63# GND 0.59067f
C2189 4bitblock_0/1bitblock_0/a_2861_3# GND 0.62907f
C2190 4bitblock_0/1bitblock_0/a_1845_466# GND 0.59854f
C2191 4bitblock_0/1bitblock_0/a_2419_63# GND 6.65822f
C2192 4bitblock_0/1bitblock_0/a_510_63# GND 0.58003f
C2193 B0 GND 1.37769f
C2194 4bitblock_0/1bitblock_0/a_9609_407# GND 0.11896f
C2195 A0 GND 1.95649f
C2196 4bitblock_0/m2_10721_n3315# GND 3.11409f
C2197 4bitblock_0/1bitblock$3_0/a_7083_63# GND 0.85222f
C2198 4bitblock_0/1bitblock$3_0/a_8723_63# GND 0.40578f
C2199 4bitblock_0/1bitblock$3_0/m2_9431_79# GND 0.62597f
C2200 4bitblock_0/1bitblock$3_0/m2_7791_79# GND 0.61991f
C2201 4bitblock_0/1bitblock$3_0/a_9609_407# GND 0.11896f
C2202 4bitblock_0/1bitblock$3_0/a_8361_407# GND 0.05045f
C2203 4bitblock_0/1bitblock$3_0/m2_6151_79# GND 0.6012f
C2204 4bitblock_0/1bitblock$3_0/a_6721_407# GND 0.01523f
C2205 4bitblock_0/1bitblock$3_0/a_5042_407# GND 0.79698f
C2206 4bitblock_0/1bitblock$3_0/a_3940_63# GND 0.46771f
C2207 4bitblock_0/m1_13543_n1146# GND 3.94827f
C2208 4bitblock_0/1bitblock$3_0/a_160_63# GND 0.59114f
C2209 4bitblock_0/1bitblock$3_0/a_5243_407# GND 0.01459f
C2210 4bitblock_0/1bitblock$3_0/a_705_407# GND 0.13647f
C2211 4bitblock_0/1bitblock$3_0/a_3498_3# GND 1.27913f
C2212 4bitblock_0/1bitblock$3_0/a_10906_n37# GND 0.02232f
C2213 4bitblock_0/1bitblock$3_0/a_9800_n37# GND 0.01742f
C2214 4bitblock_0/1bitblock$3_0/a_9408_n37# GND 0.01326f
C2215 4bitblock_0/1bitblock$3_0/a_8160_n37# GND 0.01743f
C2216 4bitblock_0/1bitblock$3_0/a_7768_n37# GND 0.01327f
C2217 4bitblock_0/1bitblock$3_0/a_6520_n37# GND 0.01743f
C2218 4bitblock_0/1bitblock$3_0/a_6128_n37# GND 0.01327f
C2219 4bitblock_0/1bitblock$3_0/a_5042_n37# GND 0.01422f
C2220 4bitblock_0/1bitblock$3_0/a_4650_n37# GND 0.01569f
C2221 4bitblock_0/m1_12480_n3815# GND 2.2546f
C2222 4bitblock_0/1bitblock$3_0/a_11922_3# GND 0.64569f
C2223 4bitblock_0/1bitblock$3_0/a_11922_391# GND 0.00119f
C2224 4bitblock_0/1bitblock$3_0/a_10906_466# GND 0.59827f
C2225 4bitblock_0/1bitblock$3_0/a_11480_63# GND 0.42359f
C2226 Y3 GND 0.13924f
C2227 4bitblock_0/1bitblock$3_0/a_9050_63# GND 0.55145f
C2228 4bitblock_0/1bitblock$3_0/a_7410_63# GND 0.55612f
C2229 4bitblock_0/1bitblock$3_0/a_5768_63# GND 0.55881f
C2230 4bitblock_0/1bitblock$3_0/a_1845_n37# GND 0.01974f
C2231 4bitblock_0/1bitblock$3_0/a_1262_n37# GND 0.0127f
C2232 4bitblock_0/1bitblock$3_0/a_870_n37# GND 0.01517f
C2233 4bitblock_0/1bitblock$3_0/a_4290_63# GND 0.59067f
C2234 4bitblock_0/1bitblock$3_0/a_2861_3# GND 0.62907f
C2235 4bitblock_0/1bitblock$3_0/a_1845_466# GND 0.59854f
C2236 4bitblock_0/1bitblock$3_0/a_2419_63# GND 6.65822f
C2237 4bitblock_0/1bitblock$3_0/a_510_63# GND 0.58003f
C2238 B3 GND 1.37287f
C2239 A3 GND 1.91221f
C2240 4bitblock_0/AND4_0/a_1120_n441# GND 0.02626f
C2241 4bitblock_0/AND4_0/a_912_n441# GND 0.02949f
C2242 4bitblock_0/AND4_0/a_704_n441# GND 0.03642f
C2243 BP0 GND 6.37077f
C2244 4bitblock_0/AND4_0/a_518_229# GND 0.81795f
C2245 4bitblock_0/m1_12484_n953# GND 3.11369f
C2246 4bitblock_0/1bitblock$2_0/a_7083_63# GND 0.85222f
C2247 4bitblock_0/1bitblock$2_0/a_8723_63# GND 0.40722f
C2248 4bitblock_0/1bitblock$2_0/m2_9431_79# GND 0.62597f
C2249 4bitblock_0/1bitblock$2_0/m2_7791_79# GND 0.61991f
C2250 4bitblock_0/1bitblock$2_0/a_9609_407# GND 0.11896f
C2251 4bitblock_0/1bitblock$2_0/a_8361_407# GND 0.05045f
C2252 4bitblock_0/1bitblock$2_0/m2_6151_79# GND 0.6012f
C2253 4bitblock_0/1bitblock$2_0/a_6721_407# GND 0.01523f
C2254 4bitblock_0/1bitblock$2_0/a_5042_407# GND 0.79698f
C2255 4bitblock_0/1bitblock$2_0/a_3940_63# GND 0.46771f
C2256 4bitblock_0/m2_2396_n2595# GND 3.94161f
C2257 4bitblock_0/1bitblock$2_0/a_160_63# GND 0.59114f
C2258 4bitblock_0/1bitblock$2_0/a_5243_407# GND 0.01459f
C2259 4bitblock_0/1bitblock$2_0/a_705_407# GND 0.13647f
C2260 4bitblock_0/1bitblock$2_0/a_3498_3# GND 1.27913f
C2261 4bitblock_0/1bitblock$2_0/a_10906_n37# GND 0.02232f
C2262 4bitblock_0/1bitblock$2_0/a_9800_n37# GND 0.01742f
C2263 4bitblock_0/1bitblock$2_0/a_9408_n37# GND 0.01326f
C2264 4bitblock_0/1bitblock$2_0/a_8160_n37# GND 0.01743f
C2265 4bitblock_0/1bitblock$2_0/a_7768_n37# GND 0.01327f
C2266 4bitblock_0/1bitblock$2_0/a_6520_n37# GND 0.01743f
C2267 4bitblock_0/1bitblock$2_0/a_6128_n37# GND 0.01327f
C2268 4bitblock_0/1bitblock$2_0/a_5042_n37# GND 0.01422f
C2269 4bitblock_0/1bitblock$2_0/a_4650_n37# GND 0.01569f
C2270 4bitblock_0/1bitblock$2_0/a_11922_3# GND 0.64569f
C2271 4bitblock_0/1bitblock$2_0/a_11922_391# GND 0.00119f
C2272 4bitblock_0/1bitblock$2_0/a_10906_466# GND 0.59827f
C2273 4bitblock_0/1bitblock$2_0/a_11480_63# GND 0.42359f
C2274 Y2 GND 0.13924f
C2275 4bitblock_0/1bitblock$2_0/a_9050_63# GND 0.55145f
C2276 4bitblock_0/1bitblock$2_0/a_7410_63# GND 0.55612f
C2277 4bitblock_0/1bitblock$2_0/a_5768_63# GND 0.55881f
C2278 4bitblock_0/1bitblock$2_0/a_1845_n37# GND 0.01974f
C2279 4bitblock_0/1bitblock$2_0/a_1262_n37# GND 0.0127f
C2280 4bitblock_0/1bitblock$2_0/a_870_n37# GND 0.01517f
C2281 4bitblock_0/1bitblock$2_0/a_4290_63# GND 0.59067f
C2282 4bitblock_0/1bitblock$2_0/a_2861_3# GND 0.62907f
C2283 4bitblock_0/1bitblock$2_0/a_1845_466# GND 0.59854f
C2284 4bitblock_0/1bitblock$2_0/a_2419_63# GND 6.65822f
C2285 4bitblock_0/1bitblock$2_0/a_510_63# GND 0.58003f
C2286 B2 GND 1.37769f
C2287 A2 GND 1.95649f
C2288 4bitblock_0/MUX21_0/m2_540_79# GND 0.81794f
C2289 4bitblock_0/MUX21_0/a_718_407# GND 0.15145f
C2290 4bitblock_0/MUX21_0/a_909_n37# GND 0.01743f
C2291 4bitblock_0/MUX21_0/a_517_n37# GND 0.01327f
C2292 4bitblock_0/MUX21_0/a_157_63# GND 0.65278f
.ends
