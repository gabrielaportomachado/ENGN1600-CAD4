* NGSPICE file created from 4bitblock.ext - technology: gf180mcuD

.subckt MUX21 a_1472_63# a_157_63# a_25_271# a_909_n37# a_650_n277# a_517_n37# a_718_407#
+ m2_540_79# via_dev$11_4/VSUBS a_846_955# w_n310_281#
X0 a_1472_63# m2_540_79# via_dev$11_4/VSUBS via_dev$11_4/VSUBS nfet_03v3 ad=0.2625p pd=2.05u as=0.265p ps=2.06u w=0.5u l=0.28u
X1 a_157_63# a_25_271# w_n310_281# w_n310_281# pfet_03v3 ad=0.65p pd=3.3u as=0.635p ps=3.27u w=1u l=0.28u
X2 a_718_407# a_650_n277# m2_540_79# w_n310_281# pfet_03v3 ad=0.675p pd=2.675u as=0.725p ps=2.725u w=2u l=0.28u
X3 a_517_n37# a_25_271# via_dev$11_4/VSUBS via_dev$11_4/VSUBS nfet_03v3 ad=0.3625p pd=1.725u as=0.54p ps=3.08u w=1u l=0.28u
X4 via_dev$11_4/VSUBS a_157_63# a_909_n37# via_dev$11_4/VSUBS nfet_03v3 ad=0.65p pd=3.3u as=0.3625p ps=1.725u w=1u l=0.28u
X5 m2_540_79# a_25_271# a_718_407# w_n310_281# pfet_03v3 ad=0.725p pd=2.725u as=1.09p ps=5.09u w=2u l=0.28u
X6 a_157_63# a_25_271# via_dev$11_4/VSUBS via_dev$11_4/VSUBS nfet_03v3 ad=0.315p pd=2.26u as=0.3175p ps=2.27u w=0.5u l=0.28u
X7 a_718_407# a_157_63# w_n310_281# w_n310_281# pfet_03v3 ad=1.3p pd=5.3u as=0.725p ps=2.725u w=2u l=0.28u
X8 a_909_n37# a_846_955# m2_540_79# via_dev$11_4/VSUBS nfet_03v3 ad=0.3625p pd=1.725u as=0.3375p ps=1.675u w=1u l=0.28u
X9 w_n310_281# a_846_955# a_718_407# w_n310_281# pfet_03v3 ad=0.725p pd=2.725u as=0.675p ps=2.675u w=2u l=0.28u
X10 a_1472_63# m2_540_79# w_n310_281# w_n310_281# pfet_03v3 ad=0.545p pd=3.09u as=0.53p ps=3.06u w=1u l=0.28u
X11 m2_540_79# a_650_n277# a_517_n37# via_dev$11_4/VSUBS nfet_03v3 ad=0.3375p pd=1.675u as=0.3625p ps=1.725u w=1u l=0.28u
C0 a_517_n37# m2_540_79# 0.01733f
C1 a_718_407# w_n310_281# 0.7633f
C2 a_1472_63# a_157_63# 0.0156f
C3 a_909_n37# m2_540_79# 0.01048f
C4 w_n310_281# a_25_271# 0.47695f
C5 a_718_407# a_25_271# 0.03028f
C6 m2_540_79# a_846_955# 0.017f
C7 a_846_955# a_650_n277# 0.04128f
C8 w_n310_281# a_157_63# 0.32903f
C9 m2_540_79# a_650_n277# 0.03687f
C10 a_718_407# a_157_63# 0.14486f
C11 a_25_271# a_157_63# 0.11031f
C12 a_1472_63# a_846_955# 0
C13 a_517_n37# a_718_407# 0
C14 a_1472_63# m2_540_79# 0.0785f
C15 a_1472_63# a_650_n277# 0
C16 w_n310_281# a_846_955# 0.19275f
C17 a_718_407# a_846_955# 0.01845f
C18 a_517_n37# a_157_63# 0.00935f
C19 m2_540_79# w_n310_281# 0.45246f
C20 a_718_407# m2_540_79# 0.49779f
C21 w_n310_281# a_650_n277# 0.11257f
C22 a_718_407# a_650_n277# 0.01687f
C23 a_909_n37# a_157_63# 0.01329f
C24 m2_540_79# a_25_271# 0.03352f
C25 a_25_271# a_650_n277# 0.03814f
C26 a_846_955# a_157_63# 0.07151f
C27 m2_540_79# a_157_63# 0.36591f
C28 a_650_n277# a_157_63# 0.02096f
C29 a_1472_63# w_n310_281# 0.10269f
C30 a_1472_63# a_718_407# 0.01268f
C31 a_1472_63# a_25_271# 0
C32 m2_540_79# via_dev$11_4/VSUBS 0.94619f
C33 a_718_407# via_dev$11_4/VSUBS 0.15332f
C34 a_909_n37# via_dev$11_4/VSUBS 0.01743f
C35 a_517_n37# via_dev$11_4/VSUBS 0.007f
C36 a_1472_63# via_dev$11_4/VSUBS 0.17252f
C37 a_157_63# via_dev$11_4/VSUBS 0.63396f
C38 a_650_n277# via_dev$11_4/VSUBS 0.37069f
C39 a_25_271# via_dev$11_4/VSUBS 0.66513f
C40 a_846_955# via_dev$11_4/VSUBS 0.36058f
C41 w_n310_281# via_dev$11_4/VSUBS 4.23822f
.ends

.subckt x1bitblock$2 a_2861_3# a_8361_407# a_6520_n37# a_1262_n37# a_2861_391# a_1845_466#
+ a_10906_n37# a_510_63# a_870_n37# a_6721_407# a_9800_n37# a_11480_63# a_6128_n37#
+ a_5768_63# a_8919_367# m2_6151_79# a_11922_391# a_5042_n37# a_9408_n37# a_9609_407#
+ a_5042_407# a_8160_n37# a_4158_271# a_11922_3# a_2419_63# m2_9431_79# a_10906_466#
+ a_4650_n37# a_9050_63# a_5243_407# a_7768_n37# a_3940_63# m2_7791_79# a_10363_63#
+ a_160_63# a_4290_63# a_7083_63# a_705_407# a_12559_3# a_7410_63# m2_5700_324# a_1845_n37#
+ via_dev$5$2_9/VSUBS m2_1295_79# a_8723_63# a_378_271# a_3498_3# w_n310_281# m2_24_342#
X0 a_2419_63# a_1845_466# via_dev$5$2_9/VSUBS via_dev$5$2_9/VSUBS nfet_03v3 ad=0.315p pd=2.26u as=0.2425p ps=1.97u w=0.5u l=0.28u
X1 a_1845_466# m2_24_342# a_1845_n37# via_dev$5$2_9/VSUBS nfet_03v3 ad=0.65p pd=3.3u as=0.42p ps=1.84u w=1u l=0.28u
X2 a_3940_63# m2_1295_79# w_n310_281# w_n310_281# pfet_03v3 ad=0.63p pd=3.26u as=0.65p ps=3.3u w=1u l=0.28u
X3 via_dev$5$2_9/VSUBS a_510_63# a_1262_n37# via_dev$5$2_9/VSUBS nfet_03v3 ad=0.65p pd=3.3u as=0.3625p ps=1.725u w=1u l=0.28u
X4 a_5243_407# a_4290_63# a_5042_407# w_n310_281# pfet_03v3 ad=1.3p pd=5.3u as=0.725p ps=2.725u w=2u l=0.28u
X5 a_6721_407# a_2419_63# m2_6151_79# w_n310_281# pfet_03v3 ad=0.675p pd=2.675u as=0.725p ps=2.725u w=2u l=0.28u
X6 a_10906_466# a_4158_271# w_n310_281# w_n310_281# pfet_03v3 ad=0.42p pd=1.84u as=0.65p ps=3.3u w=1u l=0.28u
X7 a_4290_63# a_4158_271# via_dev$5$2_9/VSUBS via_dev$5$2_9/VSUBS nfet_03v3 ad=0.315p pd=2.26u as=0.28p ps=2.12u w=0.5u l=0.28u
X8 w_n310_281# a_378_271# a_705_407# w_n310_281# pfet_03v3 ad=0.725p pd=2.725u as=1.09p ps=5.09u w=2u l=0.28u
X9 a_2861_3# m2_1295_79# via_dev$5$2_9/VSUBS via_dev$5$2_9/VSUBS nfet_03v3 ad=0.18125p pd=1.225u as=0.325p ps=2.3u w=0.5u l=0.28u
X10 via_dev$5$2_9/VSUBS a_2419_63# a_2861_3# via_dev$5$2_9/VSUBS nfet_03v3 ad=0.315p pd=2.26u as=0.18125p ps=1.225u w=0.5u l=0.28u
X11 m2_7791_79# m2_1295_79# a_7768_n37# via_dev$5$2_9/VSUBS nfet_03v3 ad=0.3375p pd=1.675u as=0.3625p ps=1.725u w=1u l=0.28u
X12 a_10906_n37# a_4158_271# via_dev$5$2_9/VSUBS via_dev$5$2_9/VSUBS nfet_03v3 ad=0.42p pd=1.84u as=0.63p ps=3.26u w=1u l=0.28u
X13 a_9050_63# a_8919_367# via_dev$5$2_9/VSUBS via_dev$5$2_9/VSUBS nfet_03v3 ad=0.31p pd=2.24u as=0.24p ps=1.96u w=0.5u l=0.28u
X14 a_11922_3# a_11480_63# via_dev$5$2_9/VSUBS via_dev$5$2_9/VSUBS nfet_03v3 ad=0.18125p pd=1.225u as=0.325p ps=2.3u w=0.5u l=0.28u
X15 via_dev$5$2_9/VSUBS a_2419_63# a_11922_3# via_dev$5$2_9/VSUBS nfet_03v3 ad=0.315p pd=2.26u as=0.18125p ps=1.225u w=0.5u l=0.28u
X16 a_705_407# a_510_63# m2_1295_79# w_n310_281# pfet_03v3 ad=1.3p pd=5.3u as=0.725p ps=2.725u w=2u l=0.28u
X17 a_4650_n37# a_4158_271# via_dev$5$2_9/VSUBS via_dev$5$2_9/VSUBS nfet_03v3 ad=0.3625p pd=1.725u as=0.54p ps=3.08u w=1u l=0.28u
X18 a_2861_3# a_2419_63# a_2861_391# w_n310_281# pfet_03v3 ad=1.3p pd=5.3u as=0.725p ps=2.725u w=2u l=0.28u
X19 a_5768_63# m2_5700_324# via_dev$5$2_9/VSUBS via_dev$5$2_9/VSUBS nfet_03v3 ad=0.315p pd=2.26u as=0.3175p ps=2.27u w=0.5u l=0.28u
X20 via_dev$5$2_9/VSUBS a_9050_63# a_9800_n37# via_dev$5$2_9/VSUBS nfet_03v3 ad=0.65p pd=3.3u as=0.3625p ps=1.725u w=1u l=0.28u
X21 a_8361_407# m2_1295_79# m2_7791_79# w_n310_281# pfet_03v3 ad=0.675p pd=2.675u as=0.725p ps=2.725u w=2u l=0.28u
X22 a_9408_n37# a_8919_367# via_dev$5$2_9/VSUBS via_dev$5$2_9/VSUBS nfet_03v3 ad=0.3625p pd=1.725u as=0.54p ps=3.08u w=1u l=0.28u
X23 a_3498_3# a_2861_3# w_n310_281# w_n310_281# pfet_03v3 ad=0.65p pd=3.3u as=0.675p ps=3.35u w=1u l=0.28u
X24 a_7410_63# m2_5700_324# via_dev$5$2_9/VSUBS via_dev$5$2_9/VSUBS nfet_03v3 ad=0.31p pd=2.24u as=0.24p ps=1.96u w=0.5u l=0.28u
X25 via_dev$5$2_9/VSUBS a_7410_63# a_8160_n37# via_dev$5$2_9/VSUBS nfet_03v3 ad=0.65p pd=3.3u as=0.3625p ps=1.725u w=1u l=0.28u
X26 a_8723_63# m2_7791_79# via_dev$5$2_9/VSUBS via_dev$5$2_9/VSUBS nfet_03v3 ad=0.2625p pd=2.05u as=0.265p ps=2.06u w=0.5u l=0.28u
X27 w_n310_281# a_4158_271# a_5243_407# w_n310_281# pfet_03v3 ad=0.725p pd=2.725u as=1.09p ps=5.09u w=2u l=0.28u
X28 a_5768_63# m2_5700_324# w_n310_281# w_n310_281# pfet_03v3 ad=0.65p pd=3.3u as=0.635p ps=3.27u w=1u l=0.28u
X29 a_9050_63# a_8919_367# w_n310_281# w_n310_281# pfet_03v3 ad=0.64p pd=3.28u as=0.48p ps=2.96u w=1u l=0.28u
X30 a_11922_391# a_11480_63# w_n310_281# w_n310_281# pfet_03v3 ad=0.725p pd=2.725u as=1.3p ps=5.3u w=2u l=0.28u
X31 a_160_63# m2_24_342# via_dev$5$2_9/VSUBS via_dev$5$2_9/VSUBS nfet_03v3 ad=0.315p pd=2.26u as=0.325p ps=2.3u w=0.5u l=0.28u
X32 a_9609_407# a_9050_63# w_n310_281# w_n310_281# pfet_03v3 ad=1.3p pd=5.3u as=0.725p ps=2.725u w=2u l=0.28u
X33 a_6128_n37# m2_5700_324# via_dev$5$2_9/VSUBS via_dev$5$2_9/VSUBS nfet_03v3 ad=0.3625p pd=1.725u as=0.54p ps=3.08u w=1u l=0.28u
X34 via_dev$5$2_9/VSUBS a_5768_63# a_6520_n37# via_dev$5$2_9/VSUBS nfet_03v3 ad=0.65p pd=3.3u as=0.3625p ps=1.725u w=1u l=0.28u
X35 a_7410_63# m2_5700_324# w_n310_281# w_n310_281# pfet_03v3 ad=0.64p pd=3.28u as=0.48p ps=2.96u w=1u l=0.28u
X36 m2_9431_79# a_8919_367# a_9609_407# w_n310_281# pfet_03v3 ad=0.725p pd=2.725u as=1.09p ps=5.09u w=2u l=0.28u
X37 a_11480_63# a_10906_466# via_dev$5$2_9/VSUBS via_dev$5$2_9/VSUBS nfet_03v3 ad=0.315p pd=2.26u as=0.2425p ps=1.97u w=0.5u l=0.28u
X38 a_1845_466# a_378_271# w_n310_281# w_n310_281# pfet_03v3 ad=0.42p pd=1.84u as=0.65p ps=3.3u w=1u l=0.28u
X39 a_8361_407# a_7410_63# w_n310_281# w_n310_281# pfet_03v3 ad=1.3p pd=5.3u as=0.725p ps=2.725u w=2u l=0.28u
X40 w_n310_281# m2_1295_79# a_10906_466# w_n310_281# pfet_03v3 ad=0.735p pd=2.47u as=0.42p ps=1.84u w=1u l=0.28u
X41 a_7083_63# m2_6151_79# via_dev$5$2_9/VSUBS via_dev$5$2_9/VSUBS nfet_03v3 ad=0.2625p pd=2.05u as=0.265p ps=2.06u w=0.5u l=0.28u
X42 a_510_63# a_378_271# w_n310_281# w_n310_281# pfet_03v3 ad=0.65p pd=3.3u as=0.56p ps=3.12u w=1u l=0.28u
X43 a_10363_63# m2_9431_79# w_n310_281# w_n310_281# pfet_03v3 ad=0.715p pd=3.43u as=0.53p ps=3.06u w=1u l=0.28u
X44 a_510_63# a_378_271# via_dev$5$2_9/VSUBS via_dev$5$2_9/VSUBS nfet_03v3 ad=0.315p pd=2.26u as=0.28p ps=2.12u w=0.5u l=0.28u
X45 a_1262_n37# a_160_63# m2_1295_79# via_dev$5$2_9/VSUBS nfet_03v3 ad=0.3625p pd=1.725u as=0.3375p ps=1.675u w=1u l=0.28u
X46 a_1845_n37# a_378_271# via_dev$5$2_9/VSUBS via_dev$5$2_9/VSUBS nfet_03v3 ad=0.42p pd=1.84u as=0.63p ps=3.26u w=1u l=0.28u
X47 m2_6151_79# m2_5700_324# a_6721_407# w_n310_281# pfet_03v3 ad=0.725p pd=2.725u as=1.09p ps=5.09u w=2u l=0.28u
X48 a_6721_407# a_5768_63# w_n310_281# w_n310_281# pfet_03v3 ad=1.3p pd=5.3u as=0.725p ps=2.725u w=2u l=0.28u
X49 a_10363_63# m2_9431_79# via_dev$5$2_9/VSUBS via_dev$5$2_9/VSUBS nfet_03v3 ad=0.3575p pd=2.43u as=0.265p ps=2.06u w=0.5u l=0.28u
X50 a_10906_466# m2_1295_79# a_10906_n37# via_dev$5$2_9/VSUBS nfet_03v3 ad=0.65p pd=3.3u as=0.42p ps=1.84u w=1u l=0.28u
X51 a_8723_63# m2_7791_79# w_n310_281# w_n310_281# pfet_03v3 ad=0.545p pd=3.09u as=0.53p ps=3.06u w=1u l=0.28u
X52 a_11480_63# a_10906_466# w_n310_281# w_n310_281# pfet_03v3 ad=0.65p pd=3.3u as=0.735p ps=2.47u w=1u l=0.28u
X53 a_12559_3# a_11922_3# via_dev$5$2_9/VSUBS via_dev$5$2_9/VSUBS nfet_03v3 ad=0.315p pd=2.26u as=0.325p ps=2.3u w=0.5u l=0.28u
X54 a_7083_63# m2_6151_79# w_n310_281# w_n310_281# pfet_03v3 ad=0.545p pd=3.09u as=0.53p ps=3.06u w=1u l=0.28u
X55 a_7768_n37# m2_5700_324# via_dev$5$2_9/VSUBS via_dev$5$2_9/VSUBS nfet_03v3 ad=0.3625p pd=1.725u as=0.54p ps=3.08u w=1u l=0.28u
X56 a_160_63# m2_24_342# w_n310_281# w_n310_281# pfet_03v3 ad=0.63p pd=3.26u as=0.65p ps=3.3u w=1u l=0.28u
X57 m2_1295_79# a_160_63# a_705_407# w_n310_281# pfet_03v3 ad=0.725p pd=2.725u as=0.675p ps=2.675u w=2u l=0.28u
X58 a_5042_n37# a_3940_63# a_5042_407# via_dev$5$2_9/VSUBS nfet_03v3 ad=0.3625p pd=1.725u as=0.3375p ps=1.675u w=1u l=0.28u
X59 m2_1295_79# m2_24_342# a_870_n37# via_dev$5$2_9/VSUBS nfet_03v3 ad=0.3375p pd=1.675u as=0.3625p ps=1.725u w=1u l=0.28u
X60 a_11922_3# a_2419_63# a_11922_391# w_n310_281# pfet_03v3 ad=1.3p pd=5.3u as=0.725p ps=2.725u w=2u l=0.28u
X61 a_9800_n37# a_7083_63# m2_9431_79# via_dev$5$2_9/VSUBS nfet_03v3 ad=0.3625p pd=1.725u as=0.3375p ps=1.675u w=1u l=0.28u
X62 m2_7791_79# m2_5700_324# a_8361_407# w_n310_281# pfet_03v3 ad=0.725p pd=2.725u as=1.09p ps=5.09u w=2u l=0.28u
X63 a_5042_407# a_3940_63# a_5243_407# w_n310_281# pfet_03v3 ad=0.725p pd=2.725u as=0.675p ps=2.675u w=2u l=0.28u
X64 a_3940_63# m2_1295_79# via_dev$5$2_9/VSUBS via_dev$5$2_9/VSUBS nfet_03v3 ad=0.315p pd=2.26u as=0.325p ps=2.3u w=0.5u l=0.28u
X65 a_8160_n37# a_3498_3# m2_7791_79# via_dev$5$2_9/VSUBS nfet_03v3 ad=0.3625p pd=1.725u as=0.3375p ps=1.675u w=1u l=0.28u
X66 a_705_407# m2_24_342# w_n310_281# w_n310_281# pfet_03v3 ad=0.675p pd=2.675u as=0.725p ps=2.725u w=2u l=0.28u
X67 a_5042_407# m2_1295_79# a_4650_n37# via_dev$5$2_9/VSUBS nfet_03v3 ad=0.3375p pd=1.675u as=0.3625p ps=1.725u w=1u l=0.28u
X68 a_6520_n37# a_5042_407# m2_6151_79# via_dev$5$2_9/VSUBS nfet_03v3 ad=0.3625p pd=1.725u as=0.3375p ps=1.675u w=1u l=0.28u
X69 w_n310_281# a_7083_63# a_9609_407# w_n310_281# pfet_03v3 ad=0.725p pd=2.725u as=0.675p ps=2.675u w=2u l=0.28u
X70 a_2419_63# a_1845_466# w_n310_281# w_n310_281# pfet_03v3 ad=0.65p pd=3.3u as=0.735p ps=2.47u w=1u l=0.28u
X71 m2_9431_79# a_8723_63# a_9408_n37# via_dev$5$2_9/VSUBS nfet_03v3 ad=0.3375p pd=1.675u as=0.3625p ps=1.725u w=1u l=0.28u
X72 w_n310_281# a_3498_3# a_8361_407# w_n310_281# pfet_03v3 ad=0.725p pd=2.725u as=0.675p ps=2.675u w=2u l=0.28u
X73 a_2861_391# m2_1295_79# w_n310_281# w_n310_281# pfet_03v3 ad=0.725p pd=2.725u as=1.3p ps=5.3u w=2u l=0.28u
X74 a_4290_63# a_4158_271# w_n310_281# w_n310_281# pfet_03v3 ad=0.65p pd=3.3u as=0.56p ps=3.12u w=1u l=0.28u
X75 a_5243_407# m2_1295_79# w_n310_281# w_n310_281# pfet_03v3 ad=0.675p pd=2.675u as=0.725p ps=2.725u w=2u l=0.28u
X76 w_n310_281# a_5042_407# a_6721_407# w_n310_281# pfet_03v3 ad=0.725p pd=2.725u as=0.675p ps=2.675u w=2u l=0.28u
X77 a_3498_3# a_2861_3# via_dev$5$2_9/VSUBS via_dev$5$2_9/VSUBS nfet_03v3 ad=0.315p pd=2.26u as=0.325p ps=2.3u w=0.5u l=0.28u
X78 a_9609_407# a_8723_63# m2_9431_79# w_n310_281# pfet_03v3 ad=0.675p pd=2.675u as=0.725p ps=2.725u w=2u l=0.28u
X79 via_dev$5$2_9/VSUBS a_4290_63# a_5042_n37# via_dev$5$2_9/VSUBS nfet_03v3 ad=0.65p pd=3.3u as=0.3625p ps=1.725u w=1u l=0.28u
X80 m2_6151_79# a_2419_63# a_6128_n37# via_dev$5$2_9/VSUBS nfet_03v3 ad=0.3375p pd=1.675u as=0.3625p ps=1.725u w=1u l=0.28u
X81 w_n310_281# m2_24_342# a_1845_466# w_n310_281# pfet_03v3 ad=0.735p pd=2.47u as=0.42p ps=1.84u w=1u l=0.28u
X82 a_870_n37# a_378_271# via_dev$5$2_9/VSUBS via_dev$5$2_9/VSUBS nfet_03v3 ad=0.3625p pd=1.725u as=0.54p ps=3.08u w=1u l=0.28u
X83 a_12559_3# a_11922_3# w_n310_281# w_n310_281# pfet_03v3 ad=0.65p pd=3.3u as=0.675p ps=3.35u w=1u l=0.28u
C0 m2_6151_79# w_n310_281# 0.44301f
C1 m2_7791_79# a_8160_n37# 0.01048f
C2 m2_6151_79# a_2419_63# 0.05852f
C3 m2_6151_79# m2_5700_324# 0.14941f
C4 m2_1295_79# a_3940_63# 0.46061f
C5 a_10363_63# w_n310_281# 0.15741f
C6 a_510_63# a_1845_466# 0.01433f
C7 m2_9431_79# a_7410_63# 0.00105f
C8 m2_7791_79# a_8919_367# 0.02774f
C9 a_11922_3# w_n310_281# 0.46598f
C10 a_10363_63# a_2419_63# 0.00126f
C11 m2_9431_79# w_n310_281# 0.46254f
C12 m2_1295_79# a_1845_n37# 0.00942f
C13 a_11922_3# a_2419_63# 0.16984f
C14 m2_9431_79# a_2419_63# 0.00832f
C15 a_5768_63# m2_1295_79# 0.00766f
C16 a_9609_407# a_8919_367# 0.02942f
C17 a_11922_391# w_n310_281# 0.03535f
C18 a_4158_271# a_8919_367# 0.001f
C19 a_7083_63# a_8160_n37# 0.00507f
C20 a_11922_391# a_2419_63# 0.00754f
C21 a_8361_407# a_8919_367# 0
C22 a_10906_466# w_n310_281# 0.44509f
C23 m2_7791_79# a_9050_63# 0.00127f
C24 a_7083_63# a_8919_367# 0.01057f
C25 m2_9431_79# a_9408_n37# 0.01733f
C26 a_10906_466# a_2419_63# 0.00833f
C27 a_5243_407# w_n310_281# 0.78984f
C28 a_705_407# m2_24_342# 0.10607f
C29 a_5243_407# a_2419_63# 0
C30 a_5243_407# m2_5700_324# 0.01927f
C31 a_8723_63# a_8919_367# 0.12587f
C32 a_9609_407# a_9050_63# 0.1261f
C33 a_4158_271# a_9050_63# 0.00717f
C34 a_3498_3# m2_24_342# 0
C35 a_705_407# a_1845_466# 0.0126f
C36 a_160_63# m2_24_342# 0.42316f
C37 a_8361_407# a_9050_63# 0
C38 a_7083_63# a_9050_63# 0.21474f
C39 m2_1295_79# a_7410_63# 0.07614f
C40 m2_1295_79# w_n310_281# 2.3522f
C41 a_3498_3# a_1845_466# 0.00105f
C42 a_160_63# a_1845_466# 0
C43 m2_1295_79# a_2419_63# 0.32461f
C44 m2_1295_79# m2_5700_324# 0.07849f
C45 a_4650_n37# a_4290_63# 0.01502f
C46 a_8723_63# a_9050_63# 0.53121f
C47 m2_9431_79# a_9800_n37# 0.0074f
C48 m2_6151_79# a_4290_63# 0
C49 a_705_407# a_2861_3# 0
C50 a_3940_63# a_1845_466# 0
C51 a_7768_n37# a_7410_63# 0.00935f
C52 m2_1295_79# a_378_271# 0.02669f
C53 a_3498_3# a_2861_3# 0.09846f
C54 a_1845_n37# a_1845_466# 0.01333f
C55 a_10363_63# a_10906_n37# 0
C56 m2_1295_79# a_2861_391# 0.00841f
C57 a_5042_n37# a_4290_63# 0.00898f
C58 a_5042_407# a_2861_3# 0
C59 a_5243_407# a_4290_63# 0.14023f
C60 a_10906_466# a_10906_n37# 0.01333f
C61 a_9609_407# m2_7791_79# 0
C62 a_3940_63# a_2861_3# 0
C63 a_8160_n37# a_7410_63# 0.01329f
C64 m2_7791_79# a_4158_271# 0
C65 w_n310_281# m2_24_342# 0.66878f
C66 a_8361_407# m2_7791_79# 0.49779f
C67 a_7410_63# a_8919_367# 0
C68 m2_24_342# a_2419_63# 0.00234f
C69 m2_7791_79# a_7083_63# 0.14708f
C70 a_9609_407# a_4158_271# 0
C71 w_n310_281# a_8919_367# 0.49838f
C72 m2_1295_79# a_4290_63# 0.13519f
C73 a_8919_367# a_2419_63# 0.01445f
C74 a_705_407# a_510_63# 0.13828f
C75 a_10363_63# m2_9431_79# 0.07766f
C76 a_11480_63# a_9609_407# 0
C77 w_n310_281# a_1845_466# 0.44517f
C78 m2_5700_324# a_8919_367# 0
C79 a_8361_407# a_9609_407# 0.00466f
C80 m2_6151_79# a_5042_n37# 0
C81 a_11480_63# a_4158_271# 0.00295f
C82 m2_7791_79# a_8723_63# 0.08396f
C83 a_9609_407# a_7083_63# 0.0285f
C84 a_2419_63# a_1845_466# 0.10509f
C85 a_7083_63# a_4158_271# 1.09133f
C86 a_160_63# a_510_63# 0.28903f
C87 a_11922_391# a_11922_3# 0.01891f
C88 a_8361_407# a_7083_63# 0.01453f
C89 a_9609_407# a_8723_63# 0.0593f
C90 m2_7791_79# a_3498_3# 0.0296f
C91 a_8723_63# a_4158_271# 0
C92 w_n310_281# a_9050_63# 0.28931f
C93 a_10363_63# a_10906_466# 0.02047f
C94 a_9050_63# a_2419_63# 0.00801f
C95 a_10906_466# a_11922_3# 0
C96 a_378_271# m2_24_342# 0.56715f
C97 a_10906_466# m2_9431_79# 0.00167f
C98 a_8361_407# a_8723_63# 0.01268f
C99 a_8723_63# a_7083_63# 0.15796f
C100 a_4158_271# a_3498_3# 0.00829f
C101 m2_7791_79# a_5042_407# 0.00555f
C102 a_378_271# a_1845_466# 0.01278f
C103 w_n310_281# a_2861_3# 0.4655f
C104 a_8361_407# a_3498_3# 0.12093f
C105 a_2419_63# a_2861_3# 0.21478f
C106 m2_6151_79# m2_1295_79# 0.00667f
C107 a_7083_63# a_3498_3# 0.01356f
C108 a_5042_n37# a_5243_407# 0
C109 a_9408_n37# a_9050_63# 0.00935f
C110 a_1845_n37# a_510_63# 0.0011f
C111 a_4158_271# a_5042_407# 0.63867f
C112 a_7083_63# a_6721_407# 0.01268f
C113 a_10363_63# m2_1295_79# 0.00179f
C114 a_8723_63# a_3498_3# 0.00575f
C115 a_11922_3# m2_1295_79# 0
C116 m2_9431_79# m2_1295_79# 0.0078f
C117 a_705_407# a_160_63# 0.06737f
C118 m2_7791_79# a_5768_63# 0
C119 a_4158_271# a_3940_63# 0.16366f
C120 a_7083_63# a_5042_407# 0.02611f
C121 a_4158_271# a_6520_n37# 0.00406f
C122 m2_1295_79# a_870_n37# 0.00639f
C123 a_3498_3# a_6721_407# 0
C124 a_6128_n37# a_6721_407# 0
C125 a_4158_271# a_5768_63# 0.00573f
C126 a_10906_466# m2_1295_79# 0.0692f
C127 a_2861_391# a_2861_3# 0.01616f
C128 a_7083_63# a_6520_n37# 0.00272f
C129 a_9800_n37# a_9050_63# 0.01329f
C130 a_3498_3# a_5042_407# 0.02015f
C131 a_5243_407# m2_1295_79# 0.10989f
C132 a_6128_n37# a_5042_407# 0.00376f
C133 a_7083_63# a_5768_63# 0.01494f
C134 a_5042_407# a_6721_407# 0.03265f
C135 m2_9431_79# a_7768_n37# 0
C136 a_3498_3# a_3940_63# 0.04602f
C137 w_n310_281# a_510_63# 0.28255f
C138 m2_7791_79# a_7410_63# 0.36168f
C139 m2_7791_79# w_n310_281# 0.45139f
C140 m2_1295_79# a_1262_n37# 0.01607f
C141 a_5768_63# a_3498_3# 0
C142 m2_7791_79# a_2419_63# 0.00843f
C143 a_6128_n37# a_5768_63# 0.00935f
C144 m2_7791_79# m2_5700_324# 0.05245f
C145 a_3940_63# a_5042_407# 0.0941f
C146 a_5768_63# a_6721_407# 0.14017f
C147 a_9609_407# w_n310_281# 0.7653f
C148 a_4158_271# a_7410_63# 0
C149 a_4158_271# w_n310_281# 0.66883f
C150 a_9609_407# a_2419_63# 0
C151 a_4290_63# a_2861_3# 0
C152 a_6520_n37# a_5042_407# 0.00483f
C153 a_4158_271# a_2419_63# 0.14782f
C154 a_8361_407# a_7410_63# 0.1423f
C155 a_4158_271# m2_5700_324# 0.00861f
C156 a_11480_63# w_n310_281# 0.37298f
C157 a_5768_63# a_5042_407# 0.22596f
C158 a_8361_407# w_n310_281# 0.75753f
C159 a_7083_63# a_7410_63# 0.07718f
C160 m2_7791_79# a_9408_n37# 0
C161 m2_9431_79# a_8160_n37# 0
C162 a_11480_63# a_2419_63# 0.0769f
C163 a_7083_63# w_n310_281# 0.31663f
C164 a_8361_407# a_2419_63# 0
C165 a_8361_407# m2_5700_324# 0.05956f
C166 a_378_271# a_510_63# 0.14298f
C167 a_7083_63# a_2419_63# 0.01345f
C168 a_10363_63# a_8919_367# 0
C169 a_7083_63# m2_5700_324# 0.12051f
C170 a_5768_63# a_3940_63# 0
C171 a_8723_63# a_7410_63# 0.01398f
C172 m2_9431_79# a_8919_367# 0.03216f
C173 a_9609_407# a_9408_n37# 0
C174 a_12559_3# w_n310_281# 0.08598f
C175 a_8723_63# w_n310_281# 0.33584f
C176 a_705_407# w_n310_281# 0.79414f
C177 a_12559_3# a_2419_63# 0
C178 a_8723_63# a_2419_63# 0.00661f
C179 a_6520_n37# a_5768_63# 0.01329f
C180 a_705_407# a_2419_63# 0
C181 a_8723_63# m2_5700_324# 0
C182 a_3498_3# a_7410_63# 0.11774f
C183 a_3498_3# w_n310_281# 1.03377f
C184 a_7083_63# a_9408_n37# 0.00336f
C185 a_160_63# w_n310_281# 0.30515f
C186 a_3498_3# a_2419_63# 0.01177f
C187 a_870_n37# a_1845_466# 0
C188 a_3498_3# m2_5700_324# 0.55174f
C189 a_10363_63# a_9050_63# 0.01385f
C190 a_6721_407# w_n310_281# 0.72579f
C191 m2_9431_79# a_9050_63# 0.328f
C192 a_6721_407# a_2419_63# 0.01825f
C193 a_6721_407# m2_5700_324# 0.50857f
C194 a_5042_407# a_7410_63# 0
C195 a_5042_407# w_n310_281# 0.29911f
C196 a_5042_407# a_2419_63# 0.08051f
C197 a_5042_407# m2_5700_324# 0.06917f
C198 a_705_407# a_378_271# 0.02817f
C199 a_4158_271# a_9800_n37# 0.00497f
C200 a_705_407# a_2861_391# 0
C201 a_3940_63# w_n310_281# 0.30087f
C202 m2_1295_79# m2_24_342# 0.04399f
C203 a_3940_63# a_2419_63# 0.00879f
C204 a_3940_63# m2_5700_324# 0.00132f
C205 w_n310_281# a_1845_n37# 0
C206 a_7083_63# a_9800_n37# 0.00527f
C207 m2_1295_79# a_8919_367# 0.01372f
C208 a_160_63# a_378_271# 0.09182f
C209 a_3498_3# a_2861_391# 0.00454f
C210 a_1262_n37# a_1845_466# 0
C211 a_5768_63# w_n310_281# 0.31314f
C212 m2_1295_79# a_1845_466# 0.09644f
C213 a_5768_63# a_2419_63# 0.07749f
C214 a_4158_271# a_4290_63# 0.11363f
C215 a_5768_63# m2_5700_324# 0.16447f
C216 a_5243_407# a_2861_3# 0
C217 a_4158_271# a_10906_n37# 0.00824f
C218 m2_1295_79# a_9050_63# 0.00716f
C219 m2_6151_79# m2_7791_79# 0.00114f
C220 m2_1295_79# a_2861_3# 0.15381f
C221 a_3498_3# a_4290_63# 0.00876f
C222 w_n310_281# a_7410_63# 0.31086f
C223 a_4158_271# a_4650_n37# 0.00383f
C224 a_7410_63# a_2419_63# 0.00801f
C225 m2_5700_324# a_7410_63# 0.14432f
C226 w_n310_281# a_2419_63# 0.75129f
C227 w_n310_281# m2_5700_324# 1.65678f
C228 m2_6151_79# a_4158_271# 0.04334f
C229 m2_7791_79# m2_9431_79# 0.01571f
C230 m2_5700_324# a_2419_63# 0.074f
C231 a_870_n37# a_510_63# 0.01502f
C232 a_5042_407# a_4290_63# 0.38112f
C233 a_10363_63# a_9609_407# 0.01306f
C234 a_10363_63# a_4158_271# 0.02222f
C235 m2_6151_79# a_7083_63# 0.08089f
C236 a_9609_407# m2_9431_79# 0.49779f
C237 a_11922_3# a_4158_271# 0.0013f
C238 m2_9431_79# a_4158_271# 0.05572f
C239 a_10363_63# a_11480_63# 0
C240 a_3940_63# a_4290_63# 0.28903f
C241 a_11480_63# a_11922_3# 0.04054f
C242 a_11480_63# m2_9431_79# 0
C243 a_10363_63# a_7083_63# 0.00582f
C244 a_8361_407# m2_9431_79# 0
C245 m2_24_342# a_1845_466# 0.06999f
C246 m2_9431_79# a_7083_63# 0.19293f
C247 a_4158_271# a_5042_n37# 0
C248 w_n310_281# a_378_271# 0.6337f
C249 a_5768_63# a_4290_63# 0.01093f
C250 a_11480_63# a_11922_391# 0.00152f
C251 a_10363_63# a_8723_63# 0
C252 a_10906_466# a_9609_407# 0
C253 w_n310_281# a_2861_391# 0.03535f
C254 m2_6151_79# a_3498_3# 0
C255 a_11922_3# a_12559_3# 0.0899f
C256 m2_6151_79# a_6128_n37# 0.01733f
C257 a_10906_466# a_4158_271# 0.03873f
C258 m2_9431_79# a_8723_63# 0.13485f
C259 a_2419_63# a_2861_391# 0.0163f
C260 a_4158_271# a_5243_407# 0.02964f
C261 m2_6151_79# a_6721_407# 0.4935f
C262 a_1262_n37# a_510_63# 0.00898f
C263 a_11480_63# a_10906_466# 0.1131f
C264 a_4650_n37# a_5042_407# 0.00712f
C265 m2_1295_79# a_510_63# 0.39896f
C266 a_10906_466# a_7083_63# 0
C267 m2_9431_79# a_3498_3# 0
C268 a_8919_367# a_9050_63# 0.10006f
C269 m2_6151_79# a_5042_407# 0.20459f
C270 m2_7791_79# m2_1295_79# 0.05731f
C271 a_4650_n37# a_3940_63# 0.00441f
C272 a_10906_466# a_12559_3# 0
C273 a_9609_407# m2_1295_79# 0.0093f
C274 a_160_63# a_870_n37# 0.00441f
C275 a_4158_271# m2_1295_79# 0.16058f
C276 m2_6151_79# a_6520_n37# 0.00766f
C277 a_11480_63# m2_1295_79# 0.00126f
C278 a_1845_466# a_2861_3# 0
C279 a_8361_407# m2_1295_79# 0.02509f
C280 w_n310_281# a_4290_63# 0.2819f
C281 a_3498_3# a_5243_407# 0.16427f
C282 m2_6151_79# a_5768_63# 0.35511f
C283 a_7083_63# m2_1295_79# 0.01071f
C284 a_4290_63# a_2419_63# 0.00652f
C285 a_5042_n37# a_5042_407# 0.01726f
C286 m2_5700_324# a_4290_63# 0.01531f
C287 m2_7791_79# a_7768_n37# 0.01733f
C288 a_705_407# a_1262_n37# 0
C289 a_8723_63# m2_1295_79# 0.00803f
C290 a_10906_n37# w_n310_281# 0
C291 a_705_407# m2_1295_79# 0.30816f
C292 a_5243_407# a_5042_407# 0.29512f
C293 a_3498_3# m2_1295_79# 0.3391f
C294 a_160_63# m2_1295_79# 0.09339f
C295 a_5243_407# a_3940_63# 0.06737f
C296 m2_1295_79# a_6721_407# 0.00452f
C297 a_8361_407# a_7768_n37# 0
C298 a_7083_63# a_7768_n37# 0.0028f
C299 a_5768_63# a_5243_407# 0.00722f
C300 m2_6151_79# a_7410_63# 0
C301 m2_1295_79# a_5042_407# 0.03487f
C302 m2_24_342# a_510_63# 0.13025f
C303 a_4158_271# via_dev$5$2_9/VSUBS 2.63898f
C304 a_7083_63# via_dev$5$2_9/VSUBS 0.86585f
C305 a_8723_63# via_dev$5$2_9/VSUBS 0.41121f
C306 m2_9431_79# via_dev$5$2_9/VSUBS 0.75255f
C307 m2_7791_79# via_dev$5$2_9/VSUBS 0.74612f
C308 a_9609_407# via_dev$5$2_9/VSUBS 0.11967f
C309 a_8361_407# via_dev$5$2_9/VSUBS 0.05216f
C310 m2_6151_79# via_dev$5$2_9/VSUBS 0.72815f
C311 a_6721_407# via_dev$5$2_9/VSUBS 0.01698f
C312 a_5042_407# via_dev$5$2_9/VSUBS 0.88916f
C313 a_3940_63# via_dev$5$2_9/VSUBS 0.46864f
C314 m2_1295_79# via_dev$5$2_9/VSUBS 3.37184f
C315 a_160_63# via_dev$5$2_9/VSUBS 0.5921f
C316 a_5243_407# via_dev$5$2_9/VSUBS 0.01661f
C317 a_705_407# via_dev$5$2_9/VSUBS 0.13677f
C318 a_3498_3# via_dev$5$2_9/VSUBS 1.27724f
C319 a_10906_n37# via_dev$5$2_9/VSUBS 0.02232f
C320 a_9800_n37# via_dev$5$2_9/VSUBS 0.01742f
C321 a_9408_n37# via_dev$5$2_9/VSUBS 0.007f
C322 a_8160_n37# via_dev$5$2_9/VSUBS 0.01743f
C323 a_7768_n37# via_dev$5$2_9/VSUBS 0.007f
C324 a_6520_n37# via_dev$5$2_9/VSUBS 0.01743f
C325 a_6128_n37# via_dev$5$2_9/VSUBS 0.007f
C326 a_5042_n37# via_dev$5$2_9/VSUBS 0.00833f
C327 a_4650_n37# via_dev$5$2_9/VSUBS 0.01565f
C328 a_12559_3# via_dev$5$2_9/VSUBS 0.19481f
C329 a_11922_3# via_dev$5$2_9/VSUBS 0.64569f
C330 a_11922_391# via_dev$5$2_9/VSUBS 0.00119f
C331 a_10906_466# via_dev$5$2_9/VSUBS 0.59796f
C332 a_11480_63# via_dev$5$2_9/VSUBS 0.42359f
C333 a_10363_63# via_dev$5$2_9/VSUBS 0.13924f
C334 a_9050_63# via_dev$5$2_9/VSUBS 0.53264f
C335 a_8919_367# via_dev$5$2_9/VSUBS 0.51866f
C336 a_7410_63# via_dev$5$2_9/VSUBS 0.53731f
C337 a_5768_63# via_dev$5$2_9/VSUBS 0.54f
C338 a_1845_n37# via_dev$5$2_9/VSUBS 0.01974f
C339 a_1262_n37# via_dev$5$2_9/VSUBS 0.0069f
C340 a_870_n37# via_dev$5$2_9/VSUBS 0.01517f
C341 a_4290_63# via_dev$5$2_9/VSUBS 0.57048f
C342 a_2861_3# via_dev$5$2_9/VSUBS 0.62907f
C343 a_1845_466# via_dev$5$2_9/VSUBS 0.59853f
C344 a_2419_63# via_dev$5$2_9/VSUBS 6.64114f
C345 a_510_63# via_dev$5$2_9/VSUBS 0.55998f
C346 a_378_271# via_dev$5$2_9/VSUBS 1.37769f
C347 w_n310_281# via_dev$5$2_9/VSUBS 27.01716f
C348 m2_24_342# via_dev$5$2_9/VSUBS 1.98211f
C349 m2_5700_324# via_dev$5$2_9/VSUBS 1.14834f
.ends

.subckt AND4 w_237_91# a_992_79# a_372_n441# a_1200_79# a_1686_n317# a_784_79# a_704_n441#
+ a_576_79# a_912_n441# a_518_229# a_1120_n441#
X0 w_237_91# a_992_79# a_518_229# w_237_91# pfet_03v3 ad=0.38p pd=1.76u as=0.38p ps=1.76u w=1u l=0.28u
X1 a_518_229# a_784_79# w_237_91# w_237_91# pfet_03v3 ad=0.38p pd=1.76u as=0.38p ps=1.76u w=1u l=0.28u
X2 a_1686_n317# a_518_229# w_237_91# w_237_91# pfet_03v3 ad=0.65p pd=3.3u as=0.65p ps=3.3u w=1u l=0.28u
X3 a_912_n441# a_784_79# a_704_n441# a_372_n441# nfet_03v3 ad=0.76p pd=2.76u as=0.76p ps=2.76u w=2u l=0.28u
X4 w_237_91# a_576_79# a_518_229# w_237_91# pfet_03v3 ad=0.38p pd=1.76u as=0.65p ps=3.3u w=1u l=0.28u
X5 a_704_n441# a_576_79# a_372_n441# a_372_n441# nfet_03v3 ad=0.76p pd=2.76u as=1.34p ps=5.34u w=2u l=0.28u
X6 a_518_229# a_1200_79# a_1120_n441# a_372_n441# nfet_03v3 ad=1.14p pd=5.14u as=0.76p ps=2.76u w=2u l=0.28u
X7 a_1686_n317# a_518_229# a_372_n441# a_372_n441# nfet_03v3 ad=0.315p pd=2.26u as=0.295p ps=2.18u w=0.5u l=0.28u
X8 a_518_229# a_1200_79# w_237_91# w_237_91# pfet_03v3 ad=0.55p pd=3.1u as=0.38p ps=1.76u w=1u l=0.28u
X9 a_1120_n441# a_992_79# a_912_n441# a_372_n441# nfet_03v3 ad=0.76p pd=2.76u as=0.76p ps=2.76u w=2u l=0.28u
C0 a_518_229# a_1686_n317# 0.12995f
C1 w_237_91# a_576_79# 0.16514f
C2 w_237_91# a_1686_n317# 0.1612f
C3 a_912_n441# a_992_79# 0.00663f
C4 a_784_79# a_704_n441# 0.00663f
C5 a_1200_79# a_518_229# 0.20239f
C6 w_237_91# a_518_229# 1.12672f
C7 a_1200_79# w_237_91# 0.15686f
C8 a_784_79# a_992_79# 0.06396f
C9 a_518_229# a_704_n441# 0.01032f
C10 a_518_229# a_992_79# 0.12168f
C11 a_1200_79# a_992_79# 0.06396f
C12 a_912_n441# a_518_229# 0.01471f
C13 w_237_91# a_992_79# 0.1469f
C14 a_1120_n441# a_518_229# 0.02253f
C15 a_784_79# a_576_79# 0.06396f
C16 a_1200_79# a_1120_n441# 0.00663f
C17 a_784_79# a_518_229# 0.11673f
C18 w_237_91# a_784_79# 0.14715f
C19 a_518_229# a_576_79# 0.11544f
C20 a_1120_n441# a_372_n441# 0.02626f
C21 a_912_n441# a_372_n441# 0.02949f
C22 a_704_n441# a_372_n441# 0.03642f
C23 a_1686_n317# a_372_n441# 0.20646f
C24 a_518_229# a_372_n441# 0.81795f
C25 a_1200_79# a_372_n441# 0.2334f
C26 a_992_79# a_372_n441# 0.22559f
C27 a_784_79# a_372_n441# 0.22803f
C28 a_576_79# a_372_n441# 0.27946f
C29 w_237_91# a_372_n441# 2.88366f
.ends

.subckt x1bitblock$3 a_2861_3# a_8361_407# a_6520_n37# a_1262_n37# a_2861_391# a_1845_466#
+ a_10906_n37# a_510_63# a_870_n37# a_9800_n37# a_11480_63# a_6128_n37# a_5768_63#
+ m2_6151_79# a_11922_391# a_5042_n37# a_9408_n37# a_9609_407# a_5042_407# a_8160_n37#
+ a_4158_271# a_11922_3# a_8918_358# a_2419_63# m2_9431_79# a_10906_466# a_4650_n37#
+ a_9050_63# a_7768_n37# a_3940_63# m2_7791_79# a_10363_63# a_160_63# a_4290_63# a_7083_63#
+ a_705_407# a_12559_3# a_7410_63# m2_5700_324# a_1845_n37# via_dev$5$3_9/VSUBS a_3498_3#
+ m2_1295_79# a_8723_63# a_378_271# w_n310_281# m2_24_342#
X0 a_2419_63# a_1845_466# via_dev$5$3_9/VSUBS via_dev$5$3_9/VSUBS nfet_03v3 ad=0.315p pd=2.26u as=0.2425p ps=1.97u w=0.5u l=0.28u
X1 a_1845_466# m2_24_342# a_1845_n37# via_dev$5$3_9/VSUBS nfet_03v3 ad=0.65p pd=3.3u as=0.42p ps=1.84u w=1u l=0.28u
X2 a_3940_63# m2_1295_79# w_n310_281# w_n310_281# pfet_03v3 ad=0.63p pd=3.26u as=0.65p ps=3.3u w=1u l=0.28u
X3 via_dev$5$3_9/VSUBS a_510_63# a_1262_n37# via_dev$5$3_9/VSUBS nfet_03v3 ad=0.65p pd=3.3u as=0.3625p ps=1.725u w=1u l=0.28u
X4 a_5243_407# a_4290_63# a_5042_407# w_n310_281# pfet_03v3 ad=1.3p pd=5.3u as=0.725p ps=2.725u w=2u l=0.28u
X5 a_6721_407# a_2419_63# m2_6151_79# w_n310_281# pfet_03v3 ad=0.675p pd=2.675u as=0.725p ps=2.725u w=2u l=0.28u
X6 a_10906_466# a_4158_271# w_n310_281# w_n310_281# pfet_03v3 ad=0.42p pd=1.84u as=0.65p ps=3.3u w=1u l=0.28u
X7 a_4290_63# a_4158_271# via_dev$5$3_9/VSUBS via_dev$5$3_9/VSUBS nfet_03v3 ad=0.315p pd=2.26u as=0.28p ps=2.12u w=0.5u l=0.28u
X8 w_n310_281# a_378_271# a_705_407# w_n310_281# pfet_03v3 ad=0.725p pd=2.725u as=1.09p ps=5.09u w=2u l=0.28u
X9 a_2861_3# m2_1295_79# via_dev$5$3_9/VSUBS via_dev$5$3_9/VSUBS nfet_03v3 ad=0.18125p pd=1.225u as=0.325p ps=2.3u w=0.5u l=0.28u
X10 via_dev$5$3_9/VSUBS a_2419_63# a_2861_3# via_dev$5$3_9/VSUBS nfet_03v3 ad=0.315p pd=2.26u as=0.18125p ps=1.225u w=0.5u l=0.28u
X11 m2_7791_79# m2_1295_79# a_7768_n37# via_dev$5$3_9/VSUBS nfet_03v3 ad=0.3375p pd=1.675u as=0.3625p ps=1.725u w=1u l=0.28u
X12 a_10906_n37# a_4158_271# via_dev$5$3_9/VSUBS via_dev$5$3_9/VSUBS nfet_03v3 ad=0.42p pd=1.84u as=0.63p ps=3.26u w=1u l=0.28u
X13 a_9050_63# a_8918_358# via_dev$5$3_9/VSUBS via_dev$5$3_9/VSUBS nfet_03v3 ad=0.31p pd=2.24u as=0.24p ps=1.96u w=0.5u l=0.28u
X14 a_11922_3# a_11480_63# via_dev$5$3_9/VSUBS via_dev$5$3_9/VSUBS nfet_03v3 ad=0.18125p pd=1.225u as=0.325p ps=2.3u w=0.5u l=0.28u
X15 via_dev$5$3_9/VSUBS a_2419_63# a_11922_3# via_dev$5$3_9/VSUBS nfet_03v3 ad=0.315p pd=2.26u as=0.18125p ps=1.225u w=0.5u l=0.28u
X16 a_705_407# a_510_63# m2_1295_79# w_n310_281# pfet_03v3 ad=1.3p pd=5.3u as=0.725p ps=2.725u w=2u l=0.28u
X17 a_4650_n37# a_4158_271# via_dev$5$3_9/VSUBS via_dev$5$3_9/VSUBS nfet_03v3 ad=0.3625p pd=1.725u as=0.54p ps=3.08u w=1u l=0.28u
X18 a_2861_3# a_2419_63# a_2861_391# w_n310_281# pfet_03v3 ad=1.3p pd=5.3u as=0.725p ps=2.725u w=2u l=0.28u
X19 a_5768_63# m2_5700_324# via_dev$5$3_9/VSUBS via_dev$5$3_9/VSUBS nfet_03v3 ad=0.315p pd=2.26u as=0.3175p ps=2.27u w=0.5u l=0.28u
X20 via_dev$5$3_9/VSUBS a_9050_63# a_9800_n37# via_dev$5$3_9/VSUBS nfet_03v3 ad=0.65p pd=3.3u as=0.3625p ps=1.725u w=1u l=0.28u
X21 a_8361_407# m2_1295_79# m2_7791_79# w_n310_281# pfet_03v3 ad=0.675p pd=2.675u as=0.725p ps=2.725u w=2u l=0.28u
X22 a_9408_n37# a_8918_358# via_dev$5$3_9/VSUBS via_dev$5$3_9/VSUBS nfet_03v3 ad=0.3625p pd=1.725u as=0.54p ps=3.08u w=1u l=0.28u
X23 a_3498_3# a_2861_3# w_n310_281# w_n310_281# pfet_03v3 ad=0.65p pd=3.3u as=0.675p ps=3.35u w=1u l=0.28u
X24 a_7410_63# m2_5700_324# via_dev$5$3_9/VSUBS via_dev$5$3_9/VSUBS nfet_03v3 ad=0.31p pd=2.24u as=0.24p ps=1.96u w=0.5u l=0.28u
X25 via_dev$5$3_9/VSUBS a_7410_63# a_8160_n37# via_dev$5$3_9/VSUBS nfet_03v3 ad=0.65p pd=3.3u as=0.3625p ps=1.725u w=1u l=0.28u
X26 a_8723_63# m2_7791_79# via_dev$5$3_9/VSUBS via_dev$5$3_9/VSUBS nfet_03v3 ad=0.2625p pd=2.05u as=0.265p ps=2.06u w=0.5u l=0.28u
X27 w_n310_281# a_4158_271# a_5243_407# w_n310_281# pfet_03v3 ad=0.725p pd=2.725u as=1.09p ps=5.09u w=2u l=0.28u
X28 a_5768_63# m2_5700_324# w_n310_281# w_n310_281# pfet_03v3 ad=0.65p pd=3.3u as=0.635p ps=3.27u w=1u l=0.28u
X29 a_9050_63# a_8918_358# w_n310_281# w_n310_281# pfet_03v3 ad=0.64p pd=3.28u as=0.48p ps=2.96u w=1u l=0.28u
X30 a_11922_391# a_11480_63# w_n310_281# w_n310_281# pfet_03v3 ad=0.725p pd=2.725u as=1.3p ps=5.3u w=2u l=0.28u
X31 a_160_63# m2_24_342# via_dev$5$3_9/VSUBS via_dev$5$3_9/VSUBS nfet_03v3 ad=0.315p pd=2.26u as=0.325p ps=2.3u w=0.5u l=0.28u
X32 a_9609_407# a_9050_63# w_n310_281# w_n310_281# pfet_03v3 ad=1.3p pd=5.3u as=0.725p ps=2.725u w=2u l=0.28u
X33 a_6128_n37# m2_5700_324# via_dev$5$3_9/VSUBS via_dev$5$3_9/VSUBS nfet_03v3 ad=0.3625p pd=1.725u as=0.54p ps=3.08u w=1u l=0.28u
X34 via_dev$5$3_9/VSUBS a_5768_63# a_6520_n37# via_dev$5$3_9/VSUBS nfet_03v3 ad=0.65p pd=3.3u as=0.3625p ps=1.725u w=1u l=0.28u
X35 a_7410_63# m2_5700_324# w_n310_281# w_n310_281# pfet_03v3 ad=0.64p pd=3.28u as=0.48p ps=2.96u w=1u l=0.28u
X36 m2_9431_79# a_8918_358# a_9609_407# w_n310_281# pfet_03v3 ad=0.725p pd=2.725u as=1.09p ps=5.09u w=2u l=0.28u
X37 a_11480_63# a_10906_466# via_dev$5$3_9/VSUBS via_dev$5$3_9/VSUBS nfet_03v3 ad=0.315p pd=2.26u as=0.2425p ps=1.97u w=0.5u l=0.28u
X38 a_1845_466# a_378_271# w_n310_281# w_n310_281# pfet_03v3 ad=0.42p pd=1.84u as=0.65p ps=3.3u w=1u l=0.28u
X39 a_8361_407# a_7410_63# w_n310_281# w_n310_281# pfet_03v3 ad=1.3p pd=5.3u as=0.725p ps=2.725u w=2u l=0.28u
X40 w_n310_281# m2_1295_79# a_10906_466# w_n310_281# pfet_03v3 ad=0.735p pd=2.47u as=0.42p ps=1.84u w=1u l=0.28u
X41 a_7083_63# m2_6151_79# via_dev$5$3_9/VSUBS via_dev$5$3_9/VSUBS nfet_03v3 ad=0.2625p pd=2.05u as=0.265p ps=2.06u w=0.5u l=0.28u
X42 a_510_63# a_378_271# w_n310_281# w_n310_281# pfet_03v3 ad=0.65p pd=3.3u as=0.56p ps=3.12u w=1u l=0.28u
X43 a_10363_63# m2_9431_79# w_n310_281# w_n310_281# pfet_03v3 ad=0.715p pd=3.43u as=0.53p ps=3.06u w=1u l=0.28u
X44 a_510_63# a_378_271# via_dev$5$3_9/VSUBS via_dev$5$3_9/VSUBS nfet_03v3 ad=0.315p pd=2.26u as=0.28p ps=2.12u w=0.5u l=0.28u
X45 a_1262_n37# a_160_63# m2_1295_79# via_dev$5$3_9/VSUBS nfet_03v3 ad=0.3625p pd=1.725u as=0.3375p ps=1.675u w=1u l=0.28u
X46 a_1845_n37# a_378_271# via_dev$5$3_9/VSUBS via_dev$5$3_9/VSUBS nfet_03v3 ad=0.42p pd=1.84u as=0.63p ps=3.26u w=1u l=0.28u
X47 m2_6151_79# m2_5700_324# a_6721_407# w_n310_281# pfet_03v3 ad=0.725p pd=2.725u as=1.09p ps=5.09u w=2u l=0.28u
X48 a_6721_407# a_5768_63# w_n310_281# w_n310_281# pfet_03v3 ad=1.3p pd=5.3u as=0.725p ps=2.725u w=2u l=0.28u
X49 a_10363_63# m2_9431_79# via_dev$5$3_9/VSUBS via_dev$5$3_9/VSUBS nfet_03v3 ad=0.3575p pd=2.43u as=0.265p ps=2.06u w=0.5u l=0.28u
X50 a_10906_466# m2_1295_79# a_10906_n37# via_dev$5$3_9/VSUBS nfet_03v3 ad=0.65p pd=3.3u as=0.42p ps=1.84u w=1u l=0.28u
X51 a_8723_63# m2_7791_79# w_n310_281# w_n310_281# pfet_03v3 ad=0.545p pd=3.09u as=0.53p ps=3.06u w=1u l=0.28u
X52 a_11480_63# a_10906_466# w_n310_281# w_n310_281# pfet_03v3 ad=0.65p pd=3.3u as=0.735p ps=2.47u w=1u l=0.28u
X53 a_12559_3# a_11922_3# via_dev$5$3_9/VSUBS via_dev$5$3_9/VSUBS nfet_03v3 ad=0.315p pd=2.26u as=0.325p ps=2.3u w=0.5u l=0.28u
X54 a_7083_63# m2_6151_79# w_n310_281# w_n310_281# pfet_03v3 ad=0.545p pd=3.09u as=0.53p ps=3.06u w=1u l=0.28u
X55 a_7768_n37# m2_5700_324# via_dev$5$3_9/VSUBS via_dev$5$3_9/VSUBS nfet_03v3 ad=0.3625p pd=1.725u as=0.54p ps=3.08u w=1u l=0.28u
X56 a_160_63# m2_24_342# w_n310_281# w_n310_281# pfet_03v3 ad=0.63p pd=3.26u as=0.65p ps=3.3u w=1u l=0.28u
X57 m2_1295_79# a_160_63# a_705_407# w_n310_281# pfet_03v3 ad=0.725p pd=2.725u as=0.675p ps=2.675u w=2u l=0.28u
X58 a_5042_n37# a_3940_63# a_5042_407# via_dev$5$3_9/VSUBS nfet_03v3 ad=0.3625p pd=1.725u as=0.3375p ps=1.675u w=1u l=0.28u
X59 m2_1295_79# m2_24_342# a_870_n37# via_dev$5$3_9/VSUBS nfet_03v3 ad=0.3375p pd=1.675u as=0.3625p ps=1.725u w=1u l=0.28u
X60 a_11922_3# a_2419_63# a_11922_391# w_n310_281# pfet_03v3 ad=1.3p pd=5.3u as=0.725p ps=2.725u w=2u l=0.28u
X61 a_9800_n37# a_7083_63# m2_9431_79# via_dev$5$3_9/VSUBS nfet_03v3 ad=0.3625p pd=1.725u as=0.3375p ps=1.675u w=1u l=0.28u
X62 m2_7791_79# m2_5700_324# a_8361_407# w_n310_281# pfet_03v3 ad=0.725p pd=2.725u as=1.09p ps=5.09u w=2u l=0.28u
X63 a_5042_407# a_3940_63# a_5243_407# w_n310_281# pfet_03v3 ad=0.725p pd=2.725u as=0.675p ps=2.675u w=2u l=0.28u
X64 a_3940_63# m2_1295_79# via_dev$5$3_9/VSUBS via_dev$5$3_9/VSUBS nfet_03v3 ad=0.315p pd=2.26u as=0.325p ps=2.3u w=0.5u l=0.28u
X65 a_8160_n37# a_3498_3# m2_7791_79# via_dev$5$3_9/VSUBS nfet_03v3 ad=0.3625p pd=1.725u as=0.3375p ps=1.675u w=1u l=0.28u
X66 a_705_407# m2_24_342# w_n310_281# w_n310_281# pfet_03v3 ad=0.675p pd=2.675u as=0.725p ps=2.725u w=2u l=0.28u
X67 a_5042_407# m2_1295_79# a_4650_n37# via_dev$5$3_9/VSUBS nfet_03v3 ad=0.3375p pd=1.675u as=0.3625p ps=1.725u w=1u l=0.28u
X68 a_6520_n37# a_5042_407# m2_6151_79# via_dev$5$3_9/VSUBS nfet_03v3 ad=0.3625p pd=1.725u as=0.3375p ps=1.675u w=1u l=0.28u
X69 w_n310_281# a_7083_63# a_9609_407# w_n310_281# pfet_03v3 ad=0.725p pd=2.725u as=0.675p ps=2.675u w=2u l=0.28u
X70 a_2419_63# a_1845_466# w_n310_281# w_n310_281# pfet_03v3 ad=0.65p pd=3.3u as=0.735p ps=2.47u w=1u l=0.28u
X71 m2_9431_79# a_8723_63# a_9408_n37# via_dev$5$3_9/VSUBS nfet_03v3 ad=0.3375p pd=1.675u as=0.3625p ps=1.725u w=1u l=0.28u
X72 w_n310_281# a_3498_3# a_8361_407# w_n310_281# pfet_03v3 ad=0.725p pd=2.725u as=0.675p ps=2.675u w=2u l=0.28u
X73 a_2861_391# m2_1295_79# w_n310_281# w_n310_281# pfet_03v3 ad=0.725p pd=2.725u as=1.3p ps=5.3u w=2u l=0.28u
X74 a_4290_63# a_4158_271# w_n310_281# w_n310_281# pfet_03v3 ad=0.65p pd=3.3u as=0.56p ps=3.12u w=1u l=0.28u
X75 a_5243_407# m2_1295_79# w_n310_281# w_n310_281# pfet_03v3 ad=0.675p pd=2.675u as=0.725p ps=2.725u w=2u l=0.28u
X76 w_n310_281# a_5042_407# a_6721_407# w_n310_281# pfet_03v3 ad=0.725p pd=2.725u as=0.675p ps=2.675u w=2u l=0.28u
X77 a_3498_3# a_2861_3# via_dev$5$3_9/VSUBS via_dev$5$3_9/VSUBS nfet_03v3 ad=0.315p pd=2.26u as=0.325p ps=2.3u w=0.5u l=0.28u
X78 a_9609_407# a_8723_63# m2_9431_79# w_n310_281# pfet_03v3 ad=0.675p pd=2.675u as=0.725p ps=2.725u w=2u l=0.28u
X79 via_dev$5$3_9/VSUBS a_4290_63# a_5042_n37# via_dev$5$3_9/VSUBS nfet_03v3 ad=0.65p pd=3.3u as=0.3625p ps=1.725u w=1u l=0.28u
X80 m2_6151_79# a_2419_63# a_6128_n37# via_dev$5$3_9/VSUBS nfet_03v3 ad=0.3375p pd=1.675u as=0.3625p ps=1.725u w=1u l=0.28u
X81 w_n310_281# m2_24_342# a_1845_466# w_n310_281# pfet_03v3 ad=0.735p pd=2.47u as=0.42p ps=1.84u w=1u l=0.28u
X82 a_870_n37# a_378_271# via_dev$5$3_9/VSUBS via_dev$5$3_9/VSUBS nfet_03v3 ad=0.3625p pd=1.725u as=0.54p ps=3.08u w=1u l=0.28u
X83 a_12559_3# a_11922_3# w_n310_281# w_n310_281# pfet_03v3 ad=0.65p pd=3.3u as=0.675p ps=3.35u w=1u l=0.28u
C0 a_9609_407# a_11480_63# 0
C1 a_1262_n37# a_1845_466# 0
C2 a_8723_63# a_9050_63# 0.52788f
C3 a_2419_63# a_12559_3# 0
C4 a_870_n37# a_1845_466# 0
C5 m2_7791_79# a_7083_63# 0.14708f
C6 a_2419_63# a_7083_63# 0.01345f
C7 m2_1295_79# a_11480_63# 0.00126f
C8 a_705_407# a_510_63# 0.13828f
C9 a_5243_407# a_4290_63# 0.14023f
C10 m2_6151_79# w_n310_281# 0.44301f
C11 a_5243_407# a_5042_n37# 0
C12 a_9609_407# a_7083_63# 0.0285f
C13 m2_9431_79# a_10906_466# 0.00167f
C14 m2_1295_79# a_378_271# 0.02669f
C15 a_160_63# w_n310_281# 0.30515f
C16 a_6721_407# w_n310_281# 0.72579f
C17 a_8361_407# a_7083_63# 0.01453f
C18 a_3498_3# a_7410_63# 0.11774f
C19 m2_9431_79# w_n310_281# 0.46253f
C20 a_7768_n37# m2_7791_79# 0.01733f
C21 a_5768_63# a_6128_n37# 0.00935f
C22 a_10363_63# a_4158_271# 0.02222f
C23 m2_1295_79# a_7083_63# 0.01071f
C24 a_8918_358# w_n310_281# 0.49498f
C25 a_5042_407# w_n310_281# 0.29911f
C26 a_5042_407# a_4650_n37# 0.00712f
C27 a_8723_63# a_7083_63# 0.15796f
C28 m2_5700_324# w_n310_281# 1.65678f
C29 a_9800_n37# a_4158_271# 0.00497f
C30 a_5243_407# a_4158_271# 0.02964f
C31 a_3940_63# w_n310_281# 0.30087f
C32 a_3940_63# a_4650_n37# 0.00441f
C33 a_378_271# m2_24_342# 0.56715f
C34 m2_6151_79# a_4290_63# 0
C35 m2_6151_79# a_5042_n37# 0
C36 a_7768_n37# a_8361_407# 0
C37 a_160_63# a_870_n37# 0.00441f
C38 a_11480_63# a_11922_3# 0.04054f
C39 m2_7791_79# a_7410_63# 0.36168f
C40 a_2419_63# a_7410_63# 0.00801f
C41 a_11480_63# a_11922_391# 0.00152f
C42 a_9050_63# w_n310_281# 0.28931f
C43 a_8160_n37# m2_7791_79# 0.01048f
C44 a_5768_63# a_6520_n37# 0.01329f
C45 a_11922_3# a_12559_3# 0.0899f
C46 a_5042_407# a_4290_63# 0.38112f
C47 a_5042_407# a_5042_n37# 0.01726f
C48 a_11480_63# a_10906_466# 0.1131f
C49 a_8361_407# a_7410_63# 0.1423f
C50 m2_5700_324# a_4290_63# 0.01531f
C51 m2_1295_79# a_510_63# 0.39896f
C52 a_3940_63# a_4290_63# 0.28903f
C53 m2_6151_79# a_4158_271# 0.04334f
C54 m2_1295_79# a_7410_63# 0.07614f
C55 a_11480_63# w_n310_281# 0.37298f
C56 a_510_63# a_1845_n37# 0.0011f
C57 a_10906_466# a_12559_3# 0
C58 a_8723_63# a_7410_63# 0.01398f
C59 a_3498_3# a_5768_63# 0
C60 m2_9431_79# a_4158_271# 0.05572f
C61 a_378_271# w_n310_281# 0.63374f
C62 a_10906_466# a_7083_63# 0
C63 a_12559_3# w_n310_281# 0.08598f
C64 a_9408_n37# m2_9431_79# 0.01733f
C65 a_8918_358# a_4158_271# 0.00101f
C66 a_5042_407# a_4158_271# 0.63867f
C67 a_510_63# m2_24_342# 0.13025f
C68 m2_5700_324# a_4158_271# 0.00861f
C69 w_n310_281# a_7083_63# 0.31663f
C70 a_3940_63# a_4158_271# 0.16366f
C71 a_705_407# a_2419_63# 0
C72 m2_7791_79# a_5768_63# 0
C73 a_5768_63# a_2419_63# 0.07749f
C74 m2_9431_79# a_10363_63# 0.07766f
C75 a_3498_3# m2_7791_79# 0.0296f
C76 a_160_63# a_1845_466# 0
C77 a_3498_3# a_2419_63# 0.01177f
C78 a_10363_63# a_8918_358# 0
C79 a_9050_63# a_4158_271# 0.00717f
C80 a_9800_n37# m2_9431_79# 0.0074f
C81 a_9408_n37# a_9050_63# 0.00935f
C82 a_705_407# m2_1295_79# 0.30816f
C83 a_5243_407# a_5042_407# 0.29512f
C84 a_3498_3# a_8361_407# 0.12093f
C85 m2_1295_79# a_5768_63# 0.00766f
C86 a_3940_63# a_1845_466# 0
C87 a_705_407# a_2861_3# 0
C88 a_5243_407# m2_5700_324# 0.01927f
C89 a_3498_3# m2_1295_79# 0.3391f
C90 a_11480_63# a_4158_271# 0.00295f
C91 m2_7791_79# a_2419_63# 0.00843f
C92 a_510_63# w_n310_281# 0.28255f
C93 a_5243_407# a_3940_63# 0.06737f
C94 a_3498_3# a_8723_63# 0.00575f
C95 a_7410_63# w_n310_281# 0.31086f
C96 a_10363_63# a_9050_63# 0.01385f
C97 a_3498_3# a_2861_3# 0.09846f
C98 a_9609_407# m2_7791_79# 0
C99 a_9609_407# a_2419_63# 0
C100 a_6721_407# m2_6151_79# 0.4935f
C101 a_9800_n37# a_9050_63# 0.01329f
C102 a_705_407# m2_24_342# 0.10607f
C103 a_8361_407# m2_7791_79# 0.49779f
C104 a_8361_407# a_2419_63# 0
C105 a_1262_n37# a_510_63# 0.00898f
C106 a_7083_63# a_4158_271# 1.09133f
C107 a_5042_407# m2_6151_79# 0.20459f
C108 m2_1295_79# m2_7791_79# 0.05731f
C109 a_3498_3# m2_24_342# 0
C110 a_9408_n37# a_7083_63# 0.00336f
C111 a_10363_63# a_11480_63# 0
C112 m2_1295_79# a_2419_63# 0.3246f
C113 a_8361_407# a_9609_407# 0.00466f
C114 a_870_n37# a_510_63# 0.01502f
C115 m2_7791_79# a_8723_63# 0.08381f
C116 m2_6151_79# m2_5700_324# 0.14941f
C117 a_8723_63# a_2419_63# 0.00649f
C118 a_2419_63# a_2861_3# 0.21478f
C119 a_5042_407# a_6721_407# 0.03265f
C120 m2_1295_79# a_9609_407# 0.0093f
C121 m2_9431_79# a_8918_358# 0.03217f
C122 a_6721_407# m2_5700_324# 0.50857f
C123 a_9609_407# a_8723_63# 0.0593f
C124 a_1845_466# a_378_271# 0.01278f
C125 m2_1295_79# a_8361_407# 0.02509f
C126 a_10363_63# a_7083_63# 0.00582f
C127 a_8918_358# m2_5700_324# 0
C128 a_5042_407# m2_5700_324# 0.06917f
C129 a_8361_407# a_8723_63# 0.01268f
C130 a_2419_63# m2_24_342# 0.00234f
C131 a_3940_63# a_5042_407# 0.0941f
C132 m2_1295_79# a_8723_63# 0.00796f
C133 a_9800_n37# a_7083_63# 0.00527f
C134 m2_1295_79# a_1845_n37# 0.00942f
C135 m2_1295_79# a_2861_3# 0.15381f
C136 a_3940_63# m2_5700_324# 0.00132f
C137 a_705_407# w_n310_281# 0.79414f
C138 m2_9431_79# a_9050_63# 0.328f
C139 a_5768_63# w_n310_281# 0.31314f
C140 a_7410_63# a_4158_271# 0
C141 a_2419_63# a_11922_3# 0.16984f
C142 a_10906_n37# a_10906_466# 0.01333f
C143 a_8918_358# a_9050_63# 0.09973f
C144 a_3498_3# w_n310_281# 1.03377f
C145 a_2419_63# a_11922_391# 0.00754f
C146 m2_1295_79# m2_24_342# 0.04399f
C147 a_705_407# a_1262_n37# 0
C148 a_10906_n37# w_n310_281# 0
C149 m2_9431_79# a_11480_63# 0
C150 a_2419_63# a_10906_466# 0.00833f
C151 a_160_63# a_378_271# 0.09182f
C152 m2_1295_79# a_11922_3# 0
C153 m2_6151_79# a_7083_63# 0.08089f
C154 a_9609_407# a_10906_466# 0
C155 m2_7791_79# w_n310_281# 0.45142f
C156 a_510_63# a_1845_466# 0.01433f
C157 a_5768_63# a_4290_63# 0.01093f
C158 a_2419_63# w_n310_281# 0.75125f
C159 a_3498_3# a_4290_63# 0.00876f
C160 a_6721_407# a_7083_63# 0.01268f
C161 a_9609_407# w_n310_281# 0.7653f
C162 m2_9431_79# a_7083_63# 0.19293f
C163 a_6520_n37# a_4158_271# 0.00406f
C164 m2_1295_79# a_10906_466# 0.0692f
C165 a_8918_358# a_7083_63# 0.01057f
C166 a_5042_407# a_7083_63# 0.02611f
C167 a_8361_407# w_n310_281# 0.75753f
C168 m2_5700_324# a_7083_63# 0.12051f
C169 m2_1295_79# w_n310_281# 2.35222f
C170 a_5768_63# a_4158_271# 0.00573f
C171 a_705_407# a_2861_391# 0
C172 a_8723_63# w_n310_281# 0.33519f
C173 a_1845_n37# w_n310_281# 0
C174 a_2861_3# w_n310_281# 0.4655f
C175 a_2419_63# a_4290_63# 0.00652f
C176 a_7768_n37# m2_9431_79# 0
C177 a_3498_3# a_4158_271# 0.00829f
C178 a_3498_3# a_2861_391# 0.00454f
C179 m2_6151_79# a_7410_63# 0
C180 a_9050_63# a_7083_63# 0.21474f
C181 m2_1295_79# a_1262_n37# 0.01607f
C182 a_11922_391# a_11922_3# 0.01891f
C183 a_10906_n37# a_4158_271# 0.00824f
C184 a_160_63# a_510_63# 0.28903f
C185 m2_6151_79# a_6128_n37# 0.01733f
C186 w_n310_281# m2_24_342# 0.66878f
C187 m2_1295_79# a_870_n37# 0.00639f
C188 a_10906_466# a_11922_3# 0
C189 m2_9431_79# a_7410_63# 0.00105f
C190 m2_1295_79# a_4290_63# 0.13519f
C191 a_705_407# a_1845_466# 0.0126f
C192 m2_7791_79# a_4158_271# 0
C193 a_6721_407# a_6128_n37# 0
C194 a_8918_358# a_7410_63# 0
C195 a_5042_407# a_7410_63# 0
C196 a_2419_63# a_4158_271# 0.14782f
C197 a_2861_3# a_4290_63# 0
C198 a_11922_3# w_n310_281# 0.46598f
C199 a_9408_n37# m2_7791_79# 0
C200 a_8160_n37# m2_9431_79# 0
C201 a_2419_63# a_2861_391# 0.0163f
C202 m2_5700_324# a_7410_63# 0.14432f
C203 a_3498_3# a_1845_466# 0.00105f
C204 a_5243_407# a_5768_63# 0.00722f
C205 a_9609_407# a_4158_271# 0
C206 a_5042_407# a_6128_n37# 0.00376f
C207 a_10906_n37# a_10363_63# 0
C208 a_3498_3# a_5243_407# 0.16427f
C209 a_9408_n37# a_9609_407# 0
C210 a_11922_391# w_n310_281# 0.03535f
C211 m2_6151_79# a_6520_n37# 0.00766f
C212 a_10906_466# w_n310_281# 0.44509f
C213 m2_1295_79# a_4158_271# 0.16058f
C214 a_10363_63# a_2419_63# 0.00126f
C215 m2_1295_79# a_2861_391# 0.00841f
C216 a_8723_63# a_4158_271# 0
C217 a_2419_63# a_1845_466# 0.10509f
C218 a_9609_407# a_10363_63# 0.01306f
C219 a_2861_3# a_2861_391# 0.01616f
C220 a_5243_407# a_2419_63# 0
C221 a_5042_407# a_6520_n37# 0.00483f
C222 m2_6151_79# a_5768_63# 0.35511f
C223 a_705_407# a_160_63# 0.06737f
C224 a_3498_3# m2_6151_79# 0
C225 a_7768_n37# a_7083_63# 0.0028f
C226 a_6721_407# a_5768_63# 0.14017f
C227 a_510_63# a_378_271# 0.14298f
C228 m2_1295_79# a_10363_63# 0.00179f
C229 a_3498_3# a_6721_407# 0
C230 a_3498_3# m2_9431_79# 0
C231 a_8723_63# a_10363_63# 0
C232 m2_1295_79# a_1845_466# 0.09644f
C233 a_5042_407# a_5768_63# 0.22596f
C234 a_5243_407# m2_1295_79# 0.10989f
C235 a_3498_3# a_5042_407# 0.02015f
C236 a_11922_3# a_4158_271# 0.0013f
C237 a_1845_466# a_1845_n37# 0.01333f
C238 a_2861_3# a_1845_466# 0
C239 w_n310_281# a_4290_63# 0.2819f
C240 a_5768_63# m2_5700_324# 0.16447f
C241 a_4650_n37# a_4290_63# 0.01502f
C242 a_7410_63# a_7083_63# 0.07718f
C243 a_3940_63# a_5768_63# 0
C244 a_3498_3# m2_5700_324# 0.55174f
C245 m2_6151_79# m2_7791_79# 0.00114f
C246 a_5243_407# a_2861_3# 0
C247 m2_6151_79# a_2419_63# 0.05852f
C248 a_3498_3# a_3940_63# 0.04602f
C249 a_8160_n37# a_7083_63# 0.00507f
C250 a_6721_407# a_2419_63# 0.01825f
C251 m2_7791_79# m2_9431_79# 0.01571f
C252 a_10906_466# a_4158_271# 0.03873f
C253 a_1845_466# m2_24_342# 0.06999f
C254 m2_9431_79# a_2419_63# 0.00832f
C255 m2_7791_79# a_8918_358# 0.02764f
C256 a_5042_407# m2_7791_79# 0.00555f
C257 a_2419_63# a_8918_358# 0.01449f
C258 a_5042_407# a_2419_63# 0.08051f
C259 a_7768_n37# a_7410_63# 0.00935f
C260 a_9609_407# m2_9431_79# 0.49779f
C261 w_n310_281# a_4158_271# 0.66883f
C262 m2_7791_79# m2_5700_324# 0.05245f
C263 a_4650_n37# a_4158_271# 0.00383f
C264 m2_1295_79# m2_6151_79# 0.00667f
C265 a_2419_63# m2_5700_324# 0.074f
C266 a_5042_n37# a_4290_63# 0.00898f
C267 a_9609_407# a_8918_358# 0.02942f
C268 w_n310_281# a_2861_391# 0.03535f
C269 a_3940_63# a_2419_63# 0.00879f
C270 a_8361_407# m2_9431_79# 0
C271 a_160_63# m2_1295_79# 0.09339f
C272 m2_1295_79# a_6721_407# 0.00452f
C273 a_8361_407# a_8918_358# 0
C274 a_6520_n37# a_7083_63# 0.00272f
C275 m2_1295_79# m2_9431_79# 0.0078f
C276 a_705_407# a_378_271# 0.02817f
C277 a_10363_63# a_10906_466# 0.02047f
C278 m2_1295_79# a_8918_358# 0.01371f
C279 m2_9431_79# a_8723_63# 0.13485f
C280 a_8361_407# m2_5700_324# 0.05956f
C281 m2_1295_79# a_5042_407# 0.03487f
C282 m2_7791_79# a_9050_63# 0.00127f
C283 a_2419_63# a_9050_63# 0.00801f
C284 a_8723_63# a_8918_358# 0.12497f
C285 m2_1295_79# m2_5700_324# 0.07849f
C286 a_10363_63# w_n310_281# 0.15741f
C287 a_5042_407# a_2861_3# 0
C288 a_8160_n37# a_7410_63# 0.01329f
C289 m2_1295_79# a_3940_63# 0.46061f
C290 a_9609_407# a_9050_63# 0.1261f
C291 a_4290_63# a_4158_271# 0.11363f
C292 a_8723_63# m2_5700_324# 0
C293 a_5042_n37# a_4158_271# 0
C294 a_5768_63# a_7083_63# 0.01494f
C295 a_1845_466# w_n310_281# 0.44517f
C296 a_160_63# m2_24_342# 0.42316f
C297 a_3498_3# a_7083_63# 0.01356f
C298 a_3940_63# a_2861_3# 0
C299 a_5243_407# w_n310_281# 0.78984f
C300 a_8361_407# a_9050_63# 0
C301 a_2419_63# a_11480_63# 0.0769f
C302 m2_1295_79# a_9050_63# 0.00716f
C303 a_4158_271# via_dev$5$3_9/VSUBS 2.63856f
C304 a_7083_63# via_dev$5$3_9/VSUBS 0.86585f
C305 a_8723_63# via_dev$5$3_9/VSUBS 0.40977f
C306 m2_9431_79# via_dev$5$3_9/VSUBS 0.75255f
C307 m2_7791_79# via_dev$5$3_9/VSUBS 0.74612f
C308 a_9609_407# via_dev$5$3_9/VSUBS 0.11967f
C309 a_8361_407# via_dev$5$3_9/VSUBS 0.05216f
C310 m2_6151_79# via_dev$5$3_9/VSUBS 0.72815f
C311 a_6721_407# via_dev$5$3_9/VSUBS 0.01698f
C312 a_5042_407# via_dev$5$3_9/VSUBS 0.88916f
C313 a_3940_63# via_dev$5$3_9/VSUBS 0.46864f
C314 m2_1295_79# via_dev$5$3_9/VSUBS 3.34703f
C315 a_160_63# via_dev$5$3_9/VSUBS 0.5921f
C316 a_5243_407# via_dev$5$3_9/VSUBS 0.01661f
C317 a_705_407# via_dev$5$3_9/VSUBS 0.13677f
C318 a_3498_3# via_dev$5$3_9/VSUBS 1.27724f
C319 a_10906_n37# via_dev$5$3_9/VSUBS 0.02232f
C320 a_9800_n37# via_dev$5$3_9/VSUBS 0.01742f
C321 a_9408_n37# via_dev$5$3_9/VSUBS 0.007f
C322 a_8160_n37# via_dev$5$3_9/VSUBS 0.01743f
C323 a_7768_n37# via_dev$5$3_9/VSUBS 0.007f
C324 a_6520_n37# via_dev$5$3_9/VSUBS 0.01743f
C325 a_6128_n37# via_dev$5$3_9/VSUBS 0.007f
C326 a_5042_n37# via_dev$5$3_9/VSUBS 0.00833f
C327 a_4650_n37# via_dev$5$3_9/VSUBS 0.01565f
C328 a_12559_3# via_dev$5$3_9/VSUBS 0.19481f
C329 a_11922_3# via_dev$5$3_9/VSUBS 0.64569f
C330 a_11922_391# via_dev$5$3_9/VSUBS 0.00119f
C331 a_10906_466# via_dev$5$3_9/VSUBS 0.59796f
C332 a_11480_63# via_dev$5$3_9/VSUBS 0.42359f
C333 a_10363_63# via_dev$5$3_9/VSUBS 0.13924f
C334 a_9050_63# via_dev$5$3_9/VSUBS 0.53264f
C335 a_8918_358# via_dev$5$3_9/VSUBS 0.5203f
C336 a_7410_63# via_dev$5$3_9/VSUBS 0.53731f
C337 a_5768_63# via_dev$5$3_9/VSUBS 0.54f
C338 a_1845_n37# via_dev$5$3_9/VSUBS 0.01974f
C339 a_1262_n37# via_dev$5$3_9/VSUBS 0.0069f
C340 a_870_n37# via_dev$5$3_9/VSUBS 0.01517f
C341 a_4290_63# via_dev$5$3_9/VSUBS 0.57048f
C342 a_2861_3# via_dev$5$3_9/VSUBS 0.62907f
C343 a_1845_466# via_dev$5$3_9/VSUBS 0.59853f
C344 a_2419_63# via_dev$5$3_9/VSUBS 6.64114f
C345 a_510_63# via_dev$5$3_9/VSUBS 0.55998f
C346 a_378_271# via_dev$5$3_9/VSUBS 1.37769f
C347 w_n310_281# via_dev$5$3_9/VSUBS 27.06676f
C348 m2_5700_324# via_dev$5$3_9/VSUBS 1.14834f
C349 m2_24_342# via_dev$5$3_9/VSUBS 1.98211f
.ends

.subckt x1bitblock a_2861_3# a_8361_407# a_6520_n37# a_1262_n37# a_2861_391# a_1845_466#
+ a_10906_n37# a_510_63# a_870_n37# a_9800_n37# a_11480_63# a_6128_n37# a_5768_63#
+ m2_6151_79# a_11922_391# a_5042_n37# a_9408_n37# a_8918_357# a_9609_407# a_5042_407#
+ a_8160_n37# a_4158_271# a_11922_3# a_2419_63# m2_9431_79# a_10906_466# a_4650_n37#
+ a_3498_3# a_9050_63# a_7768_n37# a_3940_63# m2_7791_79# a_10363_63# a_160_63# a_4290_63#
+ a_7083_63# a_705_407# a_12559_3# a_7410_63# a_1845_n37# via_dev$5_9/VSUBS m2_1295_79#
+ a_8723_63# a_378_271# m2_5700_324# w_n310_281# m2_24_342#
X0 a_2419_63# a_1845_466# via_dev$5_9/VSUBS via_dev$5_9/VSUBS nfet_03v3 ad=0.315p pd=2.26u as=0.2425p ps=1.97u w=0.5u l=0.28u
X1 a_1845_466# m2_24_342# a_1845_n37# via_dev$5_9/VSUBS nfet_03v3 ad=0.65p pd=3.3u as=0.42p ps=1.84u w=1u l=0.28u
X2 a_3940_63# m2_1295_79# w_n310_281# w_n310_281# pfet_03v3 ad=0.63p pd=3.26u as=0.65p ps=3.3u w=1u l=0.28u
X3 via_dev$5_9/VSUBS a_510_63# a_1262_n37# via_dev$5_9/VSUBS nfet_03v3 ad=0.65p pd=3.3u as=0.3625p ps=1.725u w=1u l=0.28u
X4 a_5243_407# a_4290_63# a_5042_407# w_n310_281# pfet_03v3 ad=1.3p pd=5.3u as=0.725p ps=2.725u w=2u l=0.28u
X5 a_6721_407# a_2419_63# m2_6151_79# w_n310_281# pfet_03v3 ad=0.675p pd=2.675u as=0.725p ps=2.725u w=2u l=0.28u
X6 a_10906_466# a_4158_271# w_n310_281# w_n310_281# pfet_03v3 ad=0.42p pd=1.84u as=0.65p ps=3.3u w=1u l=0.28u
X7 a_4290_63# a_4158_271# via_dev$5_9/VSUBS via_dev$5_9/VSUBS nfet_03v3 ad=0.315p pd=2.26u as=0.28p ps=2.12u w=0.5u l=0.28u
X8 w_n310_281# a_378_271# a_705_407# w_n310_281# pfet_03v3 ad=0.725p pd=2.725u as=1.09p ps=5.09u w=2u l=0.28u
X9 a_2861_3# m2_1295_79# via_dev$5_9/VSUBS via_dev$5_9/VSUBS nfet_03v3 ad=0.18125p pd=1.225u as=0.325p ps=2.3u w=0.5u l=0.28u
X10 via_dev$5_9/VSUBS a_2419_63# a_2861_3# via_dev$5_9/VSUBS nfet_03v3 ad=0.315p pd=2.26u as=0.18125p ps=1.225u w=0.5u l=0.28u
X11 m2_7791_79# m2_1295_79# a_7768_n37# via_dev$5_9/VSUBS nfet_03v3 ad=0.3375p pd=1.675u as=0.3625p ps=1.725u w=1u l=0.28u
X12 a_10906_n37# a_4158_271# via_dev$5_9/VSUBS via_dev$5_9/VSUBS nfet_03v3 ad=0.42p pd=1.84u as=0.63p ps=3.26u w=1u l=0.28u
X13 a_9050_63# a_8918_357# via_dev$5_9/VSUBS via_dev$5_9/VSUBS nfet_03v3 ad=0.31p pd=2.24u as=0.24p ps=1.96u w=0.5u l=0.28u
X14 a_11922_3# a_11480_63# via_dev$5_9/VSUBS via_dev$5_9/VSUBS nfet_03v3 ad=0.18125p pd=1.225u as=0.325p ps=2.3u w=0.5u l=0.28u
X15 via_dev$5_9/VSUBS a_2419_63# a_11922_3# via_dev$5_9/VSUBS nfet_03v3 ad=0.315p pd=2.26u as=0.18125p ps=1.225u w=0.5u l=0.28u
X16 a_705_407# a_510_63# m2_1295_79# w_n310_281# pfet_03v3 ad=1.3p pd=5.3u as=0.725p ps=2.725u w=2u l=0.28u
X17 a_4650_n37# a_4158_271# via_dev$5_9/VSUBS via_dev$5_9/VSUBS nfet_03v3 ad=0.3625p pd=1.725u as=0.54p ps=3.08u w=1u l=0.28u
X18 a_2861_3# a_2419_63# a_2861_391# w_n310_281# pfet_03v3 ad=1.3p pd=5.3u as=0.725p ps=2.725u w=2u l=0.28u
X19 a_5768_63# m2_5700_324# via_dev$5_9/VSUBS via_dev$5_9/VSUBS nfet_03v3 ad=0.315p pd=2.26u as=0.3175p ps=2.27u w=0.5u l=0.28u
X20 via_dev$5_9/VSUBS a_9050_63# a_9800_n37# via_dev$5_9/VSUBS nfet_03v3 ad=0.65p pd=3.3u as=0.3625p ps=1.725u w=1u l=0.28u
X21 a_8361_407# m2_1295_79# m2_7791_79# w_n310_281# pfet_03v3 ad=0.675p pd=2.675u as=0.725p ps=2.725u w=2u l=0.28u
X22 a_9408_n37# a_8918_357# via_dev$5_9/VSUBS via_dev$5_9/VSUBS nfet_03v3 ad=0.3625p pd=1.725u as=0.54p ps=3.08u w=1u l=0.28u
X23 a_3498_3# a_2861_3# w_n310_281# w_n310_281# pfet_03v3 ad=0.65p pd=3.3u as=0.675p ps=3.35u w=1u l=0.28u
X24 a_7410_63# m2_5700_324# via_dev$5_9/VSUBS via_dev$5_9/VSUBS nfet_03v3 ad=0.31p pd=2.24u as=0.24p ps=1.96u w=0.5u l=0.28u
X25 via_dev$5_9/VSUBS a_7410_63# a_8160_n37# via_dev$5_9/VSUBS nfet_03v3 ad=0.65p pd=3.3u as=0.3625p ps=1.725u w=1u l=0.28u
X26 a_8723_63# m2_7791_79# via_dev$5_9/VSUBS via_dev$5_9/VSUBS nfet_03v3 ad=0.2625p pd=2.05u as=0.265p ps=2.06u w=0.5u l=0.28u
X27 w_n310_281# a_4158_271# a_5243_407# w_n310_281# pfet_03v3 ad=0.725p pd=2.725u as=1.09p ps=5.09u w=2u l=0.28u
X28 a_5768_63# m2_5700_324# w_n310_281# w_n310_281# pfet_03v3 ad=0.65p pd=3.3u as=0.635p ps=3.27u w=1u l=0.28u
X29 a_9050_63# a_8918_357# w_n310_281# w_n310_281# pfet_03v3 ad=0.64p pd=3.28u as=0.48p ps=2.96u w=1u l=0.28u
X30 a_11922_391# a_11480_63# w_n310_281# w_n310_281# pfet_03v3 ad=0.725p pd=2.725u as=1.3p ps=5.3u w=2u l=0.28u
X31 a_160_63# m2_24_342# via_dev$5_9/VSUBS via_dev$5_9/VSUBS nfet_03v3 ad=0.315p pd=2.26u as=0.325p ps=2.3u w=0.5u l=0.28u
X32 a_9609_407# a_9050_63# w_n310_281# w_n310_281# pfet_03v3 ad=1.3p pd=5.3u as=0.725p ps=2.725u w=2u l=0.28u
X33 a_6128_n37# m2_5700_324# via_dev$5_9/VSUBS via_dev$5_9/VSUBS nfet_03v3 ad=0.3625p pd=1.725u as=0.54p ps=3.08u w=1u l=0.28u
X34 via_dev$5_9/VSUBS a_5768_63# a_6520_n37# via_dev$5_9/VSUBS nfet_03v3 ad=0.65p pd=3.3u as=0.3625p ps=1.725u w=1u l=0.28u
X35 a_7410_63# m2_5700_324# w_n310_281# w_n310_281# pfet_03v3 ad=0.64p pd=3.28u as=0.48p ps=2.96u w=1u l=0.28u
X36 m2_9431_79# a_8918_357# a_9609_407# w_n310_281# pfet_03v3 ad=0.725p pd=2.725u as=1.09p ps=5.09u w=2u l=0.28u
X37 a_11480_63# a_10906_466# via_dev$5_9/VSUBS via_dev$5_9/VSUBS nfet_03v3 ad=0.315p pd=2.26u as=0.2425p ps=1.97u w=0.5u l=0.28u
X38 a_1845_466# a_378_271# w_n310_281# w_n310_281# pfet_03v3 ad=0.42p pd=1.84u as=0.65p ps=3.3u w=1u l=0.28u
X39 a_8361_407# a_7410_63# w_n310_281# w_n310_281# pfet_03v3 ad=1.3p pd=5.3u as=0.725p ps=2.725u w=2u l=0.28u
X40 w_n310_281# m2_1295_79# a_10906_466# w_n310_281# pfet_03v3 ad=0.735p pd=2.47u as=0.42p ps=1.84u w=1u l=0.28u
X41 a_7083_63# m2_6151_79# via_dev$5_9/VSUBS via_dev$5_9/VSUBS nfet_03v3 ad=0.2625p pd=2.05u as=0.265p ps=2.06u w=0.5u l=0.28u
X42 a_510_63# a_378_271# w_n310_281# w_n310_281# pfet_03v3 ad=0.65p pd=3.3u as=0.56p ps=3.12u w=1u l=0.28u
X43 a_10363_63# m2_9431_79# w_n310_281# w_n310_281# pfet_03v3 ad=0.715p pd=3.43u as=0.53p ps=3.06u w=1u l=0.28u
X44 a_510_63# a_378_271# via_dev$5_9/VSUBS via_dev$5_9/VSUBS nfet_03v3 ad=0.315p pd=2.26u as=0.28p ps=2.12u w=0.5u l=0.28u
X45 a_1262_n37# a_160_63# m2_1295_79# via_dev$5_9/VSUBS nfet_03v3 ad=0.3625p pd=1.725u as=0.3375p ps=1.675u w=1u l=0.28u
X46 a_1845_n37# a_378_271# via_dev$5_9/VSUBS via_dev$5_9/VSUBS nfet_03v3 ad=0.42p pd=1.84u as=0.63p ps=3.26u w=1u l=0.28u
X47 m2_6151_79# m2_5700_324# a_6721_407# w_n310_281# pfet_03v3 ad=0.725p pd=2.725u as=1.09p ps=5.09u w=2u l=0.28u
X48 a_6721_407# a_5768_63# w_n310_281# w_n310_281# pfet_03v3 ad=1.3p pd=5.3u as=0.725p ps=2.725u w=2u l=0.28u
X49 a_10363_63# m2_9431_79# via_dev$5_9/VSUBS via_dev$5_9/VSUBS nfet_03v3 ad=0.3575p pd=2.43u as=0.265p ps=2.06u w=0.5u l=0.28u
X50 a_10906_466# m2_1295_79# a_10906_n37# via_dev$5_9/VSUBS nfet_03v3 ad=0.65p pd=3.3u as=0.42p ps=1.84u w=1u l=0.28u
X51 a_8723_63# m2_7791_79# w_n310_281# w_n310_281# pfet_03v3 ad=0.545p pd=3.09u as=0.53p ps=3.06u w=1u l=0.28u
X52 a_11480_63# a_10906_466# w_n310_281# w_n310_281# pfet_03v3 ad=0.65p pd=3.3u as=0.735p ps=2.47u w=1u l=0.28u
X53 a_12559_3# a_11922_3# via_dev$5_9/VSUBS via_dev$5_9/VSUBS nfet_03v3 ad=0.315p pd=2.26u as=0.325p ps=2.3u w=0.5u l=0.28u
X54 a_7083_63# m2_6151_79# w_n310_281# w_n310_281# pfet_03v3 ad=0.545p pd=3.09u as=0.53p ps=3.06u w=1u l=0.28u
X55 a_7768_n37# m2_5700_324# via_dev$5_9/VSUBS via_dev$5_9/VSUBS nfet_03v3 ad=0.3625p pd=1.725u as=0.54p ps=3.08u w=1u l=0.28u
X56 a_160_63# m2_24_342# w_n310_281# w_n310_281# pfet_03v3 ad=0.63p pd=3.26u as=0.65p ps=3.3u w=1u l=0.28u
X57 m2_1295_79# a_160_63# a_705_407# w_n310_281# pfet_03v3 ad=0.725p pd=2.725u as=0.675p ps=2.675u w=2u l=0.28u
X58 a_5042_n37# a_3940_63# a_5042_407# via_dev$5_9/VSUBS nfet_03v3 ad=0.3625p pd=1.725u as=0.3375p ps=1.675u w=1u l=0.28u
X59 m2_1295_79# m2_24_342# a_870_n37# via_dev$5_9/VSUBS nfet_03v3 ad=0.3375p pd=1.675u as=0.3625p ps=1.725u w=1u l=0.28u
X60 a_11922_3# a_2419_63# a_11922_391# w_n310_281# pfet_03v3 ad=1.3p pd=5.3u as=0.725p ps=2.725u w=2u l=0.28u
X61 a_9800_n37# a_7083_63# m2_9431_79# via_dev$5_9/VSUBS nfet_03v3 ad=0.3625p pd=1.725u as=0.3375p ps=1.675u w=1u l=0.28u
X62 m2_7791_79# m2_5700_324# a_8361_407# w_n310_281# pfet_03v3 ad=0.725p pd=2.725u as=1.09p ps=5.09u w=2u l=0.28u
X63 a_5042_407# a_3940_63# a_5243_407# w_n310_281# pfet_03v3 ad=0.725p pd=2.725u as=0.675p ps=2.675u w=2u l=0.28u
X64 a_3940_63# m2_1295_79# via_dev$5_9/VSUBS via_dev$5_9/VSUBS nfet_03v3 ad=0.315p pd=2.26u as=0.325p ps=2.3u w=0.5u l=0.28u
X65 a_8160_n37# a_3498_3# m2_7791_79# via_dev$5_9/VSUBS nfet_03v3 ad=0.3625p pd=1.725u as=0.3375p ps=1.675u w=1u l=0.28u
X66 a_705_407# m2_24_342# w_n310_281# w_n310_281# pfet_03v3 ad=0.675p pd=2.675u as=0.725p ps=2.725u w=2u l=0.28u
X67 a_5042_407# m2_1295_79# a_4650_n37# via_dev$5_9/VSUBS nfet_03v3 ad=0.3375p pd=1.675u as=0.3625p ps=1.725u w=1u l=0.28u
X68 a_6520_n37# a_5042_407# m2_6151_79# via_dev$5_9/VSUBS nfet_03v3 ad=0.3625p pd=1.725u as=0.3375p ps=1.675u w=1u l=0.28u
X69 w_n310_281# a_7083_63# a_9609_407# w_n310_281# pfet_03v3 ad=0.725p pd=2.725u as=0.675p ps=2.675u w=2u l=0.28u
X70 a_2419_63# a_1845_466# w_n310_281# w_n310_281# pfet_03v3 ad=0.65p pd=3.3u as=0.735p ps=2.47u w=1u l=0.28u
X71 m2_9431_79# a_8723_63# a_9408_n37# via_dev$5_9/VSUBS nfet_03v3 ad=0.3375p pd=1.675u as=0.3625p ps=1.725u w=1u l=0.28u
X72 w_n310_281# a_3498_3# a_8361_407# w_n310_281# pfet_03v3 ad=0.725p pd=2.725u as=0.675p ps=2.675u w=2u l=0.28u
X73 a_2861_391# m2_1295_79# w_n310_281# w_n310_281# pfet_03v3 ad=0.725p pd=2.725u as=1.3p ps=5.3u w=2u l=0.28u
X74 a_4290_63# a_4158_271# w_n310_281# w_n310_281# pfet_03v3 ad=0.65p pd=3.3u as=0.56p ps=3.12u w=1u l=0.28u
X75 a_5243_407# m2_1295_79# w_n310_281# w_n310_281# pfet_03v3 ad=0.675p pd=2.675u as=0.725p ps=2.725u w=2u l=0.28u
X76 w_n310_281# a_5042_407# a_6721_407# w_n310_281# pfet_03v3 ad=0.725p pd=2.725u as=0.675p ps=2.675u w=2u l=0.28u
X77 a_3498_3# a_2861_3# via_dev$5_9/VSUBS via_dev$5_9/VSUBS nfet_03v3 ad=0.315p pd=2.26u as=0.325p ps=2.3u w=0.5u l=0.28u
X78 a_9609_407# a_8723_63# m2_9431_79# w_n310_281# pfet_03v3 ad=0.675p pd=2.675u as=0.725p ps=2.725u w=2u l=0.28u
X79 via_dev$5_9/VSUBS a_4290_63# a_5042_n37# via_dev$5_9/VSUBS nfet_03v3 ad=0.65p pd=3.3u as=0.3625p ps=1.725u w=1u l=0.28u
X80 m2_6151_79# a_2419_63# a_6128_n37# via_dev$5_9/VSUBS nfet_03v3 ad=0.3375p pd=1.675u as=0.3625p ps=1.725u w=1u l=0.28u
X81 w_n310_281# m2_24_342# a_1845_466# w_n310_281# pfet_03v3 ad=0.735p pd=2.47u as=0.42p ps=1.84u w=1u l=0.28u
X82 a_870_n37# a_378_271# via_dev$5_9/VSUBS via_dev$5_9/VSUBS nfet_03v3 ad=0.3625p pd=1.725u as=0.54p ps=3.08u w=1u l=0.28u
X83 a_12559_3# a_11922_3# w_n310_281# w_n310_281# pfet_03v3 ad=0.65p pd=3.3u as=0.675p ps=3.35u w=1u l=0.28u
C0 a_4290_63# a_5042_n37# 0.00898f
C1 a_2419_63# a_12559_3# 0
C2 m2_24_342# a_378_271# 0.56715f
C3 a_2861_391# w_n310_281# 0.03535f
C4 m2_1295_79# m2_24_342# 0.04399f
C5 a_8160_n37# m2_9431_79# 0
C6 a_8361_407# a_8918_357# 0
C7 m2_6151_79# a_4290_63# 0
C8 a_705_407# w_n310_281# 0.79414f
C9 a_705_407# a_160_63# 0.06737f
C10 m2_1295_79# a_8918_357# 0.01371f
C11 a_3498_3# m2_6151_79# 0
C12 m2_1295_79# a_2861_3# 0.15381f
C13 a_4290_63# w_n310_281# 0.2819f
C14 m2_6151_79# m2_5700_324# 0.14941f
C15 m2_7791_79# a_7410_63# 0.36168f
C16 a_3498_3# w_n310_281# 1.03377f
C17 m2_5700_324# w_n310_281# 1.65678f
C18 a_3498_3# a_6721_407# 0
C19 m2_9431_79# a_9050_63# 0.328f
C20 a_6721_407# m2_5700_324# 0.50857f
C21 a_9408_n37# a_7083_63# 0.00336f
C22 a_5042_407# a_4290_63# 0.38112f
C23 a_10906_n37# w_n310_281# 0
C24 a_3498_3# a_5042_407# 0.02015f
C25 a_4158_271# a_8918_357# 0.00101f
C26 m2_1295_79# a_1262_n37# 0.01607f
C27 a_5042_407# m2_5700_324# 0.06917f
C28 a_10363_63# w_n310_281# 0.15741f
C29 a_3940_63# a_4290_63# 0.28903f
C30 a_1845_466# w_n310_281# 0.44517f
C31 a_160_63# a_1845_466# 0
C32 w_n310_281# a_9609_407# 0.7653f
C33 a_11922_3# w_n310_281# 0.46598f
C34 m2_7791_79# a_2419_63# 0.00843f
C35 a_4290_63# a_5768_63# 0.01093f
C36 a_3498_3# a_3940_63# 0.04602f
C37 a_7083_63# a_8918_357# 0.01057f
C38 a_3940_63# m2_5700_324# 0.00132f
C39 a_3498_3# a_5768_63# 0
C40 m2_5700_324# a_5768_63# 0.16447f
C41 a_11922_391# w_n310_281# 0.03535f
C42 a_9800_n37# a_4158_271# 0.00497f
C43 a_8723_63# a_8918_357# 0.1249f
C44 a_8361_407# a_7410_63# 0.1423f
C45 m2_1295_79# a_11480_63# 0.00126f
C46 a_10906_466# w_n310_281# 0.44509f
C47 a_9800_n37# a_7083_63# 0.00527f
C48 a_3498_3# m2_9431_79# 0
C49 a_3940_63# a_1845_466# 0
C50 a_5243_407# a_2419_63# 0
C51 m2_1295_79# a_7410_63# 0.07614f
C52 a_510_63# m2_24_342# 0.13025f
C53 a_9408_n37# a_9050_63# 0.00935f
C54 m2_9431_79# a_10363_63# 0.07766f
C55 a_8361_407# a_2419_63# 0
C56 m2_1295_79# a_870_n37# 0.00639f
C57 m2_9431_79# a_9609_407# 0.49779f
C58 a_4158_271# a_11480_63# 0.00295f
C59 a_4158_271# a_7410_63# 0
C60 a_7768_n37# a_7410_63# 0.00935f
C61 m2_1295_79# a_2419_63# 0.3246f
C62 a_5042_407# a_4650_n37# 0.00712f
C63 a_8918_357# a_9050_63# 0.09973f
C64 a_7083_63# a_7410_63# 0.07718f
C65 a_1262_n37# a_510_63# 0.00898f
C66 a_3940_63# a_4650_n37# 0.00441f
C67 m2_6151_79# a_5042_n37# 0
C68 m2_9431_79# a_10906_466# 0.00167f
C69 a_8723_63# a_7410_63# 0.01398f
C70 a_4158_271# a_2419_63# 0.14782f
C71 a_9800_n37# a_9050_63# 0.01329f
C72 a_705_407# m2_24_342# 0.10607f
C73 m2_7791_79# a_8361_407# 0.49779f
C74 a_6128_n37# m2_6151_79# 0.01733f
C75 a_2861_3# a_2861_391# 0.01616f
C76 m2_7791_79# m2_1295_79# 0.05731f
C77 a_7083_63# a_2419_63# 0.01345f
C78 a_3498_3# m2_24_342# 0
C79 a_705_407# a_2861_3# 0
C80 a_8160_n37# a_7410_63# 0.01329f
C81 a_5042_407# a_5042_n37# 0.01726f
C82 a_6128_n37# a_6721_407# 0
C83 m2_6151_79# w_n310_281# 0.44301f
C84 a_2861_3# a_4290_63# 0
C85 a_6721_407# m2_6151_79# 0.4935f
C86 a_8723_63# a_2419_63# 0.00649f
C87 a_3498_3# a_2861_3# 0.09846f
C88 m2_5700_324# a_8918_357# 0
C89 a_9408_n37# a_9609_407# 0
C90 a_160_63# w_n310_281# 0.30515f
C91 a_6128_n37# a_5042_407# 0.00376f
C92 a_6721_407# w_n310_281# 0.72579f
C93 a_5042_407# m2_6151_79# 0.20459f
C94 a_1845_466# m2_24_342# 0.06999f
C95 m2_7791_79# a_4158_271# 0
C96 a_705_407# a_1262_n37# 0
C97 a_870_n37# a_510_63# 0.01502f
C98 a_7768_n37# m2_7791_79# 0.01733f
C99 a_5243_407# m2_1295_79# 0.10989f
C100 a_5042_407# w_n310_281# 0.29911f
C101 a_10363_63# a_8918_357# 0
C102 a_6128_n37# a_5768_63# 0.00935f
C103 a_6520_n37# m2_6151_79# 0.00766f
C104 a_5042_407# a_6721_407# 0.03265f
C105 a_9609_407# a_8918_357# 0.02942f
C106 a_2861_3# a_1845_466# 0
C107 m2_7791_79# a_7083_63# 0.14708f
C108 m2_6151_79# a_5768_63# 0.35511f
C109 a_3940_63# w_n310_281# 0.30087f
C110 w_n310_281# a_5768_63# 0.31314f
C111 m2_1295_79# a_8361_407# 0.02509f
C112 m2_7791_79# a_8723_63# 0.08381f
C113 a_6721_407# a_5768_63# 0.14017f
C114 a_4158_271# a_5243_407# 0.02964f
C115 a_2419_63# a_9050_63# 0.00801f
C116 m2_1295_79# a_378_271# 0.02669f
C117 a_6520_n37# a_5042_407# 0.00483f
C118 a_3940_63# a_5042_407# 0.0941f
C119 a_1262_n37# a_1845_466# 0
C120 a_5042_407# a_5768_63# 0.22596f
C121 m2_9431_79# w_n310_281# 0.46253f
C122 a_8160_n37# m2_7791_79# 0.01048f
C123 a_3498_3# a_7410_63# 0.11774f
C124 a_7410_63# m2_5700_324# 0.14432f
C125 a_6520_n37# a_5768_63# 0.01329f
C126 a_7768_n37# a_8361_407# 0
C127 a_3940_63# a_5768_63# 0
C128 a_2861_391# a_2419_63# 0.0163f
C129 a_4158_271# m2_1295_79# 0.16058f
C130 a_7083_63# a_8361_407# 0.01453f
C131 m2_1295_79# a_1845_n37# 0.00942f
C132 a_705_407# a_2419_63# 0
C133 a_10363_63# a_11480_63# 0
C134 a_11480_63# a_9609_407# 0
C135 a_11480_63# a_11922_3# 0.04054f
C136 m2_7791_79# a_9050_63# 0.00127f
C137 a_4290_63# a_2419_63# 0.00652f
C138 a_7083_63# m2_1295_79# 0.01071f
C139 a_8723_63# a_8361_407# 0.01268f
C140 a_3498_3# a_2419_63# 0.01177f
C141 a_2419_63# m2_5700_324# 0.074f
C142 a_11480_63# a_11922_391# 0.00152f
C143 a_8723_63# m2_1295_79# 0.00796f
C144 a_11922_3# a_12559_3# 0.0899f
C145 a_870_n37# a_1845_466# 0
C146 a_11480_63# a_10906_466# 0.1131f
C147 a_7083_63# a_4158_271# 1.09132f
C148 a_2419_63# a_10363_63# 0.00126f
C149 a_7768_n37# a_7083_63# 0.0028f
C150 a_1845_466# a_2419_63# 0.10509f
C151 a_2419_63# a_9609_407# 0
C152 a_2419_63# a_11922_3# 0.16984f
C153 a_510_63# a_378_271# 0.14298f
C154 m2_1295_79# a_510_63# 0.39896f
C155 a_8723_63# a_4158_271# 0
C156 a_10906_466# a_12559_3# 0
C157 a_160_63# m2_24_342# 0.42316f
C158 w_n310_281# m2_24_342# 0.66878f
C159 a_2419_63# a_11922_391# 0.00754f
C160 a_3498_3# m2_7791_79# 0.0296f
C161 m2_7791_79# m2_5700_324# 0.05245f
C162 a_8361_407# a_9050_63# 0
C163 a_8723_63# a_7083_63# 0.15796f
C164 w_n310_281# a_8918_357# 0.49453f
C165 a_2861_3# w_n310_281# 0.4655f
C166 a_2419_63# a_10906_466# 0.00833f
C167 m2_1295_79# a_9050_63# 0.00716f
C168 a_5243_407# a_4290_63# 0.14023f
C169 a_1845_n37# a_510_63# 0.0011f
C170 m2_7791_79# a_9609_407# 0
C171 a_8160_n37# a_7083_63# 0.00507f
C172 a_5042_407# a_2861_3# 0
C173 a_3498_3# a_5243_407# 0.16427f
C174 a_5243_407# m2_5700_324# 0.01927f
C175 a_4158_271# a_9050_63# 0.00717f
C176 m2_1295_79# a_2861_391# 0.00841f
C177 a_3940_63# a_2861_3# 0
C178 a_9408_n37# m2_9431_79# 0.01733f
C179 a_705_407# a_378_271# 0.02817f
C180 a_705_407# m2_1295_79# 0.30816f
C181 a_3498_3# a_8361_407# 0.12093f
C182 a_7083_63# a_9050_63# 0.21474f
C183 m2_1295_79# a_4290_63# 0.13519f
C184 a_8361_407# m2_5700_324# 0.05956f
C185 a_3498_3# m2_1295_79# 0.3391f
C186 m2_9431_79# a_8918_357# 0.03217f
C187 m2_6151_79# a_7410_63# 0
C188 m2_1295_79# m2_5700_324# 0.07849f
C189 a_8723_63# a_9050_63# 0.5277f
C190 a_11480_63# w_n310_281# 0.37298f
C191 a_7410_63# w_n310_281# 0.31086f
C192 a_8361_407# a_9609_407# 0.00466f
C193 a_4158_271# a_4290_63# 0.11363f
C194 m2_1295_79# a_10363_63# 0.00179f
C195 a_9800_n37# m2_9431_79# 0.0074f
C196 a_1845_466# a_378_271# 0.01278f
C197 m2_1295_79# a_1845_466# 0.09644f
C198 m2_1295_79# a_9609_407# 0.0093f
C199 a_12559_3# w_n310_281# 0.08598f
C200 m2_1295_79# a_11922_3# 0
C201 a_3498_3# a_4158_271# 0.00829f
C202 a_5042_407# a_7410_63# 0
C203 a_4158_271# m2_5700_324# 0.00861f
C204 m2_6151_79# a_2419_63# 0.05852f
C205 a_160_63# a_870_n37# 0.00441f
C206 a_10906_n37# a_4158_271# 0.00824f
C207 a_3498_3# a_7083_63# 0.01356f
C208 a_2419_63# w_n310_281# 0.75124f
C209 a_7083_63# m2_5700_324# 0.12051f
C210 a_6721_407# a_2419_63# 0.01825f
C211 a_4158_271# a_10363_63# 0.02222f
C212 m2_1295_79# a_10906_466# 0.0692f
C213 a_4158_271# a_9609_407# 0
C214 a_4158_271# a_11922_3# 0.0013f
C215 a_3498_3# a_8723_63# 0.00575f
C216 a_8723_63# m2_5700_324# 0
C217 a_1845_466# a_1845_n37# 0.01333f
C218 a_5042_407# a_2419_63# 0.08051f
C219 m2_9431_79# a_11480_63# 0
C220 a_7083_63# a_10363_63# 0.00582f
C221 m2_9431_79# a_7410_63# 0.00105f
C222 a_705_407# a_510_63# 0.13828f
C223 a_7083_63# a_9609_407# 0.0285f
C224 a_3940_63# a_2419_63# 0.00879f
C225 m2_7791_79# m2_6151_79# 0.00114f
C226 a_8723_63# a_10363_63# 0
C227 a_2419_63# a_5768_63# 0.07749f
C228 a_8723_63# a_9609_407# 0.0593f
C229 a_4158_271# a_10906_466# 0.03873f
C230 m2_7791_79# w_n310_281# 0.45143f
C231 a_5243_407# a_5042_n37# 0
C232 a_7083_63# a_10906_466# 0
C233 m2_9431_79# a_2419_63# 0.00832f
C234 a_4158_271# a_4650_n37# 0.00383f
C235 m2_7791_79# a_5042_407# 0.00555f
C236 a_1845_466# a_510_63# 0.01433f
C237 a_5243_407# w_n310_281# 0.78984f
C238 a_705_407# a_2861_391# 0
C239 m2_7791_79# a_5768_63# 0
C240 a_10363_63# a_9050_63# 0.01385f
C241 a_9609_407# a_9050_63# 0.1261f
C242 a_3498_3# a_2861_391# 0.00454f
C243 a_5243_407# a_5042_407# 0.29512f
C244 m2_1295_79# m2_6151_79# 0.00667f
C245 a_8361_407# w_n310_281# 0.75753f
C246 m2_7791_79# m2_9431_79# 0.01571f
C247 a_4158_271# a_5042_n37# 0
C248 a_3498_3# a_4290_63# 0.00876f
C249 a_160_63# a_378_271# 0.09182f
C250 w_n310_281# a_378_271# 0.63374f
C251 a_160_63# m2_1295_79# 0.09339f
C252 a_5243_407# a_3940_63# 0.06737f
C253 m2_1295_79# w_n310_281# 2.35223f
C254 a_4290_63# m2_5700_324# 0.01531f
C255 a_5243_407# a_5768_63# 0.00722f
C256 m2_1295_79# a_6721_407# 0.00452f
C257 a_7410_63# a_8918_357# 0
C258 a_3498_3# m2_5700_324# 0.55174f
C259 a_705_407# a_1845_466# 0.0126f
C260 m2_1295_79# a_5042_407# 0.03487f
C261 a_4158_271# m2_6151_79# 0.04334f
C262 a_2419_63# m2_24_342# 0.00234f
C263 a_4158_271# w_n310_281# 0.66883f
C264 a_3498_3# a_1845_466# 0.00105f
C265 m2_1295_79# a_3940_63# 0.46061f
C266 a_7083_63# m2_6151_79# 0.08089f
C267 w_n310_281# a_1845_n37# 0
C268 m2_1295_79# a_5768_63# 0.00766f
C269 a_2419_63# a_8918_357# 0.01449f
C270 a_10906_n37# a_10363_63# 0
C271 a_2861_3# a_2419_63# 0.21478f
C272 a_7083_63# w_n310_281# 0.31663f
C273 a_4158_271# a_5042_407# 0.63867f
C274 m2_9431_79# a_8361_407# 0
C275 a_7083_63# a_6721_407# 0.01268f
C276 a_10363_63# a_9609_407# 0.01306f
C277 a_8723_63# w_n310_281# 0.33516f
C278 m2_9431_79# m2_1295_79# 0.0078f
C279 a_6520_n37# a_4158_271# 0.00406f
C280 a_9408_n37# m2_7791_79# 0
C281 a_4158_271# a_3940_63# 0.16366f
C282 a_7083_63# a_5042_407# 0.02611f
C283 a_4158_271# a_5768_63# 0.00573f
C284 a_4290_63# a_4650_n37# 0.01502f
C285 a_11922_391# a_11922_3# 0.01891f
C286 a_6520_n37# a_7083_63# 0.00272f
C287 a_10906_n37# a_10906_466# 0.01333f
C288 a_7083_63# a_5768_63# 0.01494f
C289 a_160_63# a_510_63# 0.28903f
C290 w_n310_281# a_510_63# 0.28255f
C291 m2_7791_79# a_8918_357# 0.02763f
C292 a_10363_63# a_10906_466# 0.02047f
C293 m2_9431_79# a_4158_271# 0.05572f
C294 a_10906_466# a_9609_407# 0
C295 a_10906_466# a_11922_3# 0
C296 a_7768_n37# m2_9431_79# 0
C297 m2_9431_79# a_7083_63# 0.19293f
C298 a_2419_63# a_11480_63# 0.0769f
C299 w_n310_281# a_9050_63# 0.28931f
C300 a_7410_63# a_2419_63# 0.00801f
C301 m2_9431_79# a_8723_63# 0.13485f
C302 a_5243_407# a_2861_3# 0
C303 a_4158_271# via_dev$5_9/VSUBS 2.6385f
C304 a_7083_63# via_dev$5_9/VSUBS 0.86585f
C305 a_8723_63# via_dev$5_9/VSUBS 0.40969f
C306 m2_9431_79# via_dev$5_9/VSUBS 0.75255f
C307 m2_7791_79# via_dev$5_9/VSUBS 0.74612f
C308 a_8361_407# via_dev$5_9/VSUBS 0.05216f
C309 m2_6151_79# via_dev$5_9/VSUBS 0.72815f
C310 a_6721_407# via_dev$5_9/VSUBS 0.01698f
C311 a_5042_407# via_dev$5_9/VSUBS 0.88916f
C312 a_3940_63# via_dev$5_9/VSUBS 0.46864f
C313 m2_1295_79# via_dev$5_9/VSUBS 3.34416f
C314 a_160_63# via_dev$5_9/VSUBS 0.5921f
C315 a_5243_407# via_dev$5_9/VSUBS 0.01661f
C316 a_705_407# via_dev$5_9/VSUBS 0.13677f
C317 a_3498_3# via_dev$5_9/VSUBS 1.27724f
C318 a_10906_n37# via_dev$5_9/VSUBS 0.02232f
C319 a_9800_n37# via_dev$5_9/VSUBS 0.01742f
C320 a_9408_n37# via_dev$5_9/VSUBS 0.007f
C321 a_8160_n37# via_dev$5_9/VSUBS 0.01743f
C322 a_7768_n37# via_dev$5_9/VSUBS 0.007f
C323 a_6520_n37# via_dev$5_9/VSUBS 0.01743f
C324 a_6128_n37# via_dev$5_9/VSUBS 0.007f
C325 a_5042_n37# via_dev$5_9/VSUBS 0.00833f
C326 a_4650_n37# via_dev$5_9/VSUBS 0.01565f
C327 a_12559_3# via_dev$5_9/VSUBS 0.19481f
C328 a_11922_3# via_dev$5_9/VSUBS 0.64569f
C329 a_11922_391# via_dev$5_9/VSUBS 0.00119f
C330 a_10906_466# via_dev$5_9/VSUBS 0.59796f
C331 a_11480_63# via_dev$5_9/VSUBS 0.42359f
C332 a_10363_63# via_dev$5_9/VSUBS 0.13924f
C333 a_9050_63# via_dev$5_9/VSUBS 0.53264f
C334 a_8918_357# via_dev$5_9/VSUBS 0.52045f
C335 a_7410_63# via_dev$5_9/VSUBS 0.53731f
C336 a_5768_63# via_dev$5_9/VSUBS 0.54f
C337 a_1845_n37# via_dev$5_9/VSUBS 0.01974f
C338 a_1262_n37# via_dev$5_9/VSUBS 0.0069f
C339 a_870_n37# via_dev$5_9/VSUBS 0.01517f
C340 a_4290_63# via_dev$5_9/VSUBS 0.57048f
C341 a_2861_3# via_dev$5_9/VSUBS 0.62907f
C342 a_1845_466# via_dev$5_9/VSUBS 0.59853f
C343 a_2419_63# via_dev$5_9/VSUBS 6.64114f
C344 a_510_63# via_dev$5_9/VSUBS 0.55998f
C345 a_378_271# via_dev$5_9/VSUBS 1.37769f
C346 w_n310_281# via_dev$5_9/VSUBS 27.06926f
C347 a_9609_407# via_dev$5_9/VSUBS 0.11967f
C348 m2_24_342# via_dev$5_9/VSUBS 1.98211f
C349 m2_5700_324# via_dev$5_9/VSUBS 1.14834f
.ends

.subckt x1bitblock$1 a_2861_3# a_8361_407# a_6520_n37# a_1262_n37# a_2861_391# m2_24_342#
+ a_1845_466# a_10906_n37# a_510_63# a_870_n37# a_6721_407# a_9800_n37# a_11480_63#
+ a_6128_n37# a_5768_63# m2_6151_79# a_3498_3# a_11922_391# a_5042_n37# a_9408_n37#
+ a_9609_407# a_5042_407# a_8160_n37# a_4158_271# a_11922_3# a_2419_63# m2_9431_79#
+ a_10906_466# a_4650_n37# m2_1295_79# a_9050_63# a_5243_407# a_7768_n37# a_160_63#
+ a_3940_63# a_8919_370# m2_7791_79# a_10363_63# a_4290_63# a_7083_63# a_705_407#
+ a_12559_3# a_7410_63# m2_5700_324# a_1845_n37# via_dev$5$1_9/VSUBS a_8723_63# a_378_271#
+ w_n310_281#
X0 a_2419_63# a_1845_466# via_dev$5$1_9/VSUBS via_dev$5$1_9/VSUBS nfet_03v3 ad=0.315p pd=2.26u as=0.2425p ps=1.97u w=0.5u l=0.28u
X1 a_1845_466# m2_24_342# a_1845_n37# via_dev$5$1_9/VSUBS nfet_03v3 ad=0.65p pd=3.3u as=0.42p ps=1.84u w=1u l=0.28u
X2 a_3940_63# m2_1295_79# w_n310_281# w_n310_281# pfet_03v3 ad=0.63p pd=3.26u as=0.65p ps=3.3u w=1u l=0.28u
X3 via_dev$5$1_9/VSUBS a_510_63# a_1262_n37# via_dev$5$1_9/VSUBS nfet_03v3 ad=0.65p pd=3.3u as=0.3625p ps=1.725u w=1u l=0.28u
X4 a_5243_407# a_4290_63# a_5042_407# w_n310_281# pfet_03v3 ad=1.3p pd=5.3u as=0.725p ps=2.725u w=2u l=0.28u
X5 a_6721_407# a_2419_63# m2_6151_79# w_n310_281# pfet_03v3 ad=0.675p pd=2.675u as=0.725p ps=2.725u w=2u l=0.28u
X6 a_10906_466# a_4158_271# w_n310_281# w_n310_281# pfet_03v3 ad=0.42p pd=1.84u as=0.65p ps=3.3u w=1u l=0.28u
X7 a_4290_63# a_4158_271# via_dev$5$1_9/VSUBS via_dev$5$1_9/VSUBS nfet_03v3 ad=0.315p pd=2.26u as=0.28p ps=2.12u w=0.5u l=0.28u
X8 w_n310_281# a_378_271# a_705_407# w_n310_281# pfet_03v3 ad=0.725p pd=2.725u as=1.09p ps=5.09u w=2u l=0.28u
X9 a_2861_3# m2_1295_79# via_dev$5$1_9/VSUBS via_dev$5$1_9/VSUBS nfet_03v3 ad=0.18125p pd=1.225u as=0.325p ps=2.3u w=0.5u l=0.28u
X10 via_dev$5$1_9/VSUBS a_2419_63# a_2861_3# via_dev$5$1_9/VSUBS nfet_03v3 ad=0.315p pd=2.26u as=0.18125p ps=1.225u w=0.5u l=0.28u
X11 m2_7791_79# m2_1295_79# a_7768_n37# via_dev$5$1_9/VSUBS nfet_03v3 ad=0.3375p pd=1.675u as=0.3625p ps=1.725u w=1u l=0.28u
X12 a_10906_n37# a_4158_271# via_dev$5$1_9/VSUBS via_dev$5$1_9/VSUBS nfet_03v3 ad=0.42p pd=1.84u as=0.63p ps=3.26u w=1u l=0.28u
X13 a_9050_63# a_8919_370# via_dev$5$1_9/VSUBS via_dev$5$1_9/VSUBS nfet_03v3 ad=0.31p pd=2.24u as=0.24p ps=1.96u w=0.5u l=0.28u
X14 a_11922_3# a_11480_63# via_dev$5$1_9/VSUBS via_dev$5$1_9/VSUBS nfet_03v3 ad=0.18125p pd=1.225u as=0.325p ps=2.3u w=0.5u l=0.28u
X15 via_dev$5$1_9/VSUBS a_2419_63# a_11922_3# via_dev$5$1_9/VSUBS nfet_03v3 ad=0.315p pd=2.26u as=0.18125p ps=1.225u w=0.5u l=0.28u
X16 a_705_407# a_510_63# m2_1295_79# w_n310_281# pfet_03v3 ad=1.3p pd=5.3u as=0.725p ps=2.725u w=2u l=0.28u
X17 a_4650_n37# a_4158_271# via_dev$5$1_9/VSUBS via_dev$5$1_9/VSUBS nfet_03v3 ad=0.3625p pd=1.725u as=0.54p ps=3.08u w=1u l=0.28u
X18 a_2861_3# a_2419_63# a_2861_391# w_n310_281# pfet_03v3 ad=1.3p pd=5.3u as=0.725p ps=2.725u w=2u l=0.28u
X19 a_5768_63# m2_5700_324# via_dev$5$1_9/VSUBS via_dev$5$1_9/VSUBS nfet_03v3 ad=0.315p pd=2.26u as=0.3175p ps=2.27u w=0.5u l=0.28u
X20 via_dev$5$1_9/VSUBS a_9050_63# a_9800_n37# via_dev$5$1_9/VSUBS nfet_03v3 ad=0.65p pd=3.3u as=0.3625p ps=1.725u w=1u l=0.28u
X21 a_8361_407# m2_1295_79# m2_7791_79# w_n310_281# pfet_03v3 ad=0.675p pd=2.675u as=0.725p ps=2.725u w=2u l=0.28u
X22 a_9408_n37# a_8919_370# via_dev$5$1_9/VSUBS via_dev$5$1_9/VSUBS nfet_03v3 ad=0.3625p pd=1.725u as=0.54p ps=3.08u w=1u l=0.28u
X23 a_3498_3# a_2861_3# w_n310_281# w_n310_281# pfet_03v3 ad=0.65p pd=3.3u as=0.675p ps=3.35u w=1u l=0.28u
X24 a_7410_63# m2_5700_324# via_dev$5$1_9/VSUBS via_dev$5$1_9/VSUBS nfet_03v3 ad=0.31p pd=2.24u as=0.24p ps=1.96u w=0.5u l=0.28u
X25 via_dev$5$1_9/VSUBS a_7410_63# a_8160_n37# via_dev$5$1_9/VSUBS nfet_03v3 ad=0.65p pd=3.3u as=0.3625p ps=1.725u w=1u l=0.28u
X26 a_8723_63# m2_7791_79# via_dev$5$1_9/VSUBS via_dev$5$1_9/VSUBS nfet_03v3 ad=0.2625p pd=2.05u as=0.265p ps=2.06u w=0.5u l=0.28u
X27 w_n310_281# a_4158_271# a_5243_407# w_n310_281# pfet_03v3 ad=0.725p pd=2.725u as=1.09p ps=5.09u w=2u l=0.28u
X28 a_5768_63# m2_5700_324# w_n310_281# w_n310_281# pfet_03v3 ad=0.65p pd=3.3u as=0.635p ps=3.27u w=1u l=0.28u
X29 a_9050_63# a_8919_370# w_n310_281# w_n310_281# pfet_03v3 ad=0.64p pd=3.28u as=0.48p ps=2.96u w=1u l=0.28u
X30 a_11922_391# a_11480_63# w_n310_281# w_n310_281# pfet_03v3 ad=0.725p pd=2.725u as=1.3p ps=5.3u w=2u l=0.28u
X31 a_160_63# m2_24_342# via_dev$5$1_9/VSUBS via_dev$5$1_9/VSUBS nfet_03v3 ad=0.315p pd=2.26u as=0.325p ps=2.3u w=0.5u l=0.28u
X32 a_9609_407# a_9050_63# w_n310_281# w_n310_281# pfet_03v3 ad=1.3p pd=5.3u as=0.725p ps=2.725u w=2u l=0.28u
X33 a_6128_n37# m2_5700_324# via_dev$5$1_9/VSUBS via_dev$5$1_9/VSUBS nfet_03v3 ad=0.3625p pd=1.725u as=0.54p ps=3.08u w=1u l=0.28u
X34 via_dev$5$1_9/VSUBS a_5768_63# a_6520_n37# via_dev$5$1_9/VSUBS nfet_03v3 ad=0.65p pd=3.3u as=0.3625p ps=1.725u w=1u l=0.28u
X35 a_7410_63# m2_5700_324# w_n310_281# w_n310_281# pfet_03v3 ad=0.64p pd=3.28u as=0.48p ps=2.96u w=1u l=0.28u
X36 m2_9431_79# a_8919_370# a_9609_407# w_n310_281# pfet_03v3 ad=0.725p pd=2.725u as=1.09p ps=5.09u w=2u l=0.28u
X37 a_11480_63# a_10906_466# via_dev$5$1_9/VSUBS via_dev$5$1_9/VSUBS nfet_03v3 ad=0.315p pd=2.26u as=0.2425p ps=1.97u w=0.5u l=0.28u
X38 a_1845_466# a_378_271# w_n310_281# w_n310_281# pfet_03v3 ad=0.42p pd=1.84u as=0.65p ps=3.3u w=1u l=0.28u
X39 a_8361_407# a_7410_63# w_n310_281# w_n310_281# pfet_03v3 ad=1.3p pd=5.3u as=0.725p ps=2.725u w=2u l=0.28u
X40 w_n310_281# m2_1295_79# a_10906_466# w_n310_281# pfet_03v3 ad=0.735p pd=2.47u as=0.42p ps=1.84u w=1u l=0.28u
X41 a_7083_63# m2_6151_79# via_dev$5$1_9/VSUBS via_dev$5$1_9/VSUBS nfet_03v3 ad=0.2625p pd=2.05u as=0.265p ps=2.06u w=0.5u l=0.28u
X42 a_510_63# a_378_271# w_n310_281# w_n310_281# pfet_03v3 ad=0.65p pd=3.3u as=0.56p ps=3.12u w=1u l=0.28u
X43 a_10363_63# m2_9431_79# w_n310_281# w_n310_281# pfet_03v3 ad=0.715p pd=3.43u as=0.53p ps=3.06u w=1u l=0.28u
X44 a_510_63# a_378_271# via_dev$5$1_9/VSUBS via_dev$5$1_9/VSUBS nfet_03v3 ad=0.315p pd=2.26u as=0.28p ps=2.12u w=0.5u l=0.28u
X45 a_1262_n37# a_160_63# m2_1295_79# via_dev$5$1_9/VSUBS nfet_03v3 ad=0.3625p pd=1.725u as=0.3375p ps=1.675u w=1u l=0.28u
X46 a_1845_n37# a_378_271# via_dev$5$1_9/VSUBS via_dev$5$1_9/VSUBS nfet_03v3 ad=0.42p pd=1.84u as=0.63p ps=3.26u w=1u l=0.28u
X47 m2_6151_79# m2_5700_324# a_6721_407# w_n310_281# pfet_03v3 ad=0.725p pd=2.725u as=1.09p ps=5.09u w=2u l=0.28u
X48 a_6721_407# a_5768_63# w_n310_281# w_n310_281# pfet_03v3 ad=1.3p pd=5.3u as=0.725p ps=2.725u w=2u l=0.28u
X49 a_10363_63# m2_9431_79# via_dev$5$1_9/VSUBS via_dev$5$1_9/VSUBS nfet_03v3 ad=0.3575p pd=2.43u as=0.265p ps=2.06u w=0.5u l=0.28u
X50 a_10906_466# m2_1295_79# a_10906_n37# via_dev$5$1_9/VSUBS nfet_03v3 ad=0.65p pd=3.3u as=0.42p ps=1.84u w=1u l=0.28u
X51 a_8723_63# m2_7791_79# w_n310_281# w_n310_281# pfet_03v3 ad=0.545p pd=3.09u as=0.53p ps=3.06u w=1u l=0.28u
X52 a_11480_63# a_10906_466# w_n310_281# w_n310_281# pfet_03v3 ad=0.65p pd=3.3u as=0.735p ps=2.47u w=1u l=0.28u
X53 a_12559_3# a_11922_3# via_dev$5$1_9/VSUBS via_dev$5$1_9/VSUBS nfet_03v3 ad=0.315p pd=2.26u as=0.325p ps=2.3u w=0.5u l=0.28u
X54 a_7083_63# m2_6151_79# w_n310_281# w_n310_281# pfet_03v3 ad=0.545p pd=3.09u as=0.53p ps=3.06u w=1u l=0.28u
X55 a_7768_n37# m2_5700_324# via_dev$5$1_9/VSUBS via_dev$5$1_9/VSUBS nfet_03v3 ad=0.3625p pd=1.725u as=0.54p ps=3.08u w=1u l=0.28u
X56 a_160_63# m2_24_342# w_n310_281# w_n310_281# pfet_03v3 ad=0.63p pd=3.26u as=0.65p ps=3.3u w=1u l=0.28u
X57 m2_1295_79# a_160_63# a_705_407# w_n310_281# pfet_03v3 ad=0.725p pd=2.725u as=0.675p ps=2.675u w=2u l=0.28u
X58 a_5042_n37# a_3940_63# a_5042_407# via_dev$5$1_9/VSUBS nfet_03v3 ad=0.3625p pd=1.725u as=0.3375p ps=1.675u w=1u l=0.28u
X59 m2_1295_79# m2_24_342# a_870_n37# via_dev$5$1_9/VSUBS nfet_03v3 ad=0.3375p pd=1.675u as=0.3625p ps=1.725u w=1u l=0.28u
X60 a_11922_3# a_2419_63# a_11922_391# w_n310_281# pfet_03v3 ad=1.3p pd=5.3u as=0.725p ps=2.725u w=2u l=0.28u
X61 a_9800_n37# a_7083_63# m2_9431_79# via_dev$5$1_9/VSUBS nfet_03v3 ad=0.3625p pd=1.725u as=0.3375p ps=1.675u w=1u l=0.28u
X62 m2_7791_79# m2_5700_324# a_8361_407# w_n310_281# pfet_03v3 ad=0.725p pd=2.725u as=1.09p ps=5.09u w=2u l=0.28u
X63 a_5042_407# a_3940_63# a_5243_407# w_n310_281# pfet_03v3 ad=0.725p pd=2.725u as=0.675p ps=2.675u w=2u l=0.28u
X64 a_3940_63# m2_1295_79# via_dev$5$1_9/VSUBS via_dev$5$1_9/VSUBS nfet_03v3 ad=0.315p pd=2.26u as=0.325p ps=2.3u w=0.5u l=0.28u
X65 a_8160_n37# a_3498_3# m2_7791_79# via_dev$5$1_9/VSUBS nfet_03v3 ad=0.3625p pd=1.725u as=0.3375p ps=1.675u w=1u l=0.28u
X66 a_705_407# m2_24_342# w_n310_281# w_n310_281# pfet_03v3 ad=0.675p pd=2.675u as=0.725p ps=2.725u w=2u l=0.28u
X67 a_5042_407# m2_1295_79# a_4650_n37# via_dev$5$1_9/VSUBS nfet_03v3 ad=0.3375p pd=1.675u as=0.3625p ps=1.725u w=1u l=0.28u
X68 a_6520_n37# a_5042_407# m2_6151_79# via_dev$5$1_9/VSUBS nfet_03v3 ad=0.3625p pd=1.725u as=0.3375p ps=1.675u w=1u l=0.28u
X69 w_n310_281# a_7083_63# a_9609_407# w_n310_281# pfet_03v3 ad=0.725p pd=2.725u as=0.675p ps=2.675u w=2u l=0.28u
X70 a_2419_63# a_1845_466# w_n310_281# w_n310_281# pfet_03v3 ad=0.65p pd=3.3u as=0.735p ps=2.47u w=1u l=0.28u
X71 m2_9431_79# a_8723_63# a_9408_n37# via_dev$5$1_9/VSUBS nfet_03v3 ad=0.3375p pd=1.675u as=0.3625p ps=1.725u w=1u l=0.28u
X72 w_n310_281# a_3498_3# a_8361_407# w_n310_281# pfet_03v3 ad=0.725p pd=2.725u as=0.675p ps=2.675u w=2u l=0.28u
X73 a_2861_391# m2_1295_79# w_n310_281# w_n310_281# pfet_03v3 ad=0.725p pd=2.725u as=1.3p ps=5.3u w=2u l=0.28u
X74 a_4290_63# a_4158_271# w_n310_281# w_n310_281# pfet_03v3 ad=0.65p pd=3.3u as=0.56p ps=3.12u w=1u l=0.28u
X75 a_5243_407# m2_1295_79# w_n310_281# w_n310_281# pfet_03v3 ad=0.675p pd=2.675u as=0.725p ps=2.725u w=2u l=0.28u
X76 w_n310_281# a_5042_407# a_6721_407# w_n310_281# pfet_03v3 ad=0.725p pd=2.725u as=0.675p ps=2.675u w=2u l=0.28u
X77 a_3498_3# a_2861_3# via_dev$5$1_9/VSUBS via_dev$5$1_9/VSUBS nfet_03v3 ad=0.315p pd=2.26u as=0.325p ps=2.3u w=0.5u l=0.28u
X78 a_9609_407# a_8723_63# m2_9431_79# w_n310_281# pfet_03v3 ad=0.675p pd=2.675u as=0.725p ps=2.725u w=2u l=0.28u
X79 via_dev$5$1_9/VSUBS a_4290_63# a_5042_n37# via_dev$5$1_9/VSUBS nfet_03v3 ad=0.65p pd=3.3u as=0.3625p ps=1.725u w=1u l=0.28u
X80 m2_6151_79# a_2419_63# a_6128_n37# via_dev$5$1_9/VSUBS nfet_03v3 ad=0.3375p pd=1.675u as=0.3625p ps=1.725u w=1u l=0.28u
X81 w_n310_281# m2_24_342# a_1845_466# w_n310_281# pfet_03v3 ad=0.735p pd=2.47u as=0.42p ps=1.84u w=1u l=0.28u
X82 a_870_n37# a_378_271# via_dev$5$1_9/VSUBS via_dev$5$1_9/VSUBS nfet_03v3 ad=0.3625p pd=1.725u as=0.54p ps=3.08u w=1u l=0.28u
X83 a_12559_3# a_11922_3# w_n310_281# w_n310_281# pfet_03v3 ad=0.65p pd=3.3u as=0.675p ps=3.35u w=1u l=0.28u
C0 a_4158_271# a_4650_n37# 0.00383f
C1 a_7083_63# a_4158_271# 1.09133f
C2 a_11480_63# w_n310_281# 0.37298f
C3 a_11480_63# a_11922_3# 0.04054f
C4 a_8723_63# a_4158_271# 0
C5 a_11480_63# a_11922_391# 0.00152f
C6 m2_7791_79# a_8919_370# 0.02774f
C7 a_8723_63# a_7083_63# 0.15796f
C8 a_160_63# a_1845_466# 0
C9 a_11480_63# a_10906_466# 0.1131f
C10 a_4158_271# a_5042_n37# 0
C11 a_4158_271# a_11480_63# 0.00295f
C12 a_1845_n37# a_1845_466# 0.01333f
C13 m2_7791_79# a_9050_63# 0.00127f
C14 a_3940_63# a_1845_466# 0
C15 w_n310_281# a_1845_466# 0.44517f
C16 a_5768_63# a_6128_n37# 0.00935f
C17 m2_7791_79# a_7768_n37# 0.01733f
C18 a_510_63# a_1845_466# 0.01433f
C19 a_8919_370# w_n310_281# 0.50001f
C20 m2_7791_79# a_7410_63# 0.36168f
C21 a_9050_63# a_9408_n37# 0.00935f
C22 m2_6151_79# a_7410_63# 0
C23 m2_7791_79# a_2419_63# 0.00843f
C24 m2_6151_79# a_2419_63# 0.05852f
C25 a_5042_407# a_7410_63# 0
C26 a_6721_407# a_2419_63# 0.01825f
C27 a_9050_63# w_n310_281# 0.28931f
C28 a_4158_271# a_8919_370# 0.001f
C29 a_5768_63# a_6520_n37# 0.01329f
C30 m2_7791_79# a_8160_n37# 0.01048f
C31 a_9050_63# a_9800_n37# 0.01329f
C32 a_5042_407# a_2419_63# 0.08051f
C33 a_7083_63# a_8919_370# 0.01057f
C34 a_7410_63# w_n310_281# 0.31086f
C35 a_3940_63# a_2419_63# 0.00879f
C36 m2_7791_79# a_9609_407# 0
C37 a_870_n37# a_1845_466# 0
C38 a_160_63# m2_24_342# 0.42316f
C39 a_8723_63# a_8919_370# 0.12581f
C40 w_n310_281# a_2419_63# 0.75141f
C41 m2_6151_79# a_4290_63# 0
C42 a_11922_3# a_2419_63# 0.16984f
C43 a_4158_271# a_9050_63# 0.00717f
C44 m2_7791_79# a_8361_407# 0.49779f
C45 a_9609_407# a_9408_n37# 0
C46 m2_7791_79# m2_1295_79# 0.05731f
C47 a_11922_391# a_2419_63# 0.00754f
C48 a_5243_407# a_5042_407# 0.29512f
C49 a_7083_63# a_9050_63# 0.21474f
C50 m2_1295_79# m2_6151_79# 0.00667f
C51 a_4158_271# a_7410_63# 0
C52 a_5042_407# a_4290_63# 0.38112f
C53 a_160_63# m2_1295_79# 0.09339f
C54 a_5243_407# a_3940_63# 0.06737f
C55 a_10906_466# a_2419_63# 0.00833f
C56 a_8723_63# a_9050_63# 0.53121f
C57 w_n310_281# m2_24_342# 0.66878f
C58 a_7083_63# a_7768_n37# 0.0028f
C59 m2_1295_79# a_6721_407# 0.00452f
C60 a_7083_63# a_7410_63# 0.07718f
C61 a_5243_407# w_n310_281# 0.78984f
C62 a_4158_271# a_2419_63# 0.14782f
C63 a_510_63# m2_24_342# 0.13025f
C64 a_3940_63# a_4290_63# 0.28903f
C65 m2_7791_79# a_5768_63# 0
C66 a_9609_407# w_n310_281# 0.7653f
C67 w_n310_281# a_2861_391# 0.03535f
C68 m2_6151_79# a_5768_63# 0.35511f
C69 w_n310_281# a_4290_63# 0.2819f
C70 m2_1295_79# a_5042_407# 0.03487f
C71 a_8723_63# a_7410_63# 0.01398f
C72 m2_7791_79# a_3498_3# 0.0296f
C73 a_7083_63# a_2419_63# 0.01345f
C74 a_160_63# a_705_407# 0.06737f
C75 m2_1295_79# a_1845_n37# 0.00942f
C76 m2_6151_79# a_3498_3# 0
C77 a_8361_407# w_n310_281# 0.75753f
C78 m2_1295_79# a_3940_63# 0.46061f
C79 a_6721_407# a_5768_63# 0.14017f
C80 a_8723_63# a_2419_63# 0.00661f
C81 m2_1295_79# w_n310_281# 2.35219f
C82 a_6721_407# a_3498_3# 0
C83 m2_1295_79# a_11922_3# 0
C84 m2_7791_79# m2_9431_79# 0.01571f
C85 a_4158_271# a_5243_407# 0.02964f
C86 a_5042_407# a_5768_63# 0.22596f
C87 m2_1295_79# a_510_63# 0.39896f
C88 a_9609_407# a_10906_466# 0
C89 a_1262_n37# a_510_63# 0.00898f
C90 a_7083_63# a_8160_n37# 0.00507f
C91 a_5042_407# a_3498_3# 0.02015f
C92 a_4158_271# a_9609_407# 0
C93 a_160_63# a_378_271# 0.09182f
C94 a_4158_271# a_4290_63# 0.11363f
C95 a_2861_3# a_5042_407# 0
C96 a_3940_63# a_5768_63# 0
C97 w_n310_281# a_705_407# 0.79414f
C98 m2_7791_79# m2_5700_324# 0.05245f
C99 m2_9431_79# a_9408_n37# 0.01733f
C100 a_11480_63# a_2419_63# 0.0769f
C101 a_5768_63# w_n310_281# 0.31314f
C102 m2_6151_79# m2_5700_324# 0.14941f
C103 a_3940_63# a_3498_3# 0.04602f
C104 a_7083_63# a_9609_407# 0.0285f
C105 a_4650_n37# a_4290_63# 0.01502f
C106 a_510_63# a_705_407# 0.13828f
C107 m2_1295_79# a_10906_466# 0.0692f
C108 a_2861_3# a_3940_63# 0
C109 w_n310_281# a_3498_3# 1.03377f
C110 a_4158_271# m2_1295_79# 0.16058f
C111 a_2861_3# w_n310_281# 0.4655f
C112 a_6721_407# m2_5700_324# 0.50857f
C113 a_12559_3# w_n310_281# 0.08598f
C114 a_7083_63# a_8361_407# 0.01453f
C115 a_8723_63# a_9609_407# 0.0593f
C116 a_11922_3# a_12559_3# 0.0899f
C117 w_n310_281# a_10906_n37# 0
C118 a_7083_63# m2_1295_79# 0.01071f
C119 a_5042_407# m2_5700_324# 0.06917f
C120 a_10363_63# w_n310_281# 0.15741f
C121 a_378_271# w_n310_281# 0.6337f
C122 a_8723_63# a_8361_407# 0.01268f
C123 m2_9431_79# w_n310_281# 0.46254f
C124 a_5243_407# a_5042_n37# 0
C125 a_378_271# a_510_63# 0.14298f
C126 a_4158_271# a_5768_63# 0.00573f
C127 a_8723_63# m2_1295_79# 0.00803f
C128 a_3940_63# m2_5700_324# 0.00132f
C129 a_8919_370# a_9050_63# 0.10006f
C130 m2_9431_79# a_9800_n37# 0.0074f
C131 m2_1295_79# a_870_n37# 0.00639f
C132 a_9609_407# a_11480_63# 0
C133 a_10906_466# a_12559_3# 0
C134 a_4158_271# a_3498_3# 0.00829f
C135 a_5042_n37# a_4290_63# 0.00898f
C136 w_n310_281# m2_5700_324# 1.65678f
C137 a_7083_63# a_5768_63# 0.01494f
C138 a_10906_466# a_10906_n37# 0.01333f
C139 a_8919_370# a_7410_63# 0
C140 a_10906_466# a_10363_63# 0.02047f
C141 a_4158_271# a_10906_n37# 0.00824f
C142 a_7083_63# a_3498_3# 0.01356f
C143 m2_9431_79# a_10906_466# 0.00167f
C144 a_2419_63# a_1845_466# 0.10509f
C145 a_4158_271# a_10363_63# 0.02222f
C146 m2_1295_79# a_11480_63# 0.00126f
C147 m2_9431_79# a_4158_271# 0.05572f
C148 a_8723_63# a_3498_3# 0.00575f
C149 a_8919_370# a_2419_63# 0.01445f
C150 a_7083_63# a_10363_63# 0.00582f
C151 m2_9431_79# a_7083_63# 0.19293f
C152 a_4158_271# m2_5700_324# 0.00861f
C153 m2_6151_79# a_6128_n37# 0.01733f
C154 a_8723_63# a_10363_63# 0
C155 m2_9431_79# a_8723_63# 0.13485f
C156 m2_24_342# a_1845_466# 0.06999f
C157 a_7083_63# m2_5700_324# 0.12051f
C158 a_6721_407# a_6128_n37# 0
C159 a_7410_63# a_7768_n37# 0.00935f
C160 a_9050_63# a_2419_63# 0.00801f
C161 a_8723_63# m2_5700_324# 0
C162 a_8919_370# a_9609_407# 0.02942f
C163 a_5042_407# a_6128_n37# 0.00376f
C164 a_11480_63# a_10363_63# 0
C165 m2_9431_79# a_11480_63# 0
C166 a_7410_63# a_2419_63# 0.00801f
C167 a_1262_n37# a_1845_466# 0
C168 m2_1295_79# a_1845_466# 0.09644f
C169 a_8919_370# a_8361_407# 0
C170 m2_6151_79# a_6520_n37# 0.00766f
C171 a_8919_370# m2_1295_79# 0.01372f
C172 a_7410_63# a_8160_n37# 0.01329f
C173 a_705_407# a_1845_466# 0.0126f
C174 a_9609_407# a_9050_63# 0.1261f
C175 a_5042_407# a_6520_n37# 0.00483f
C176 a_3498_3# a_1845_466# 0.00105f
C177 a_8361_407# a_9050_63# 0
C178 a_2861_3# a_1845_466# 0
C179 m2_24_342# a_2419_63# 0.00234f
C180 m2_1295_79# a_9050_63# 0.00716f
C181 a_5243_407# a_2419_63# 0
C182 a_8361_407# a_7768_n37# 0
C183 a_8361_407# a_7410_63# 0.1423f
C184 a_9609_407# a_2419_63# 0
C185 a_378_271# a_1845_466# 0.01278f
C186 a_2419_63# a_2861_391# 0.0163f
C187 a_2419_63# a_4290_63# 0.00652f
C188 m2_1295_79# a_7410_63# 0.07614f
C189 a_8919_370# a_10363_63# 0
C190 m2_9431_79# a_8919_370# 0.03216f
C191 a_8361_407# a_2419_63# 0
C192 m2_7791_79# m2_6151_79# 0.00114f
C193 m2_1295_79# a_2419_63# 0.32461f
C194 a_8919_370# m2_5700_324# 0
C195 a_4158_271# a_6520_n37# 0.00406f
C196 m2_7791_79# a_9408_n37# 0
C197 a_5243_407# a_4290_63# 0.14023f
C198 a_6721_407# m2_6151_79# 0.4935f
C199 a_7410_63# a_3498_3# 0.11774f
C200 a_2419_63# a_705_407# 0
C201 a_10363_63# a_9050_63# 0.01385f
C202 m2_9431_79# a_9050_63# 0.328f
C203 a_7083_63# a_6520_n37# 0.00272f
C204 m2_7791_79# a_5042_407# 0.00555f
C205 a_5768_63# a_2419_63# 0.07749f
C206 a_5042_407# m2_6151_79# 0.20459f
C207 m2_1295_79# m2_24_342# 0.04399f
C208 a_2419_63# a_3498_3# 0.01177f
C209 a_8361_407# a_9609_407# 0.00466f
C210 a_5243_407# m2_1295_79# 0.10989f
C211 m2_9431_79# a_7768_n37# 0
C212 a_2861_3# a_2419_63# 0.21478f
C213 a_12559_3# a_2419_63# 0
C214 m2_9431_79# a_7410_63# 0.00105f
C215 a_5042_407# a_6721_407# 0.03265f
C216 m2_1295_79# a_9609_407# 0.0093f
C217 m2_7791_79# w_n310_281# 0.45139f
C218 m2_1295_79# a_2861_391# 0.00841f
C219 m2_1295_79# a_4290_63# 0.13519f
C220 m2_6151_79# w_n310_281# 0.44301f
C221 a_10363_63# a_2419_63# 0.00126f
C222 m2_24_342# a_705_407# 0.10607f
C223 m2_9431_79# a_2419_63# 0.00832f
C224 m2_1295_79# a_8361_407# 0.02509f
C225 a_7410_63# m2_5700_324# 0.14432f
C226 a_160_63# w_n310_281# 0.30515f
C227 a_5243_407# a_5768_63# 0.00722f
C228 a_6721_407# w_n310_281# 0.72579f
C229 m2_24_342# a_3498_3# 0
C230 m2_1295_79# a_1262_n37# 0.01607f
C231 a_160_63# a_510_63# 0.28903f
C232 a_705_407# a_2861_391# 0
C233 a_5243_407# a_3498_3# 0.16427f
C234 a_3940_63# a_5042_407# 0.0941f
C235 a_2419_63# m2_5700_324# 0.074f
C236 a_5768_63# a_4290_63# 0.01093f
C237 a_2861_3# a_5243_407# 0
C238 a_5042_407# w_n310_281# 0.29911f
C239 a_3498_3# a_2861_391# 0.00454f
C240 a_3498_3# a_4290_63# 0.00876f
C241 a_1845_n37# w_n310_281# 0
C242 m2_9431_79# a_8160_n37# 0
C243 m2_7791_79# a_4158_271# 0
C244 a_2861_3# a_2861_391# 0.01616f
C245 a_2861_3# a_4290_63# 0
C246 a_378_271# m2_24_342# 0.56715f
C247 a_4158_271# m2_6151_79# 0.04334f
C248 m2_1295_79# a_705_407# 0.30816f
C249 a_1262_n37# a_705_407# 0
C250 a_1845_n37# a_510_63# 0.0011f
C251 a_3940_63# w_n310_281# 0.30087f
C252 a_8361_407# a_3498_3# 0.12093f
C253 m2_1295_79# a_5768_63# 0.00766f
C254 m2_7791_79# a_7083_63# 0.14708f
C255 a_9609_407# a_10363_63# 0.01306f
C256 a_11922_3# w_n310_281# 0.46598f
C257 a_7083_63# m2_6151_79# 0.08089f
C258 m2_1295_79# a_3498_3# 0.3391f
C259 m2_9431_79# a_9609_407# 0.49779f
C260 a_510_63# w_n310_281# 0.28255f
C261 a_2861_3# m2_1295_79# 0.15381f
C262 a_5243_407# m2_5700_324# 0.01927f
C263 m2_7791_79# a_8723_63# 0.08396f
C264 a_11922_391# w_n310_281# 0.03535f
C265 a_7083_63# a_9408_n37# 0.00336f
C266 a_4158_271# a_5042_407# 0.63867f
C267 m2_9431_79# a_8361_407# 0
C268 a_7083_63# a_6721_407# 0.01268f
C269 a_11922_391# a_11922_3# 0.01891f
C270 m2_5700_324# a_4290_63# 0.01531f
C271 m2_1295_79# a_10363_63# 0.00179f
C272 m2_1295_79# a_378_271# 0.02669f
C273 m2_9431_79# m2_1295_79# 0.0078f
C274 a_5042_407# a_4650_n37# 0.00712f
C275 a_10906_466# w_n310_281# 0.44509f
C276 a_2861_3# a_705_407# 0
C277 a_5768_63# a_3498_3# 0
C278 a_4158_271# a_3940_63# 0.16366f
C279 a_7083_63# a_5042_407# 0.02611f
C280 a_160_63# a_870_n37# 0.00441f
C281 a_8361_407# m2_5700_324# 0.05956f
C282 a_10906_466# a_11922_3# 0
C283 a_4158_271# w_n310_281# 0.66883f
C284 a_4158_271# a_11922_3# 0.0013f
C285 a_3940_63# a_4650_n37# 0.00441f
C286 m2_1295_79# m2_5700_324# 0.07849f
C287 a_2861_3# a_3498_3# 0.09846f
C288 a_378_271# a_705_407# 0.02817f
C289 m2_6151_79# a_5042_n37# 0
C290 a_4158_271# a_9800_n37# 0.00497f
C291 a_7083_63# w_n310_281# 0.31663f
C292 a_7083_63# a_9800_n37# 0.00527f
C293 m2_9431_79# a_3498_3# 0
C294 a_8723_63# w_n310_281# 0.33581f
C295 a_4158_271# a_10906_466# 0.03873f
C296 a_5768_63# m2_5700_324# 0.16447f
C297 a_10363_63# a_10906_n37# 0
C298 a_5042_407# a_5042_n37# 0.01726f
C299 a_3498_3# m2_5700_324# 0.55174f
C300 a_870_n37# a_510_63# 0.01502f
C301 m2_9431_79# a_10363_63# 0.07766f
C302 a_7083_63# a_10906_466# 0
C303 a_4158_271# via_dev$5$1_9/VSUBS 2.63898f
C304 a_7083_63# via_dev$5$1_9/VSUBS 0.86585f
C305 a_8723_63# via_dev$5$1_9/VSUBS 0.41121f
C306 m2_9431_79# via_dev$5$1_9/VSUBS 0.75255f
C307 m2_7791_79# via_dev$5$1_9/VSUBS 0.74612f
C308 a_9609_407# via_dev$5$1_9/VSUBS 0.11967f
C309 a_8361_407# via_dev$5$1_9/VSUBS 0.05216f
C310 m2_6151_79# via_dev$5$1_9/VSUBS 0.72815f
C311 a_6721_407# via_dev$5$1_9/VSUBS 0.01698f
C312 a_5042_407# via_dev$5$1_9/VSUBS 0.88916f
C313 a_3940_63# via_dev$5$1_9/VSUBS 0.46864f
C314 m2_1295_79# via_dev$5$1_9/VSUBS 3.37184f
C315 a_160_63# via_dev$5$1_9/VSUBS 0.5921f
C316 a_5243_407# via_dev$5$1_9/VSUBS 0.01661f
C317 a_705_407# via_dev$5$1_9/VSUBS 0.13677f
C318 a_3498_3# via_dev$5$1_9/VSUBS 1.27724f
C319 a_10906_n37# via_dev$5$1_9/VSUBS 0.02232f
C320 a_9800_n37# via_dev$5$1_9/VSUBS 0.01742f
C321 a_9408_n37# via_dev$5$1_9/VSUBS 0.007f
C322 a_8160_n37# via_dev$5$1_9/VSUBS 0.01743f
C323 a_7768_n37# via_dev$5$1_9/VSUBS 0.007f
C324 a_6520_n37# via_dev$5$1_9/VSUBS 0.01743f
C325 a_6128_n37# via_dev$5$1_9/VSUBS 0.007f
C326 a_5042_n37# via_dev$5$1_9/VSUBS 0.00833f
C327 a_4650_n37# via_dev$5$1_9/VSUBS 0.01565f
C328 a_12559_3# via_dev$5$1_9/VSUBS 0.19481f
C329 a_11922_3# via_dev$5$1_9/VSUBS 0.64569f
C330 a_11922_391# via_dev$5$1_9/VSUBS 0.00119f
C331 a_10906_466# via_dev$5$1_9/VSUBS 0.59796f
C332 a_11480_63# via_dev$5$1_9/VSUBS 0.42359f
C333 a_10363_63# via_dev$5$1_9/VSUBS 0.13924f
C334 a_9050_63# via_dev$5$1_9/VSUBS 0.53264f
C335 a_8919_370# via_dev$5$1_9/VSUBS 0.51824f
C336 a_7410_63# via_dev$5$1_9/VSUBS 0.53731f
C337 a_5768_63# via_dev$5$1_9/VSUBS 0.54f
C338 a_1845_n37# via_dev$5$1_9/VSUBS 0.01974f
C339 a_1262_n37# via_dev$5$1_9/VSUBS 0.0069f
C340 a_870_n37# via_dev$5$1_9/VSUBS 0.01517f
C341 a_4290_63# via_dev$5$1_9/VSUBS 0.57048f
C342 a_2861_3# via_dev$5$1_9/VSUBS 0.62907f
C343 a_1845_466# via_dev$5$1_9/VSUBS 0.59853f
C344 a_2419_63# via_dev$5$1_9/VSUBS 6.64124f
C345 a_510_63# via_dev$5$1_9/VSUBS 0.55998f
C346 a_378_271# via_dev$5$1_9/VSUBS 1.37769f
C347 w_n310_281# via_dev$5$1_9/VSUBS 27.06296f
C348 m2_24_342# via_dev$5$1_9/VSUBS 1.98211f
C349 m2_5700_324# via_dev$5$1_9/VSUBS 1.14834f
.ends

.subckt x4bitblock BP GND VDD Cout S1 B0 A0 A1 B1 A2 B2 A3 B3 P0 P1 P2 P3 S0 Cin Y0
+ Y1 Y2 Y3
XMUX21_0 Cout MUX21_0/a_157_63# BP MUX21_0/a_909_n37# Cin MUX21_0/a_517_n37# MUX21_0/a_718_407#
+ MUX21_0/m2_540_79# GND m1_12480_n3815# VDD MUX21
X1bitblock$2_0 1bitblock$2_0/a_2861_3# 1bitblock$2_0/a_8361_407# 1bitblock$2_0/a_6520_n37#
+ 1bitblock$2_0/a_1262_n37# 1bitblock$2_0/a_2861_391# 1bitblock$2_0/a_1845_466# 1bitblock$2_0/a_10906_n37#
+ 1bitblock$2_0/a_510_63# 1bitblock$2_0/a_870_n37# 1bitblock$2_0/a_6721_407# 1bitblock$2_0/a_9800_n37#
+ 1bitblock$2_0/a_11480_63# 1bitblock$2_0/a_6128_n37# 1bitblock$2_0/a_5768_63# S1
+ 1bitblock$2_0/m2_6151_79# 1bitblock$2_0/a_11922_391# 1bitblock$2_0/a_5042_n37# 1bitblock$2_0/a_9408_n37#
+ 1bitblock$2_0/a_9609_407# 1bitblock$2_0/a_5042_407# 1bitblock$2_0/a_8160_n37# m1_12484_n953#
+ 1bitblock$2_0/a_11922_3# 1bitblock$2_0/a_2419_63# 1bitblock$2_0/m2_9431_79# 1bitblock$2_0/a_10906_466#
+ 1bitblock$2_0/a_4650_n37# 1bitblock$2_0/a_9050_63# 1bitblock$2_0/a_5243_407# 1bitblock$2_0/a_7768_n37#
+ 1bitblock$2_0/a_3940_63# 1bitblock$2_0/m2_7791_79# Y2 1bitblock$2_0/a_160_63# 1bitblock$2_0/a_4290_63#
+ 1bitblock$2_0/a_7083_63# 1bitblock$2_0/a_705_407# m2_10721_n3315# 1bitblock$2_0/a_7410_63#
+ S0 1bitblock$2_0/a_1845_n37# GND P2 1bitblock$2_0/a_8723_63# B2 1bitblock$2_0/a_3498_3#
+ VDD A2 x1bitblock$2
XAND4_0 VDD P2 GND P3 BP P1 AND4_0/a_704_n441# P0 AND4_0/a_912_n441# AND4_0/a_518_229#
+ AND4_0/a_1120_n441# AND4
X1bitblock$3_0 1bitblock$3_0/a_2861_3# 1bitblock$3_0/a_8361_407# 1bitblock$3_0/a_6520_n37#
+ 1bitblock$3_0/a_1262_n37# 1bitblock$3_0/a_2861_391# 1bitblock$3_0/a_1845_466# 1bitblock$3_0/a_10906_n37#
+ 1bitblock$3_0/a_510_63# 1bitblock$3_0/a_870_n37# 1bitblock$3_0/a_9800_n37# 1bitblock$3_0/a_11480_63#
+ 1bitblock$3_0/a_6128_n37# 1bitblock$3_0/a_5768_63# 1bitblock$3_0/m2_6151_79# 1bitblock$3_0/a_11922_391#
+ 1bitblock$3_0/a_5042_n37# 1bitblock$3_0/a_9408_n37# 1bitblock$3_0/a_9609_407# 1bitblock$3_0/a_5042_407#
+ 1bitblock$3_0/a_8160_n37# m2_10721_n3315# 1bitblock$3_0/a_11922_3# S1 1bitblock$3_0/a_2419_63#
+ 1bitblock$3_0/m2_9431_79# 1bitblock$3_0/a_10906_466# 1bitblock$3_0/a_4650_n37# 1bitblock$3_0/a_9050_63#
+ 1bitblock$3_0/a_7768_n37# 1bitblock$3_0/a_3940_63# 1bitblock$3_0/m2_7791_79# Y3
+ 1bitblock$3_0/a_160_63# 1bitblock$3_0/a_4290_63# 1bitblock$3_0/a_7083_63# 1bitblock$3_0/a_705_407#
+ m1_12480_n3815# 1bitblock$3_0/a_7410_63# S0 1bitblock$3_0/a_1845_n37# GND 1bitblock$3_0/a_3498_3#
+ P3 1bitblock$3_0/a_8723_63# B3 VDD A3 x1bitblock$3
X1bitblock_0 1bitblock_0/a_2861_3# 1bitblock_0/a_8361_407# 1bitblock_0/a_6520_n37#
+ 1bitblock_0/a_1262_n37# 1bitblock_0/a_2861_391# 1bitblock_0/a_1845_466# 1bitblock_0/a_10906_n37#
+ 1bitblock_0/a_510_63# 1bitblock_0/a_870_n37# 1bitblock_0/a_9800_n37# 1bitblock_0/a_11480_63#
+ 1bitblock_0/a_6128_n37# 1bitblock_0/a_5768_63# 1bitblock_0/m2_6151_79# 1bitblock_0/a_11922_391#
+ 1bitblock_0/a_5042_n37# 1bitblock_0/a_9408_n37# S1 1bitblock_0/a_9609_407# 1bitblock_0/a_5042_407#
+ 1bitblock_0/a_8160_n37# Cin 1bitblock_0/a_11922_3# 1bitblock_0/a_2419_63# 1bitblock_0/m2_9431_79#
+ 1bitblock_0/a_10906_466# 1bitblock_0/a_4650_n37# 1bitblock_0/a_3498_3# 1bitblock_0/a_9050_63#
+ 1bitblock_0/a_7768_n37# 1bitblock_0/a_3940_63# 1bitblock_0/m2_7791_79# Y0 1bitblock_0/a_160_63#
+ 1bitblock_0/a_4290_63# 1bitblock_0/a_7083_63# 1bitblock_0/a_705_407# m1_12486_242#
+ 1bitblock_0/a_7410_63# 1bitblock_0/a_1845_n37# GND P0 1bitblock_0/a_8723_63# B0
+ S0 VDD A0 x1bitblock
X1bitblock$1_0 1bitblock$1_0/a_2861_3# 1bitblock$1_0/a_8361_407# 1bitblock$1_0/a_6520_n37#
+ 1bitblock$1_0/a_1262_n37# 1bitblock$1_0/a_2861_391# A1 1bitblock$1_0/a_1845_466#
+ 1bitblock$1_0/a_10906_n37# 1bitblock$1_0/a_510_63# 1bitblock$1_0/a_870_n37# 1bitblock$1_0/a_6721_407#
+ 1bitblock$1_0/a_9800_n37# 1bitblock$1_0/a_11480_63# 1bitblock$1_0/a_6128_n37# 1bitblock$1_0/a_5768_63#
+ 1bitblock$1_0/m2_6151_79# 1bitblock$1_0/a_3498_3# 1bitblock$1_0/a_11922_391# 1bitblock$1_0/a_5042_n37#
+ 1bitblock$1_0/a_9408_n37# 1bitblock$1_0/a_9609_407# 1bitblock$1_0/a_5042_407# 1bitblock$1_0/a_8160_n37#
+ m1_12486_242# 1bitblock$1_0/a_11922_3# 1bitblock$1_0/a_2419_63# 1bitblock$1_0/m2_9431_79#
+ 1bitblock$1_0/a_10906_466# 1bitblock$1_0/a_4650_n37# P1 1bitblock$1_0/a_9050_63#
+ 1bitblock$1_0/a_5243_407# 1bitblock$1_0/a_7768_n37# 1bitblock$1_0/a_160_63# 1bitblock$1_0/a_3940_63#
+ S1 1bitblock$1_0/m2_7791_79# Y1 1bitblock$1_0/a_4290_63# 1bitblock$1_0/a_7083_63#
+ 1bitblock$1_0/a_705_407# m1_12484_n953# 1bitblock$1_0/a_7410_63# S0 1bitblock$1_0/a_1845_n37#
+ GND 1bitblock$1_0/a_8723_63# B1 VDD x1bitblock$1
X0 1bitblock_0/a_870_n37# B0.t5 GND GND nfet_03v3 ad=0.3625p pd=1.725u as=0.54p ps=3.08u w=0 l=0
X1 1bitblock$3_0/m2_7791_79# P3.t4 1bitblock$3_0/a_7768_n37# GND nfet_03v3 ad=0.3375p pd=1.675u as=0.3625p ps=1.725u w=0 l=0
X2 1bitblock$3_0/a_160_63# A3.t1 GND GND nfet_03v3 ad=0.315p pd=2.26u as=0.325p ps=2.3u w=0 l=0
X3 1bitblock$1_0/a_6128_n37# S0.t27 GND GND nfet_03v3 ad=0.3625p pd=1.725u as=0.54p ps=3.08u w=0 l=0
X4 1bitblock_0/a_4290_63# Cin.t7 VDD VDD pfet_03v3 ad=0.65p pd=3.3u as=0.56p ps=3.12u w=0 l=0
X5 1bitblock_0/a_9408_n37# S1.t9 GND GND nfet_03v3 ad=0.3625p pd=1.725u as=0.54p ps=3.08u w=0 l=0
X6 1bitblock_0/a_3940_63# P0.t9 GND GND nfet_03v3 ad=0.315p pd=2.26u as=0.325p ps=2.3u w=0 l=0
X7 1bitblock_0/m2_7791_79# S0.t23 1bitblock_0/a_8361_407# VDD pfet_03v3 ad=0.725p pd=2.725u as=1.09p ps=5.09u w=0 l=0
X8 1bitblock$3_0/a_870_n37# B3.t5 GND GND nfet_03v3 ad=0.3625p pd=1.725u as=0.54p ps=3.08u w=0 l=0
X9 1bitblock$3_0/a_1845_466# A3.t0 1bitblock$3_0/a_1845_n37# GND nfet_03v3 ad=0.65p pd=3.3u as=0.42p ps=1.84u w=0 l=0
X10 1bitblock$2_0/m2_6151_79# S0.t5 1bitblock$2_0/a_6721_407# VDD pfet_03v3 ad=0.725p pd=2.725u as=1.09p ps=5.09u w=0 l=0
X11 1bitblock$3_0/a_3940_63# P3.t2 VDD VDD pfet_03v3 ad=0.63p pd=3.26u as=0.65p ps=3.3u w=0 l=0
X12 1bitblock$1_0/a_5243_407# P1.t11 VDD VDD pfet_03v3 ad=0.675p pd=2.675u as=0.725p ps=2.725u w=0 l=0
X13 1bitblock$1_0/a_1845_466# B1.t1 VDD VDD pfet_03v3 ad=0.42p pd=1.84u as=0.65p ps=3.3u w=0 l=0
X14 1bitblock_0/m2_6151_79# S0.t21 1bitblock_0/a_6721_407# VDD pfet_03v3 ad=0.725p pd=2.725u as=1.09p ps=5.09u w=0 l=0
X15 1bitblock$2_0/a_9050_63# S1.t2 VDD VDD pfet_03v3 ad=0.64p pd=3.28u as=0.48p ps=2.96u w=0 l=0
X16 GND 1bitblock_0/a_2419_63# 1bitblock_0/a_2861_3# GND.t15 nfet_03v3 ad=0.315p pd=2.26u as=0.18125p ps=1.225u w=0 l=0
X17 1bitblock$2_0/m2_9431_79# S1.t3 1bitblock$2_0/a_9609_407# VDD pfet_03v3 ad=0.725p pd=2.725u as=1.09p ps=5.09u w=0 l=0
X18 1bitblock$3_0/a_8361_407# P3.t5 1bitblock$3_0/m2_7791_79# VDD pfet_03v3 ad=0.675p pd=2.675u as=0.725p ps=2.725u w=0 l=0
X19 1bitblock_0/a_2861_3# P0.t4 GND GND nfet_03v3 ad=0.18125p pd=1.225u as=0.325p ps=2.3u w=0 l=0
X20 VDD B3.t0 1bitblock$3_0/a_705_407# VDD pfet_03v3 ad=0.725p pd=2.725u as=1.09p ps=5.09u w=0 l=0
X21 1bitblock$2_0/m2_7791_79# P2.t2 1bitblock$2_0/a_7768_n37# GND nfet_03v3 ad=0.3375p pd=1.675u as=0.3625p ps=1.725u w=0 l=0
X22 1bitblock$3_0/a_7410_63# S0.t12 VDD VDD pfet_03v3 ad=0.64p pd=3.28u as=0.48p ps=2.96u w=0 l=0
X23 1bitblock$1_0/m2_6151_79# S0.t29 1bitblock$1_0/a_6721_407# VDD pfet_03v3 ad=0.725p pd=2.725u as=1.09p ps=5.09u w=0 l=0
X24 GND 1bitblock_0/a_2419_63# 1bitblock_0/a_11922_3# GND.t12 nfet_03v3 ad=0.315p pd=2.26u as=0.18125p ps=1.225u w=0 l=0
X25 1bitblock_0/a_10906_466# Cin.t2 VDD VDD pfet_03v3 ad=0.42p pd=1.84u as=0.65p ps=3.3u w=0 l=0
X26 1bitblock$2_0/a_870_n37# B2.t5 GND GND nfet_03v3 ad=0.3625p pd=1.725u as=0.54p ps=3.08u w=0 l=0
X27 AND4_0/a_518_229# P3.t0 AND4_0/a_1120_n441# GND nfet_03v3 ad=1.14p pd=5.14u as=0.76p ps=2.76u w=0 l=0
X28 1bitblock$3_0/a_3940_63# P3.t8 GND GND nfet_03v3 ad=0.315p pd=2.26u as=0.325p ps=2.3u w=0 l=0
X29 1bitblock_0/a_3940_63# P0.t3 VDD VDD pfet_03v3 ad=0.63p pd=3.26u as=0.65p ps=3.3u w=0 l=0
X30 1bitblock$2_0/a_1845_466# A2.t0 1bitblock$2_0/a_1845_n37# GND nfet_03v3 ad=0.65p pd=3.3u as=0.42p ps=1.84u w=0 l=0
X31 1bitblock$2_0/a_9050_63# S1.t0 GND GND nfet_03v3 ad=0.31p pd=2.24u as=0.24p ps=1.96u w=0 l=0
X32 1bitblock$1_0/a_2861_391# P1.t10 VDD VDD pfet_03v3 ad=0.725p pd=2.725u as=1.3p ps=5.3u w=0 l=0
X33 1bitblock_0/a_1845_n37# B0.t4 GND GND nfet_03v3 ad=0.42p pd=1.84u as=0.63p ps=3.26u w=0 l=0
X34 1bitblock$1_0/m2_9431_79# S1.t15 1bitblock$1_0/a_9609_407# VDD pfet_03v3 ad=0.725p pd=2.725u as=1.09p ps=5.09u w=0 l=0
X35 1bitblock$2_0/a_2861_3# P2.t1 GND GND nfet_03v3 ad=0.18125p pd=1.225u as=0.325p ps=2.3u w=0 l=0
X36 1bitblock$3_0/a_2861_391# P3.t10 VDD VDD pfet_03v3 ad=0.725p pd=2.725u as=1.3p ps=5.3u w=0 l=0
X37 1bitblock_0/m2_9431_79# 1bitblock_0/a_8723_63# 1bitblock_0/a_9408_n37# GND.t0 nfet_03v3 ad=0.3375p pd=1.675u as=0.3625p ps=1.725u w=0 l=0
X38 1bitblock_0/a_160_63# A0.t1 GND GND nfet_03v3 ad=0.315p pd=2.26u as=0.325p ps=2.3u w=0 l=0
X39 1bitblock_0/a_9050_63# S1.t8 GND GND nfet_03v3 ad=0.31p pd=2.24u as=0.24p ps=1.96u w=0 l=0
X40 1bitblock$2_0/a_1845_466# B2.t1 VDD VDD pfet_03v3 ad=0.42p pd=1.84u as=0.65p ps=3.3u w=0 l=0
X41 1bitblock$1_0/a_1845_n37# B1.t4 GND GND nfet_03v3 ad=0.42p pd=1.84u as=0.63p ps=3.26u w=0 l=0
X42 1bitblock$2_0/a_8361_407# P2.t3 1bitblock$2_0/m2_7791_79# VDD pfet_03v3 ad=0.675p pd=2.675u as=0.725p ps=2.725u w=0 l=0
X43 1bitblock$3_0/a_7410_63# S0.t9 GND GND nfet_03v3 ad=0.31p pd=2.24u as=0.24p ps=1.96u w=0 l=0
X44 1bitblock_0/a_5768_63# S0.t16 GND GND nfet_03v3 ad=0.315p pd=2.26u as=0.3175p ps=2.27u w=0 l=0
X45 1bitblock$3_0/a_10906_466# P3.t7 1bitblock$3_0/a_10906_n37# GND nfet_03v3 ad=0.65p pd=3.3u as=0.42p ps=1.84u w=0 l=0
X46 MUX21_0/a_517_n37# BP.t1 GND GND nfet_03v3 ad=0.3625p pd=1.725u as=0.54p ps=3.08u w=0 l=0
X47 1bitblock_0/a_10906_466# P0.t8 1bitblock_0/a_10906_n37# GND.t24 nfet_03v3 ad=0.65p pd=3.3u as=0.42p ps=1.84u w=0 l=0
X48 VDD B2.t0 1bitblock$2_0/a_705_407# VDD pfet_03v3 ad=0.725p pd=2.725u as=1.09p ps=5.09u w=0 l=0
X49 1bitblock$3_0/a_510_63# B3.t2 VDD VDD pfet_03v3 ad=0.65p pd=3.3u as=0.56p ps=3.12u w=0 l=0
X50 1bitblock_0/a_7410_63# S0.t17 GND GND nfet_03v3 ad=0.31p pd=2.24u as=0.24p ps=1.96u w=0 l=0
X51 1bitblock_0/m2_7791_79# P0.t5 1bitblock_0/a_7768_n37# GND.t10 nfet_03v3 ad=0.3375p pd=1.675u as=0.3625p ps=1.725u w=0 l=0
X52 1bitblock$1_0/a_3940_63# P1.t2 VDD VDD pfet_03v3 ad=0.63p pd=3.26u as=0.65p ps=3.3u w=0 l=0
X53 1bitblock_0/a_11922_3# 1bitblock_0/a_2419_63# 1bitblock_0/a_11922_391# VDD.t9 pfet_03v3 ad=1.3p pd=5.3u as=0.725p ps=2.725u w=0 l=0
X54 VDD A0.t5 1bitblock_0/a_1845_466# VDD.t16 pfet_03v3 ad=0.735p pd=2.47u as=0.42p ps=1.84u w=0 l=0
X55 1bitblock$1_0/a_7768_n37# S0.t30 GND GND nfet_03v3 ad=0.3625p pd=1.725u as=0.54p ps=3.08u w=0 l=0
X56 1bitblock_0/m2_6151_79# 1bitblock_0/a_2419_63# 1bitblock_0/a_6128_n37# GND.t11 nfet_03v3 ad=0.3375p pd=1.675u as=0.3625p ps=1.725u w=0 l=0
X57 MUX21_0/m2_540_79# BP.t2 MUX21_0/a_718_407# VDD pfet_03v3 ad=0.725p pd=2.725u as=1.09p ps=5.09u w=0 l=0
X58 1bitblock$1_0/a_510_63# B1.t3 GND GND nfet_03v3 ad=0.315p pd=2.26u as=0.28p ps=2.12u w=0 l=0
X59 1bitblock_0/a_9609_407# 1bitblock_0/a_8723_63# 1bitblock_0/m2_9431_79# VDD.t0 pfet_03v3 ad=0.675p pd=2.675u as=0.725p ps=2.725u w=0 l=0
X60 VDD P0.t1 AND4_0/a_518_229# VDD pfet_03v3 ad=0.38p pd=1.76u as=0.65p ps=3.3u w=0 l=0
X61 1bitblock$3_0/a_1845_466# B3.t1 VDD VDD pfet_03v3 ad=0.42p pd=1.84u as=0.65p ps=3.3u w=0 l=0
X62 1bitblock$1_0/a_8361_407# P1.t5 1bitblock$1_0/m2_7791_79# VDD pfet_03v3 ad=0.675p pd=2.675u as=0.725p ps=2.725u w=0 l=0
X63 1bitblock_0/a_510_63# B0.t3 GND GND nfet_03v3 ad=0.315p pd=2.26u as=0.28p ps=2.12u w=0 l=0
X64 VDD B1.t0 1bitblock$1_0/a_705_407# VDD pfet_03v3 ad=0.725p pd=2.725u as=1.09p ps=5.09u w=0 l=0
X65 1bitblock_0/a_160_63# A0.t2 VDD VDD pfet_03v3 ad=0.63p pd=3.26u as=0.65p ps=3.3u w=0 l=0
X66 1bitblock_0/a_9050_63# S1.t10 VDD VDD pfet_03v3 ad=0.64p pd=3.28u as=0.48p ps=2.96u w=0 l=0
X67 1bitblock$3_0/a_5768_63# S0.t10 VDD VDD pfet_03v3 ad=0.65p pd=3.3u as=0.635p ps=3.27u w=0 l=0
X68 1bitblock$3_0/a_510_63# B3.t3 GND GND nfet_03v3 ad=0.315p pd=2.26u as=0.28p ps=2.12u w=0 l=0
X69 1bitblock$2_0/a_10906_466# P2.t5 1bitblock$2_0/a_10906_n37# GND nfet_03v3 ad=0.65p pd=3.3u as=0.42p ps=1.84u w=0 l=0
X70 1bitblock$1_0/a_7410_63# S0.t28 VDD VDD pfet_03v3 ad=0.64p pd=3.28u as=0.48p ps=2.96u w=0 l=0
X71 1bitblock_0/a_5768_63# S0.t18 VDD VDD pfet_03v3 ad=0.65p pd=3.3u as=0.635p ps=3.27u w=0 l=0
X72 VDD B0.t0 1bitblock_0/a_705_407# VDD pfet_03v3 ad=0.725p pd=2.725u as=1.09p ps=5.09u w=0 l=0
X73 AND4_0/a_704_n441# P0.t2 GND GND nfet_03v3 ad=0.76p pd=2.76u as=1.34p ps=5.34u w=0 l=0
X74 1bitblock$1_0/a_5042_407# P1.t9 1bitblock$1_0/a_4650_n37# GND nfet_03v3 ad=0.3375p pd=1.675u as=0.3625p ps=1.725u w=0 l=0
X75 1bitblock_0/a_5243_407# P0.t12 VDD.t15 VDD.t14 pfet_03v3 ad=0.675p pd=2.675u as=0.725p ps=2.725u w=0 l=0
X76 1bitblock_0/a_7410_63# S0.t20 VDD VDD pfet_03v3 ad=0.64p pd=3.28u as=0.48p ps=2.96u w=0 l=0
X77 1bitblock$3_0/a_7768_n37# S0.t14 GND GND nfet_03v3 ad=0.3625p pd=1.725u as=0.54p ps=3.08u w=0 l=0
X78 1bitblock_0/a_1845_466# B0.t1 VDD VDD pfet_03v3 ad=0.42p pd=1.84u as=0.65p ps=3.3u w=0 l=0
X79 GND 1bitblock_0/a_510_63# 1bitblock_0/a_1262_n37# GND.t4 nfet_03v3 ad=0.65p pd=3.3u as=0.3625p ps=1.725u w=0 l=0
X80 1bitblock_0/a_6721_407# 1bitblock_0/a_2419_63# 1bitblock_0/m2_6151_79# VDD.t11 pfet_03v3 ad=0.675p pd=2.675u as=0.725p ps=2.725u w=0 l=0
X81 1bitblock$3_0/a_5768_63# S0.t8 GND GND nfet_03v3 ad=0.315p pd=2.26u as=0.3175p ps=2.27u w=0 l=0
X82 1bitblock$1_0/a_5768_63# S0.t24 GND GND nfet_03v3 ad=0.315p pd=2.26u as=0.3175p ps=2.27u w=0 l=0
X83 1bitblock$2_0/a_3940_63# P2.t0 VDD VDD pfet_03v3 ad=0.63p pd=3.26u as=0.65p ps=3.3u w=0 l=0
X84 P3 A3.t3 1bitblock$3_0/a_870_n37# GND nfet_03v3 ad=0.3375p pd=1.675u as=0.3625p ps=1.725u w=0 l=0
X85 1bitblock_0/a_510_63# B0.t2 VDD VDD pfet_03v3 ad=0.65p pd=3.3u as=0.56p ps=3.12u w=0 l=0
X86 1bitblock$1_0/a_160_63# A1.t2 VDD VDD pfet_03v3 ad=0.63p pd=3.26u as=0.65p ps=3.3u w=0 l=0
X87 VDD A1.t5 1bitblock$1_0/a_1845_466# VDD pfet_03v3 ad=0.735p pd=2.47u as=0.42p ps=1.84u w=0 l=0
X88 1bitblock$1_0/a_510_63# B1.t2 VDD VDD pfet_03v3 ad=0.65p pd=3.3u as=0.56p ps=3.12u w=0 l=0
X89 1bitblock_0/a_5042_407# P0.t10 1bitblock_0/a_4650_n37# GND.t20 nfet_03v3 ad=0.3375p pd=1.675u as=0.3625p ps=1.725u w=0 l=0
X90 1bitblock_0/a_10906_n37# Cin.t4 GND GND nfet_03v3 ad=0.42p pd=1.84u as=0.63p ps=3.26u w=0 l=0
X91 1bitblock$3_0/m2_7791_79# S0.t15 1bitblock$3_0/a_8361_407# VDD pfet_03v3 ad=0.725p pd=2.725u as=1.09p ps=5.09u w=0 l=0
X92 1bitblock$1_0/a_870_n37# B1.t5 GND GND nfet_03v3 ad=0.3625p pd=1.725u as=0.54p ps=3.08u w=0 l=0
X93 VDD A3.t5 1bitblock$3_0/a_1845_466# VDD pfet_03v3 ad=0.735p pd=2.47u as=0.42p ps=1.84u w=0 l=0
X94 1bitblock$1_0/m2_7791_79# P1.t4 1bitblock$1_0/a_7768_n37# GND nfet_03v3 ad=0.3375p pd=1.675u as=0.3625p ps=1.725u w=0 l=0
X95 GND 1bitblock_0/a_4290_63# 1bitblock_0/a_5042_n37# GND.t1 nfet_03v3 ad=0.65p pd=3.3u as=0.3625p ps=1.725u w=0 l=0
X96 1bitblock_0/a_8361_407# P0.t6 1bitblock_0/m2_7791_79# VDD.t5 pfet_03v3 ad=0.675p pd=2.675u as=0.725p ps=2.725u w=0 l=0
X97 1bitblock_0/a_705_407# 1bitblock_0/a_510_63# P0.t0 VDD.t2 pfet_03v3 ad=1.3p pd=5.3u as=0.725p ps=2.725u w=0 l=0
X98 1bitblock$1_0/a_7410_63# S0.t25 GND GND nfet_03v3 ad=0.31p pd=2.24u as=0.24p ps=1.96u w=0 l=0
X99 1bitblock$2_0/a_7768_n37# S0.t6 GND GND nfet_03v3 ad=0.3625p pd=1.725u as=0.54p ps=3.08u w=0 l=0
X100 AND4_0/a_518_229# P3.t1 VDD VDD pfet_03v3 ad=0.55p pd=3.1u as=0.38p ps=1.76u w=0 l=0
X101 1bitblock$3_0/a_9050_63# S1.t6 VDD VDD pfet_03v3 ad=0.64p pd=3.28u as=0.48p ps=2.96u w=0 l=0
X102 1bitblock$2_0/a_7410_63# S0.t4 VDD VDD pfet_03v3 ad=0.64p pd=3.28u as=0.48p ps=2.96u w=0 l=0
X103 1bitblock$2_0/a_3940_63# P2.t6 GND GND nfet_03v3 ad=0.315p pd=2.26u as=0.325p ps=2.3u w=0 l=0
X104 AND4_0/a_912_n441# P1.t1 AND4_0/a_704_n441# GND nfet_03v3 ad=0.76p pd=2.76u as=0.76p ps=2.76u w=0 l=0
X105 1bitblock_0/a_4650_n37# Cin.t5 GND GND nfet_03v3 ad=0.3625p pd=1.725u as=0.54p ps=3.08u w=0 l=0
X106 MUX21_0/a_718_407# Cin.t0 MUX21_0/m2_540_79# VDD pfet_03v3 ad=0.675p pd=2.675u as=0.725p ps=2.725u w=0 l=0
X107 MUX21_0/a_157_63# BP.t0 VDD VDD pfet_03v3 ad=0.65p pd=3.3u as=0.635p ps=3.27u w=0 l=0
X108 1bitblock$3_0/a_705_407# A3.t4 VDD VDD pfet_03v3 ad=0.675p pd=2.675u as=0.725p ps=2.725u w=0 l=0
X109 VDD Cin.t6 1bitblock_0/a_5243_407# VDD pfet_03v3 ad=0.725p pd=2.725u as=1.09p ps=5.09u w=0 l=0
X110 GND 1bitblock_0/a_9050_63# 1bitblock_0/a_9800_n37# GND.t7 nfet_03v3 ad=0.65p pd=3.3u as=0.3625p ps=1.725u w=0 l=0
X111 1bitblock$1_0/a_160_63# A1.t1 GND GND nfet_03v3 ad=0.315p pd=2.26u as=0.325p ps=2.3u w=0 l=0
X112 1bitblock$1_0/a_5768_63# S0.t26 VDD VDD pfet_03v3 ad=0.65p pd=3.3u as=0.635p ps=3.27u w=0 l=0
X113 P2 A2.t3 1bitblock$2_0/a_870_n37# GND nfet_03v3 ad=0.3375p pd=1.675u as=0.3625p ps=1.725u w=0 l=0
X114 1bitblock$3_0/a_2861_3# P3.t3 GND GND nfet_03v3 ad=0.18125p pd=1.225u as=0.325p ps=2.3u w=0 l=0
X115 1bitblock$3_0/a_5042_407# P3.t9 1bitblock$3_0/a_4650_n37# GND nfet_03v3 ad=0.3375p pd=1.675u as=0.3625p ps=1.725u w=0 l=0
X116 1bitblock$2_0/a_1845_n37# B2.t4 GND GND nfet_03v3 ad=0.42p pd=1.84u as=0.63p ps=3.26u w=0 l=0
X117 1bitblock_0/m2_9431_79# S1.t11 1bitblock_0/a_9609_407# VDD pfet_03v3 ad=0.725p pd=2.725u as=1.09p ps=5.09u w=0 l=0
X118 GND 1bitblock_0/a_7410_63# 1bitblock_0/a_8160_n37# GND.t25 nfet_03v3 ad=0.65p pd=3.3u as=0.3625p ps=1.725u w=0 l=0
X119 MUX21_0/a_157_63# BP.t3 GND GND nfet_03v3 ad=0.315p pd=2.26u as=0.3175p ps=2.27u w=0 l=0
X120 1bitblock$2_0/a_7410_63# S0.t1 GND GND nfet_03v3 ad=0.31p pd=2.24u as=0.24p ps=1.96u w=0 l=0
X121 1bitblock$3_0/a_9050_63# S1.t4 GND GND nfet_03v3 ad=0.31p pd=2.24u as=0.24p ps=1.96u w=0 l=0
X122 1bitblock_0/a_5243_407# 1bitblock_0/a_4290_63# 1bitblock_0/a_5042_407# VDD.t1 pfet_03v3 ad=1.3p pd=5.3u as=0.725p ps=2.725u w=0 l=0
X123 VDD A2.t5 1bitblock$2_0/a_1845_466# VDD pfet_03v3 ad=0.735p pd=2.47u as=0.42p ps=1.84u w=0 l=0
X124 1bitblock$2_0/a_160_63# A2.t2 VDD VDD pfet_03v3 ad=0.63p pd=3.26u as=0.65p ps=3.3u w=0 l=0
X125 1bitblock$2_0/m2_7791_79# S0.t7 1bitblock$2_0/a_8361_407# VDD pfet_03v3 ad=0.725p pd=2.725u as=1.09p ps=5.09u w=0 l=0
X126 VDD P0.t7 1bitblock_0/a_10906_466# VDD.t6 pfet_03v3 ad=0.735p pd=2.47u as=0.42p ps=1.84u w=0 l=0
X127 GND 1bitblock_0/a_5768_63# 1bitblock_0/a_6520_n37# GND.t21 nfet_03v3 ad=0.65p pd=3.3u as=0.3625p ps=1.725u w=0 l=0
X128 1bitblock_0/a_6128_n37# S0.t19 GND GND nfet_03v3 ad=0.3625p pd=1.725u as=0.54p ps=3.08u w=0 l=0
X129 1bitblock$2_0/a_510_63# B2.t2 VDD VDD pfet_03v3 ad=0.65p pd=3.3u as=0.56p ps=3.12u w=0 l=0
X130 1bitblock_0/a_9609_407# 1bitblock_0/a_9050_63# VDD.t4 VDD.t3 pfet_03v3 ad=1.3p pd=5.3u as=0.725p ps=2.725u w=0 l=0
X131 VDD P1.t6 1bitblock$1_0/a_10906_466# VDD pfet_03v3 ad=0.735p pd=2.47u as=0.42p ps=1.84u w=0 l=0
X132 1bitblock$3_0/a_6128_n37# S0.t11 GND GND nfet_03v3 ad=0.3625p pd=1.725u as=0.54p ps=3.08u w=0 l=0
X133 MUX21_0/m2_540_79# Cin.t1 MUX21_0/a_517_n37# GND nfet_03v3 ad=0.3375p pd=1.675u as=0.3625p ps=1.725u w=0 l=0
X134 VDD P2.t10 AND4_0/a_518_229# VDD pfet_03v3 ad=0.38p pd=1.76u as=0.38p ps=1.76u w=0 l=0
X135 1bitblock$2_0/a_705_407# A2.t4 VDD VDD pfet_03v3 ad=0.675p pd=2.675u as=0.725p ps=2.725u w=0 l=0
X136 1bitblock$3_0/a_1845_n37# B3.t4 GND GND nfet_03v3 ad=0.42p pd=1.84u as=0.63p ps=3.26u w=0 l=0
X137 1bitblock$3_0/a_5243_407# P3.t11 VDD VDD pfet_03v3 ad=0.675p pd=2.675u as=0.725p ps=2.725u w=0 l=0
X138 1bitblock$3_0/a_9408_n37# S1.t5 GND GND nfet_03v3 ad=0.3625p pd=1.725u as=0.54p ps=3.08u w=0 l=0
X139 VDD P3.t6 1bitblock$3_0/a_10906_466# VDD pfet_03v3 ad=0.735p pd=2.47u as=0.42p ps=1.84u w=0 l=0
X140 1bitblock$1_0/a_10906_466# P1.t7 1bitblock$1_0/a_10906_n37# GND nfet_03v3 ad=0.65p pd=3.3u as=0.42p ps=1.84u w=0 l=0
X141 1bitblock_0/a_8361_407# 1bitblock_0/a_7410_63# VDD.t22 VDD.t21 pfet_03v3 ad=1.3p pd=5.3u as=0.725p ps=2.725u w=0 l=0
X142 1bitblock$2_0/a_160_63# A2.t1 GND GND nfet_03v3 ad=0.315p pd=2.26u as=0.325p ps=2.3u w=0 l=0
X143 1bitblock$2_0/a_5042_407# P2.t7 1bitblock$2_0/a_4650_n37# GND nfet_03v3 ad=0.3375p pd=1.675u as=0.3625p ps=1.725u w=0 l=0
X144 1bitblock$2_0/a_2861_391# P2.t8 VDD VDD pfet_03v3 ad=0.725p pd=2.725u as=1.3p ps=5.3u w=0 l=0
X145 1bitblock$1_0/m2_7791_79# S0.t31 1bitblock$1_0/a_8361_407# VDD pfet_03v3 ad=0.725p pd=2.725u as=1.09p ps=5.09u w=0 l=0
X146 P1 A1.t3 1bitblock$1_0/a_870_n37# GND nfet_03v3 ad=0.3375p pd=1.675u as=0.3625p ps=1.725u w=0 l=0
X147 1bitblock$1_0/a_3940_63# P1.t8 GND GND nfet_03v3 ad=0.315p pd=2.26u as=0.325p ps=2.3u w=0 l=0
X148 1bitblock$1_0/a_9050_63# S1.t12 GND GND nfet_03v3 ad=0.31p pd=2.24u as=0.24p ps=1.96u w=0 l=0
X149 1bitblock_0/a_4290_63# Cin.t3 GND GND nfet_03v3 ad=0.315p pd=2.26u as=0.28p ps=2.12u w=0 l=0
X150 1bitblock_0/a_1845_466# A0.t0 1bitblock_0/a_1845_n37# GND.t19 nfet_03v3 ad=0.65p pd=3.3u as=0.42p ps=1.84u w=0 l=0
X151 1bitblock$2_0/a_510_63# B2.t3 GND GND nfet_03v3 ad=0.315p pd=2.26u as=0.28p ps=2.12u w=0 l=0
X152 1bitblock_0/a_7768_n37# S0.t22 GND GND nfet_03v3 ad=0.3625p pd=1.725u as=0.54p ps=3.08u w=0 l=0
X153 1bitblock$2_0/a_5768_63# S0.t2 VDD VDD pfet_03v3 ad=0.65p pd=3.3u as=0.635p ps=3.27u w=0 l=0
X154 1bitblock$1_0/a_9050_63# S1.t14 VDD VDD pfet_03v3 ad=0.64p pd=3.28u as=0.48p ps=2.96u w=0 l=0
X155 1bitblock$3_0/a_160_63# A3.t2 VDD VDD pfet_03v3 ad=0.63p pd=3.26u as=0.65p ps=3.3u w=0 l=0
X156 1bitblock_0/a_6721_407# 1bitblock_0/a_5768_63# VDD.t20 VDD.t19 pfet_03v3 ad=1.3p pd=5.3u as=0.725p ps=2.725u w=0 l=0
X157 1bitblock_0/a_2861_3# 1bitblock_0/a_2419_63# 1bitblock_0/a_2861_391# VDD.t10 pfet_03v3 ad=1.3p pd=5.3u as=0.725p ps=2.725u w=0 l=0
X158 AND4_0/a_1120_n441# P2.t11 AND4_0/a_912_n441# GND nfet_03v3 ad=0.76p pd=2.76u as=0.76p ps=2.76u w=0 l=0
X159 1bitblock$1_0/a_1845_466# A1.t0 1bitblock$1_0/a_1845_n37# GND nfet_03v3 ad=0.65p pd=3.3u as=0.42p ps=1.84u w=0 l=0
X160 1bitblock$3_0/m2_6151_79# S0.t13 1bitblock$3_0/a_6721_407# VDD pfet_03v3 ad=0.725p pd=2.725u as=1.09p ps=5.09u w=0 l=0
X161 1bitblock$1_0/a_705_407# A1.t4 VDD VDD pfet_03v3 ad=0.675p pd=2.675u as=0.725p ps=2.725u w=0 l=0
X162 1bitblock$1_0/a_2861_3# P1.t3 GND GND nfet_03v3 ad=0.18125p pd=1.225u as=0.325p ps=2.3u w=0 l=0
X163 1bitblock$2_0/a_6128_n37# S0.t3 GND GND nfet_03v3 ad=0.3625p pd=1.725u as=0.54p ps=3.08u w=0 l=0
X164 1bitblock$1_0/a_9408_n37# S1.t13 GND GND nfet_03v3 ad=0.3625p pd=1.725u as=0.54p ps=3.08u w=0 l=0
X165 1bitblock$3_0/m2_9431_79# S1.t7 1bitblock$3_0/a_9609_407# VDD pfet_03v3 ad=0.725p pd=2.725u as=1.09p ps=5.09u w=0 l=0
X166 1bitblock_0/a_2861_391# P0.t11 VDD VDD pfet_03v3 ad=0.725p pd=2.725u as=1.3p ps=5.3u w=0 l=0
X167 1bitblock$2_0/a_5768_63# S0.t0 GND GND nfet_03v3 ad=0.315p pd=2.26u as=0.3175p ps=2.27u w=0 l=0
X168 1bitblock$2_0/a_9408_n37# S1.t1 GND GND nfet_03v3 ad=0.3625p pd=1.725u as=0.54p ps=3.08u w=0 l=0
X169 VDD P2.t4 1bitblock$2_0/a_10906_466# VDD pfet_03v3 ad=0.735p pd=2.47u as=0.42p ps=1.84u w=0 l=0
X170 AND4_0/a_518_229# P1.t0 VDD VDD pfet_03v3 ad=0.38p pd=1.76u as=0.38p ps=1.76u w=0 l=0
X171 1bitblock$2_0/a_5243_407# P2.t9 VDD VDD pfet_03v3 ad=0.675p pd=2.675u as=0.725p ps=2.725u w=0 l=0
X172 1bitblock_0/a_705_407# A0.t4 VDD.t13 VDD.t12 pfet_03v3 ad=0.675p pd=2.675u as=0.725p ps=2.725u w=0 l=0
X173 P0 A0.t3 1bitblock_0/a_870_n37# GND.t18 nfet_03v3 ad=0.3375p pd=1.675u as=0.3625p ps=1.725u w=0 l=0
R0 GND.n63 GND.n48 344714
R1 GND.n51 GND.n47 234914
R2 GND.n64 GND.n63 168218
R3 GND.n63 GND.n62 113659
R4 GND.n55 GND.n52 14337.3
R5 GND.n56 GND.n54 13084.4
R6 GND.n62 GND.n51 11891.4
R7 GND.n62 GND.n61 10113.6
R8 GND.n64 GND.n47 2590.73
R9 GND.n67 GND.t24 1208.4
R10 GND.n23 GND.n1 1167
R11 GND.n11 GND.n6 1164.41
R12 GND.t12 GND.n44 1143.71
R13 GND.n37 GND.n36 1143.71
R14 GND.t15 GND.n34 1143.71
R15 GND.n46 GND.n45 1128.18
R16 GND.n36 GND.n35 1128.18
R17 GND.n22 GND.n21 936.705
R18 GND.n18 GND.n17 936.705
R19 GND.n14 GND.n13 936.705
R20 GND.t11 GND.n11 931.529
R21 GND.t20 GND.n38 931.529
R22 GND.t0 GND.n19 926.355
R23 GND.t10 GND.n15 926.355
R24 GND.n24 GND.n23 918.591
R25 GND.n44 GND.n43 905.654
R26 GND.n38 GND.n37 905.654
R27 GND.n34 GND.n33 905.654
R28 GND.n19 GND.n18 846.139
R29 GND.n15 GND.n14 846.139
R30 GND.n51 GND.n50 727.111
R31 GND.n43 GND.t24 579.619
R32 GND.n33 GND.t19 579.619
R33 GND.n32 GND.n31 566.681
R34 GND.n45 GND.t12 520.105
R35 GND.n21 GND.t7 520.105
R36 GND.n20 GND.t0 520.105
R37 GND.n17 GND.t25 520.105
R38 GND.n16 GND.t10 520.105
R39 GND.n13 GND.t21 520.105
R40 GND.n12 GND.t11 520.105
R41 GND.n40 GND.t1 520.105
R42 GND.n39 GND.t20 520.105
R43 GND.n35 GND.t15 520.105
R44 GND.t7 GND.n20 494.228
R45 GND.t25 GND.n16 494.228
R46 GND.t21 GND.n12 494.228
R47 GND.t1 GND.n39 494.228
R48 GND.n47 GND.n46 491.64
R49 GND.n25 GND.n24 483.877
R50 GND.n28 GND.n27 460.589
R51 GND.t18 GND.n26 442.476
R52 GND.t19 GND.n32 411.425
R53 GND.t4 GND.n29 367.437
R54 GND.n31 GND.n30 349.324
R55 GND.n66 GND.n22 191.482
R56 GND.n41 GND.n40 188.893
R57 GND.n30 GND.t4 170.78
R58 GND.n29 GND.n28 77.6279
R59 GND.n27 GND.t18 59.5148
R60 GND.n26 GND.n25 36.2266
R61 GND.n57 GND.n48 18.7035
R62 GND.n54 GND.n53 18.7035
R63 GND.n59 GND.n0 12.7769
R64 GND.n68 GND.n67 12.7557
R65 GND.n72 GND.n6 10.6172
R66 GND.n57 GND.n56 10.6172
R67 GND.n55 GND.n53 10.6172
R68 GND.n42 GND.n41 10.6172
R69 GND.n66 GND.n65 10.6172
R70 GND.n77 GND.n1 10.59
R71 GND.n58 GND.n52 10.59
R72 GND.n61 GND.n60 10.59
R73 GND.n50 GND.n49 10.59
R74 GND.n54 GND.n48 10.2287
R75 GND.n56 GND.n55 10.2287
R76 GND.n61 GND.n52 10.2287
R77 GND.n76 GND.n2 10.0847
R78 GND.n73 GND.n5 10.0847
R79 GND.n58 GND.n57 8.97115
R80 GND.n60 GND.n53 8.97115
R81 GND.n49 GND.n42 8.97115
R82 GND.n65 GND.n42 8.08681
R83 GND.n70 GND.n8 7.68721
R84 GND.n68 GND.n10 7.68721
R85 GND.n74 GND.n4 7.62421
R86 GND.n75 GND.n3 6.77556
R87 GND.n65 GND.n64 6.67446
R88 GND.n71 GND.n7 6.44669
R89 GND.n69 GND.n9 6.44669
R90 GND.n67 GND.n66 5.17566
R91 GND.n41 GND.n6 5.17566
R92 GND.n50 GND.n1 5.17566
R93 GND.n74 GND.n73 3.91746
R94 GND.n72 GND.n71 2.80811
R95 GND.n73 GND.n72 2.14093
R96 GND.n70 GND.n69 2.08811
R97 GND.n75 GND.n74 1.57746
R98 GND.n77 GND.n76 0.773326
R99 GND.n76 GND.n75 0.563978
R100 GND.n71 GND.n70 0.526804
R101 GND.n69 GND.n68 0.526804
R102 GND.n49 GND.n0 0.439861
R103 GND.n59 GND.n58 0.403624
R104 GND.n60 GND.n59 0.382236
R105 GND.n78 GND.n0 0.335188
R106 GND.n78 GND.n77 0.086587
R107 GND GND.n78 0.0141957
R108 BP.n1 BP.n0 61.6449
R109 BP.n0 BP.t1 39.8898
R110 BP.n0 BP.t2 31.0255
R111 BP BP.n2 29.8482
R112 BP.n1 BP.t0 25.8112
R113 BP.n2 BP.t3 22.6984
R114 BP.n2 BP.n1 4.96987
R115 VDD.n37 VDD.t6 724.032
R116 VDD.n61 VDD.n60 712.12
R117 VDD.n45 VDD.n2 697.674
R118 VDD.n24 VDD.t9 685.271
R119 VDD.n50 VDD.n49 685.271
R120 VDD.n52 VDD.t10 685.271
R121 VDD.n23 VDD.n22 675.97
R122 VDD.n51 VDD.n50 675.97
R123 VDD.n36 VDD.n35 561.24
R124 VDD.n32 VDD.n31 561.24
R125 VDD.n28 VDD.n27 561.24
R126 VDD.t11 VDD.n2 558.14
R127 VDD.n48 VDD.t14 558.14
R128 VDD.t0 VDD.n33 555.039
R129 VDD.t5 VDD.n29 555.039
R130 VDD.n60 VDD.n59 550.389
R131 VDD.n25 VDD.n24 542.636
R132 VDD.n49 VDD.n48 542.636
R133 VDD.n53 VDD.n52 542.636
R134 VDD.n33 VDD.n32 506.978
R135 VDD.n29 VDD.n28 506.978
R136 VDD.t6 VDD.n25 347.288
R137 VDD.t16 VDD.n53 347.288
R138 VDD.n55 VDD.n54 339.536
R139 VDD.t9 VDD.n23 311.628
R140 VDD.n35 VDD.t3 311.628
R141 VDD.n34 VDD.t0 311.628
R142 VDD.n31 VDD.t21 311.628
R143 VDD.n30 VDD.t5 311.628
R144 VDD.n27 VDD.t19 311.628
R145 VDD.n26 VDD.t11 311.628
R146 VDD.t1 VDD.n46 311.628
R147 VDD.t14 VDD.n47 311.628
R148 VDD.t10 VDD.n51 311.628
R149 VDD.t3 VDD.n34 296.125
R150 VDD.t21 VDD.n30 296.125
R151 VDD.t19 VDD.n26 296.125
R152 VDD.n47 VDD.t1 296.125
R153 VDD.n59 VDD.n58 289.923
R154 VDD.t12 VDD.n57 275.969
R155 VDD.n58 VDD.t12 265.116
R156 VDD.n54 VDD.t16 246.512
R157 VDD.n57 VDD.t2 220.155
R158 VDD.n56 VDD.n55 209.303
R159 VDD.n37 VDD.n36 117.829
R160 VDD.n46 VDD.n45 116.279
R161 VDD.t2 VDD.n56 102.326
R162 VDD.n45 VDD.n44 12.8954
R163 VDD.n38 VDD.n37 12.8954
R164 VDD.n42 VDD.n15 10.2587
R165 VDD.n40 VDD.n18 10.2587
R166 VDD.n38 VDD.n21 9.5865
R167 VDD.n1 VDD.n0 9.58202
R168 VDD.n11 VDD.n10 9.58202
R169 VDD.n7 VDD.n6 9.03691
R170 VDD.n9 VDD.n8 8.44781
R171 VDD.n5 VDD.n4 5.47481
R172 VDD VDD.n61 4.12669
R173 VDD.n12 VDD.t15 3.31133
R174 VDD.n11 VDD.n9 3.09572
R175 VDD.n43 VDD.n14 1.98133
R176 VDD.n41 VDD.n17 1.98133
R177 VDD.n39 VDD.n20 1.98133
R178 VDD.n44 VDD.n43 1.86898
R179 VDD.n42 VDD.n41 1.67137
R180 VDD.n40 VDD.n39 1.67137
R181 VDD.n7 VDD.n5 1.36224
R182 VDD.n44 VDD.n12 1.36224
R183 VDD.n4 VDD.t13 1.313
R184 VDD.n14 VDD.n13 1.1905
R185 VDD.n17 VDD.n16 1.1905
R186 VDD.n20 VDD.n19 1.1905
R187 VDD.n14 VDD.t20 1.173
R188 VDD.n17 VDD.t22 1.173
R189 VDD.n20 VDD.t4 1.173
R190 VDD.n39 VDD.n38 1.1392
R191 VDD.n43 VDD.n42 1.09224
R192 VDD.n41 VDD.n40 1.09224
R193 VDD.n9 VDD.n7 0.974848
R194 VDD.n5 VDD.n1 0.923978
R195 VDD.n12 VDD.n11 0.923978
R196 VDD.n61 VDD.n1 0.702891
R197 VDD.n4 VDD.n3 0.368
R198 Cin.t1 Cin.t0 70.9148
R199 Cin.n3 Cin.n2 64.3344
R200 Cin.n1 Cin.t1 57.7716
R201 Cin.t3 Cin.n1 56.4716
R202 Cin.n0 Cin.t2 38.3255
R203 Cin.n2 Cin.t6 37.5434
R204 Cin.n2 Cin.t5 33.3719
R205 Cin.n3 Cin.t7 28.6791
R206 Cin.n0 Cin.t4 24.1166
R207 Cin.n3 Cin.t3 20.5969
R208 Cin Cin.n3 14.3423
R209 Cin.n1 Cin.n0 13.027
R210 A2.t1 A2.t0 464.651
R211 A2.t0 A2.t5 65.5701
R212 A2.n0 A2.t4 36.6922
R213 A2.n1 A2.t2 31.4779
R214 A2.n0 A2.t3 28.0886
R215 A2.n1 A2.t1 21.5708
R216 A2.n2 A2.n0 18.1154
R217 A2.n2 A2.n1 8.0005
R218 A2 A2.n2 0.006125
R219 P2.t0 P2.n1 866.122
R220 P2.n1 P2.t4 690.241
R221 P2.t3 P2.t2 68.3076
R222 P2.t4 P2.t5 65.5701
R223 P2.n1 P2.t3 55.2719
R224 P2.n4 P2.t8 50.2493
R225 P2.n6 P2.t11 43.7679
R226 P2.n0 P2.t9 36.6922
R227 P2.n7 P2.n6 36.4193
R228 P2.n2 P2.t0 31.4779
R229 P2.n0 P2.t7 28.0886
R230 P2.n6 P2.t10 25.2572
R231 P2.n2 P2.t6 21.5708
R232 P2.n4 P2.t1 13.7493
R233 P2.n3 P2.n0 13.6154
R234 P2.n5 P2.n4 12.5005
R235 P2.n3 P2.n2 12.5005
R236 P2 P2.n7 6.72688
R237 P2.n5 P2.n3 1.77929
R238 P2.n7 P2.n5 0.149964
R239 B2.t3 B2.t4 326.356
R240 B2.t4 B2.t1 65.5701
R241 B2.n1 B2.n0 64.3344
R242 B2.n0 B2.t0 37.5434
R243 B2.n0 B2.t5 33.3719
R244 B2.n1 B2.t2 28.6791
R245 B2.n1 B2.t3 20.5969
R246 B2 B2.n1 14.3447
R247 S1.n12 S1.n11 61.2394
R248 S1.n8 S1.n7 61.2394
R249 S1.n4 S1.n3 61.2394
R250 S1.n1 S1.n0 61.2394
R251 S1.n11 S1.t9 39.8898
R252 S1.n7 S1.t13 39.8898
R253 S1.n3 S1.t1 39.8898
R254 S1.n0 S1.t5 39.8898
R255 S1.n12 S1.t8 33.3719
R256 S1.n8 S1.t12 33.3719
R257 S1.n4 S1.t0 33.3719
R258 S1.n1 S1.t4 33.3719
R259 S1.n11 S1.t11 31.0255
R260 S1.n7 S1.t15 31.0255
R261 S1.n3 S1.t3 31.0255
R262 S1.n0 S1.t7 31.0255
R263 S1.n6 S1.n2 23.0071
R264 S1.n13 S1.t10 22.4219
R265 S1.n2 S1.t6 22.2916
R266 S1.n5 S1.t2 21.1184
R267 S1.n9 S1.t14 20.7273
R268 S1.n10 S1.n9 20.5544
R269 S1.n6 S1.n5 20.5544
R270 S1.n14 S1.n13 11.6505
R271 S1.n14 S1.n10 11.3374
R272 S1.n9 S1.n8 5.08443
R273 S1.n5 S1.n4 4.69336
R274 S1.n2 S1.n1 3.52014
R275 S1.n13 S1.n12 3.38979
R276 S1.n10 S1.n6 2.13953
R277 S1 S1.n14 0.00523684
R278 S0.n21 S0.n20 64.1999
R279 S0.n16 S0.n15 64.1999
R280 S0.n10 S0.n9 64.1999
R281 S0.n5 S0.n4 64.1999
R282 S0.n14 S0.n13 63.7944
R283 S0.n8 S0.n7 63.7944
R284 S0.n3 S0.n2 63.7944
R285 S0.n1 S0.n0 63.7944
R286 S0.n20 S0.t19 39.8898
R287 S0.n15 S0.t27 39.8898
R288 S0.n13 S0.t30 39.8898
R289 S0.n9 S0.t3 39.8898
R290 S0.n7 S0.t6 39.8898
R291 S0.n4 S0.t11 39.8898
R292 S0.n2 S0.t14 39.8898
R293 S0.n0 S0.t22 39.8898
R294 S0.n20 S0.t21 31.0255
R295 S0.n15 S0.t29 31.0255
R296 S0.n13 S0.t31 31.0255
R297 S0.n9 S0.t5 31.0255
R298 S0.n7 S0.t7 31.0255
R299 S0.n4 S0.t13 31.0255
R300 S0.n2 S0.t15 31.0255
R301 S0.n0 S0.t23 31.0255
R302 S0.n21 S0.t16 27.5059
R303 S0.n16 S0.t24 27.5059
R304 S0.n14 S0.t25 27.5059
R305 S0.n10 S0.t0 27.5059
R306 S0.n8 S0.t1 27.5059
R307 S0.n5 S0.t8 27.5059
R308 S0.n3 S0.t9 27.5059
R309 S0.n1 S0.t17 27.5059
R310 S0.n17 S0.n14 21.3785
R311 S0.n11 S0.n8 21.3785
R312 S0.n6 S0.n3 21.3785
R313 S0.n19 S0.n1 21.3785
R314 S0.n21 S0.t18 21.2487
R315 S0.n16 S0.t26 21.2487
R316 S0.n14 S0.t28 21.2487
R317 S0.n10 S0.t2 21.2487
R318 S0.n8 S0.t4 21.2487
R319 S0.n5 S0.t10 21.2487
R320 S0.n3 S0.t12 21.2487
R321 S0.n1 S0.t20 21.2487
R322 S0.n17 S0.n16 18.7055
R323 S0.n11 S0.n10 18.7055
R324 S0.n6 S0.n5 18.7055
R325 S0.n22 S0.n21 14.2055
R326 S0.n12 S0.n6 6.78517
R327 S0.n19 S0.n18 6.75431
R328 S0.n12 S0.n11 4.5005
R329 S0.n18 S0.n17 4.5005
R330 S0.n22 S0.n19 4.5005
R331 S0.n18 S0.n12 2.2729
R332 S0 S0.n22 0.003875
R333 P1.t2 P1.n1 866.122
R334 P1.n1 P1.t6 690.241
R335 P1.t5 P1.t4 68.3076
R336 P1.t6 P1.t7 65.5701
R337 P1.n1 P1.t5 55.2719
R338 P1.n4 P1.t10 50.2493
R339 P1.n6 P1.t1 43.7679
R340 P1.n7 P1.n6 41.4919
R341 P1.n0 P1.t11 36.6922
R342 P1.n2 P1.t2 31.4779
R343 P1.n0 P1.t9 28.0886
R344 P1.n6 P1.t0 25.2572
R345 P1.n2 P1.t8 21.5708
R346 P1.n4 P1.t3 13.7493
R347 P1.n3 P1.n0 13.6154
R348 P1.n5 P1.n4 12.5005
R349 P1.n3 P1.n2 12.5005
R350 P1 P1.n7 5.61554
R351 P1.n5 P1.n3 1.77929
R352 P1.n7 P1.n5 1.27496
R353 P0.t3 P0.n1 866.122
R354 P0.n1 P0.t7 690.241
R355 P0.t6 P0.t5 68.3076
R356 P0.t7 P0.t8 65.5701
R357 P0.n1 P0.t6 55.2719
R358 P0.n4 P0.t11 50.2493
R359 P0.n6 P0.t2 43.7679
R360 P0.n0 P0.t12 36.6922
R361 P0.n2 P0.t3 31.4779
R362 P0.n7 P0.n6 29.8878
R363 P0.n0 P0.t10 28.0886
R364 P0.n6 P0.t1 25.2572
R365 P0.n2 P0.t9 21.5708
R366 P0.n4 P0.t4 13.7493
R367 P0.n3 P0.n0 13.6154
R368 P0.n5 P0.n4 12.5005
R369 P0.n3 P0.n2 12.5005
R370 P0.n8 P0.n7 6.70438
R371 P0.n8 P0.t0 3.11712
R372 P0.n5 P0.n3 1.77929
R373 P0.n7 P0.n5 0.151571
R374 P0 P0.n8 0.010625
R375 P3.t2 P3.n1 866.122
R376 P3.n1 P3.t6 690.241
R377 P3.t5 P3.t4 68.3076
R378 P3.t6 P3.t7 65.5701
R379 P3.n1 P3.t5 55.2719
R380 P3.n4 P3.t10 50.2493
R381 P3.n6 P3.t0 43.7679
R382 P3.n0 P3.t11 36.6922
R383 P3.n7 P3.n6 33.8483
R384 P3.n2 P3.t2 31.4779
R385 P3.n0 P3.t9 28.0886
R386 P3.n6 P3.t1 25.2572
R387 P3.n2 P3.t8 21.5708
R388 P3.n4 P3.t3 13.7493
R389 P3.n3 P3.n0 13.6154
R390 P3.n5 P3.n4 12.5005
R391 P3.n3 P3.n2 12.5005
R392 P3 P3.n7 6.70711
R393 P3.n5 P3.n3 1.77929
R394 P3.n7 P3.n5 0.167643
R395 A3.t1 A3.t0 464.651
R396 A3.t0 A3.t5 65.5701
R397 A3.n0 A3.t4 36.6922
R398 A3.n1 A3.t2 31.4779
R399 A3.n0 A3.t3 28.0886
R400 A3.n1 A3.t1 21.5708
R401 A3.n2 A3.n0 18.1154
R402 A3.n2 A3.n1 8.0005
R403 A3 A3.n2 0.003875
R404 B3.t3 B3.t4 326.356
R405 B3.t4 B3.t1 65.5701
R406 B3.n1 B3.n0 64.3344
R407 B3.n0 B3.t0 37.5434
R408 B3.n0 B3.t5 33.3719
R409 B3.n1 B3.t2 28.6791
R410 B3.n1 B3.t3 20.5969
R411 B3 B3.n1 14.3471
R412 A0.t1 A0.t0 464.651
R413 A0.t0 A0.t5 65.5701
R414 A0.n0 A0.t4 36.6922
R415 A0.n1 A0.t2 31.4779
R416 A0.n0 A0.t3 28.0886
R417 A0.n1 A0.t1 21.5708
R418 A0.n2 A0.n0 18.1154
R419 A0.n2 A0.n1 8.0005
R420 A0 A0.n2 0.003875
R421 B0.t3 B0.t4 326.356
R422 B0.t4 B0.t1 65.5701
R423 B0.n1 B0.n0 64.3344
R424 B0.n0 B0.t0 37.5434
R425 B0.n0 B0.t5 33.3719
R426 B0.n1 B0.t2 28.6791
R427 B0.n1 B0.t3 20.5969
R428 B0 B0.n1 14.3471
R429 Y0 Y0.n1 9.58433
R430 Y0 Y0.n0 8.79885
R431 A1.t1 A1.t0 464.651
R432 A1.t0 A1.t5 65.5701
R433 A1.n0 A1.t4 36.6922
R434 A1.n1 A1.t2 31.4779
R435 A1.n0 A1.t3 28.0886
R436 A1.n1 A1.t1 21.5708
R437 A1.n2 A1.n0 18.1154
R438 A1.n2 A1.n1 8.0005
R439 A1 A1.n2 0.008375
R440 B1.t3 B1.t4 326.356
R441 B1.t4 B1.t1 65.5701
R442 B1.n1 B1.n0 64.3344
R443 B1.n0 B1.t0 37.5434
R444 B1.n0 B1.t5 33.3719
R445 B1.n1 B1.t2 28.6791
R446 B1.n1 B1.t3 20.5969
R447 B1 B1.n1 14.3459
C0 P2 Y2 0.00459f
C1 1bitblock$3_0/m2_9431_79# 1bitblock$3_0/a_8723_63# -0
C2 P1 1bitblock$1_0/m2_9431_79# 0
C3 AND4_0/a_518_229# m1_12484_n953# 0.00876f
C4 A1 A0 0.16333f
C5 A1 P1 0.02455f
C6 P1 1bitblock$1_0/a_870_n37# 0
C7 Cin S1 0.0504f
C8 P2 1bitblock$1_0/a_2861_391# 0.00705f
C9 P3 B3 0.00199f
C10 Y0 S1 0.00105f
C11 1bitblock$1_0/a_2861_3# 1bitblock_0/a_2419_63# 0
C12 1bitblock$1_0/a_2419_63# 1bitblock_0/a_2861_3# 0
C13 m1_12480_n3815# BP 0
C14 1bitblock_0/a_6128_n37# S0 0
C15 1bitblock_0/a_8361_407# S1 0
C16 B2 VDD 0.00489f
C17 1bitblock_0/a_160_63# 1bitblock$1_0/a_160_63# 0.04611f
C18 1bitblock_0/a_7768_n37# S1 0
C19 1bitblock$3_0/m2_7791_79# VDD -0
C20 P3 1bitblock$3_0/a_3940_63# 0
C21 1bitblock$1_0/a_5042_n37# S0 0
C22 1bitblock_0/a_7083_63# S1 0.05365f
C23 1bitblock$1_0/a_3498_3# S1 0.00389f
C24 1bitblock$1_0/a_7410_63# P1 0
C25 1bitblock_0/m2_9431_79# VDD -0.00109f
C26 1bitblock$1_0/a_2861_3# VDD 0.00101f
C27 Cin P2 0
C28 Cin MUX21_0/a_718_407# 0
C29 P0 S1 0.01252f
C30 P3 1bitblock$2_0/a_705_407# 0
C31 1bitblock$2_0/a_11922_3# VDD 0.00103f
C32 1bitblock$1_0/a_705_407# 1bitblock$2_0/a_510_63# 0
C33 1bitblock$3_0/m2_9431_79# S1 0.02041f
C34 1bitblock_0/a_7410_63# S1 0.00465f
C35 1bitblock_0/a_5042_407# VDD 0
C36 B1 1bitblock$2_0/a_705_407# 0
C37 1bitblock_0/a_8723_63# S1 0.07922f
C38 m1_12484_n953# 1bitblock$2_0/a_11922_3# 0.03274f
C39 P2 1bitblock$3_0/a_160_63# 0.00103f
C40 1bitblock$3_0/a_160_63# A2 0.00437f
C41 P2 1bitblock$1_0/a_3498_3# 1.69486f
C42 P2 1bitblock$2_0/a_11480_63# 0.00938f
C43 1bitblock$2_0/a_1262_n37# 1bitblock$3_0/a_705_407# 0
C44 1bitblock$1_0/a_4290_63# VDD 0
C45 P3 1bitblock$2_0/a_3498_3# 0
C46 P1 1bitblock_0/a_2861_3# 0.00149f
C47 1bitblock_0/a_11480_63# m1_12486_242# 0.00896f
C48 P0 P2 0.00193f
C49 P0 MUX21_0/a_718_407# 0
C50 P3 1bitblock$2_0/a_160_63# 0.00107f
C51 P0 1bitblock_0/a_1845_466# 0.01466f
C52 1bitblock$2_0/a_11922_3# 1bitblock$3_0/a_11922_3# 0.0017f
C53 1bitblock$1_0/a_11480_63# BP 0
C54 1bitblock_0/a_1845_n37# P1 0.00311f
C55 m1_12484_n953# 1bitblock$2_0/a_11922_391# 0.00755f
C56 P1 1bitblock$1_0/a_1262_n37# 0
C57 P2 1bitblock$1_0/a_10906_n37# 0.00153f
C58 P3 VDD 0.69902f
C59 1bitblock$2_0/a_10906_466# VDD 0.00105f
C60 P0 A1 0.00373f
C61 1bitblock_0/a_3940_63# m1_12486_242# 0
C62 B1 VDD 0.00489f
C63 1bitblock_0/a_6520_n37# S0 0.0015f
C64 1bitblock$1_0/a_510_63# A2 0
C65 1bitblock_0/a_8160_n37# S1 0.00164f
C66 1bitblock$3_0/a_8723_63# VDD -0.00531f
C67 1bitblock$3_0/a_3498_3# 1bitblock$3_0/a_1845_466# -0
C68 P2 B3 0.00248f
C69 1bitblock$2_0/m2_7791_79# 1bitblock$2_0/m2_9431_79# -0.00474f
C70 P3 m1_12484_n953# 0.08498f
C71 m1_12484_n953# 1bitblock$2_0/a_10906_466# 0.0176f
C72 AND4_0/a_518_229# 1bitblock$1_0/a_11922_3# 0.0046f
C73 P3 Y3 0.00478f
C74 1bitblock$2_0/m2_7791_79# VDD -0
C75 1bitblock$2_0/a_3940_63# P3 0
C76 P2 1bitblock$3_0/a_3940_63# 0
C77 BP m2_10721_n3315# 0.00204f
C78 1bitblock_0/m2_9431_79# 1bitblock_0/a_3498_3# -0
C79 A3 P3 0.0031f
C80 P3 1bitblock$3_0/a_11922_3# 0.01495f
C81 S1 1bitblock$2_0/a_3498_3# 0.00389f
C82 S1 1bitblock_0/a_2419_63# 0.00658f
C83 P0 m1_12480_n3815# 0
C84 S0 m2_10721_n3315# 0.04805f
C85 P2 1bitblock$2_0/a_705_407# 0.00549f
C86 1bitblock$2_0/m2_9431_79# S1 0.02467f
C87 1bitblock$2_0/a_7410_63# S1 0.00637f
C88 S1 1bitblock$1_0/m2_7791_79# 0.02398f
C89 P3 1bitblock$3_0/a_11922_391# 0.00701f
C90 1bitblock$1_0/a_705_407# 1bitblock_0/a_510_63# 0
C91 S1 VDD 0.27477f
C92 BP AND4_0/a_704_n441# 0.00119f
C93 A1 1bitblock$2_0/a_705_407# 0
C94 P0 1bitblock_0/a_2861_3# 0.0205f
C95 S0 1bitblock$3_0/a_7083_63# 0.00109f
C96 A2 1bitblock$2_0/a_3498_3# -0
C97 P2 1bitblock$2_0/a_3498_3# 1.47226f
C98 1bitblock$3_0/a_705_407# 1bitblock$3_0/a_2861_3# -0
C99 B1 1bitblock_0/a_705_407# 0
C100 P2 1bitblock_0/a_2419_63# 0
C101 1bitblock$3_0/a_10906_n37# m2_10721_n3315# 0.00484f
C102 A2 1bitblock$2_0/a_160_63# 0
C103 P2 1bitblock$2_0/a_160_63# 0
C104 m1_12484_n953# S1 0.05077f
C105 P2 1bitblock$2_0/m2_9431_79# 0.01952f
C106 P0 1bitblock_0/a_1845_n37# 0
C107 P3 1bitblock$3_0/a_10906_466# 0.01097f
C108 1bitblock$2_0/a_11922_3# 1bitblock$1_0/a_11922_3# 0
C109 P2 1bitblock$2_0/a_7410_63# 0.00156f
C110 1bitblock$2_0/a_7083_63# VDD 0
C111 P2 1bitblock$1_0/m2_7791_79# 0.0169f
C112 P0 1bitblock$1_0/a_1262_n37# 0
C113 S1 m1_12486_242# 0.05039f
C114 1bitblock$2_0/a_1845_466# P1 0.0015f
C115 Y3 S1 0.00105f
C116 1bitblock$1_0/a_160_63# 1bitblock_0/a_510_63# 0
C117 A2 VDD 0.03105f
C118 MUX21_0/a_718_407# VDD 0.0018f
C119 P2 VDD 1.58588f
C120 P1 AND4_0/a_704_n441# 0.01591f
C121 P2 1bitblock$2_0/a_10906_n37# 0.00148f
C122 1bitblock$3_0/a_3498_3# 1bitblock$3_0/a_2861_3# -0
C123 1bitblock$3_0/a_6128_n37# S0 0
C124 1bitblock$2_0/m2_9431_79# 1bitblock$2_0/a_8723_63# -0
C125 A1 1bitblock$2_0/a_160_63# 0
C126 1bitblock$2_0/a_11480_63# 1bitblock$1_0/a_11480_63# 0.00182f
C127 1bitblock_0/a_1845_466# VDD 0
C128 1bitblock$1_0/m2_7791_79# 1bitblock$1_0/m2_9431_79# -0.00474f
C129 AND4_0/a_1120_n441# BP 0.00515f
C130 P3 1bitblock$3_0/a_2419_63# 0.07504f
C131 B1 1bitblock_0/a_160_63# 0.00373f
C132 1bitblock$2_0/a_8723_63# VDD -0.0053f
C133 S1 1bitblock$1_0/a_7083_63# 0.05469f
C134 1bitblock$2_0/a_9050_63# VDD 0
C135 P2 m1_12484_n953# 0.16107f
C136 1bitblock$1_0/m2_9431_79# VDD -0
C137 A1 VDD 0.03103f
C138 P3 1bitblock$3_0/a_1262_n37# -0
C139 P2 m1_12486_242# 0.0866f
C140 P2 1bitblock$2_0/a_3940_63# 0
C141 P2 A3 0.00389f
C142 A3 A2 0.14833f
C143 P3 1bitblock$1_0/a_11922_3# 0
C144 AND4_0/a_1120_n441# P1 0.00916f
C145 S1 1bitblock$1_0/a_8723_63# 0.09524f
C146 1bitblock_0/a_5768_63# S0 0.01316f
C147 P1 B0 0.00257f
C148 P2 1bitblock$1_0/a_7083_63# 0.00482f
C149 1bitblock$1_0/a_7410_63# VDD 0
C150 P3 1bitblock$2_0/a_510_63# 0
C151 1bitblock_0/a_3498_3# S1 0.00142f
C152 1bitblock_0/a_5768_63# P1 0
C153 B1 1bitblock$2_0/a_510_63# 0
C154 m1_12480_n3815# VDD 0.04173f
C155 BP 1bitblock$1_0/a_2419_63# 0.00162f
C156 S1 1bitblock$3_0/a_2419_63# 0.00663f
C157 P2 1bitblock$1_0/a_8723_63# 0.02997f
C158 P3 1bitblock$3_0/a_7410_63# 0.0016f
C159 MUX21_0/a_157_63# BP 0.01122f
C160 m1_12484_n953# m1_12480_n3815# 0
C161 1bitblock$1_0/a_5243_407# S0 0.01246f
C162 S0 1bitblock$1_0/a_2419_63# 0.00541f
C163 A1 1bitblock_0/a_705_407# 0
C164 1bitblock$2_0/a_10906_466# 1bitblock$1_0/a_10906_466# 0.00145f
C165 P0 AND4_0/a_704_n441# 0.01112f
C166 1bitblock$1_0/m2_9431_79# 1bitblock$1_0/a_8723_63# -0
C167 P3 1bitblock$3_0/a_2861_391# 0.01584f
C168 Y1 S1 0.00192f
C169 1bitblock_0/a_3498_3# 1bitblock_0/a_1845_466# -0
C170 1bitblock$3_0/a_11922_3# m1_12480_n3815# 0.00447f
C171 P1 1bitblock$1_0/a_2419_63# 0.4677f
C172 P2 1bitblock$3_0/a_2419_63# 0.00529f
C173 MUX21_0/a_157_63# P1 0
C174 P1 1bitblock$1_0/a_9609_407# -0
C175 P2 1bitblock$3_0/a_1262_n37# 0
C176 A1 1bitblock_0/a_160_63# 0.00432f
C177 1bitblock_0/a_160_63# 1bitblock$1_0/a_870_n37# 0.00138f
C178 P2 Y1 0.00482f
C179 P1 BP 0.85907f
C180 1bitblock$1_0/a_11480_63# VDD 0
C181 1bitblock$1_0/a_9050_63# S1 0.02224f
C182 P3 1bitblock$2_0/a_2419_63# 0.00534f
C183 1bitblock$2_0/a_2861_391# 1bitblock$2_0/a_705_407# -0
C184 1bitblock$3_0/a_1845_466# VDD 0
C185 S0 1bitblock$3_0/a_3498_3# 0
C186 P2 1bitblock$1_0/a_11922_3# 0.01205f
C187 1bitblock$3_0/a_9050_63# 1bitblock$3_0/m2_7791_79# -0
C188 P0 B0 0.00199f
C189 1bitblock$3_0/a_7410_63# S1 0.00461f
C190 1bitblock$1_0/a_705_407# B2 0
C191 P1 1bitblock$1_0/a_8361_407# -0
C192 P1 S0 0.03676f
C193 m1_12484_n953# 1bitblock$1_0/a_11480_63# 0.00279f
C194 P2 1bitblock$2_0/a_510_63# 0.00105f
C195 MUX21_0/a_909_n37# BP 0
C196 1bitblock$1_0/a_11480_63# m1_12486_242# 0.01269f
C197 1bitblock_0/a_705_407# 1bitblock_0/a_2861_3# -0
C198 A0 P1 0.01532f
C199 1bitblock$2_0/a_2861_3# 1bitblock$2_0/a_705_407# -0
C200 P2 1bitblock$1_0/a_11922_391# 0.00705f
C201 Cin 1bitblock$1_0/a_2419_63# 0.01284f
C202 P2 1bitblock$1_0/a_9050_63# 0.00507f
C203 Cin MUX21_0/a_157_63# 0
C204 m2_10721_n3315# VDD 0.0925f
C205 A1 1bitblock$2_0/a_510_63# 0
C206 1bitblock_0/a_705_407# 1bitblock$1_0/a_1262_n37# 0
C207 1bitblock$2_0/a_1845_466# 1bitblock$2_0/a_3498_3# -0
C208 1bitblock_0/a_4290_63# S0 0.00478f
C209 1bitblock_0/a_3498_3# 1bitblock_0/a_2861_3# -0
C210 1bitblock$1_0/a_9050_63# 1bitblock$1_0/m2_9431_79# -0
C211 1bitblock$2_0/a_2861_3# 1bitblock$2_0/a_3498_3# -0
C212 1bitblock_0/m2_7791_79# P1 0
C213 P2 1bitblock$1_0/a_10906_466# 0.0111f
C214 Cin BP 0.13525f
C215 m1_12484_n953# m2_10721_n3315# 1.5892f
C216 P0 1bitblock$1_0/a_2419_63# 0.004f
C217 1bitblock_0/a_4290_63# P1 0
C218 1bitblock$2_0/a_2419_63# S1 0.00665f
C219 Cin S0 0.05217f
C220 1bitblock$2_0/a_1845_466# VDD 0.00109f
C221 P0 MUX21_0/a_157_63# 0.0056f
C222 1bitblock$2_0/a_3940_63# m2_10721_n3315# 0
C223 1bitblock$3_0/a_9050_63# P3 0.00508f
C224 1bitblock$2_0/a_2861_3# VDD 0.00101f
C225 1bitblock$3_0/m2_6151_79# S0 0.01067f
C226 1bitblock$3_0/a_11922_3# m2_10721_n3315# 0.01722f
C227 1bitblock$3_0/a_160_63# 1bitblock$3_0/a_705_407# 0
C228 Cin P1 2.16295f
C229 S0 1bitblock$3_0/a_4290_63# 0.00473f
C230 P0 BP 0.09216f
C231 1bitblock_0/m2_7791_79# 1bitblock_0/a_9609_407# -0
C232 1bitblock_0/a_7083_63# S0 0.00107f
C233 1bitblock$1_0/a_3498_3# S0 0.05026f
C234 S0 1bitblock$2_0/a_4290_63# 0.00738f
C235 P2 1bitblock$2_0/a_2419_63# 0.07185f
C236 1bitblock_0/a_11922_3# P1 0
C237 1bitblock$3_0/a_11922_391# m2_10721_n3315# 0.00397f
C238 P0 S0 0.00325f
C239 1bitblock$3_0/a_9408_n37# S1 0
C240 1bitblock_0/a_7083_63# P1 0.02635f
C241 1bitblock$1_0/a_3498_3# P1 -0.0052f
C242 P0 A0 0.0031f
C243 1bitblock$3_0/m2_9431_79# 1bitblock$3_0/a_3498_3# -0
C244 1bitblock$1_0/a_5042_407# 1bitblock$1_0/a_4290_63# 0
C245 P0 P1 0.36644f
C246 B3 1bitblock$3_0/a_705_407# -0
C247 1bitblock$3_0/a_5042_407# S0 0.05824f
C248 1bitblock$3_0/a_10906_466# m2_10721_n3315# 0.0161f
C249 1bitblock_0/a_7410_63# P1 0
C250 1bitblock_0/a_8723_63# P1 0
C251 1bitblock$3_0/a_9050_63# S1 0.01697f
C252 P0 1bitblock_0/m2_7791_79# 0.01686f
C253 m2_10721_n3315# 1bitblock$3_0/a_2419_63# 0.02256f
C254 1bitblock$3_0/a_3940_63# S0 0.00284f
C255 1bitblock_0/a_3940_63# 1bitblock$1_0/a_3940_63# 0.01129f
C256 1bitblock$1_0/a_510_63# P1 0.00173f
C257 1bitblock_0/m2_7791_79# 1bitblock_0/a_7410_63# 0
C258 1bitblock$1_0/a_2419_63# 1bitblock$2_0/a_3498_3# 0
C259 Cin 1bitblock_0/a_11922_3# 0
C260 1bitblock$1_0/a_2419_63# 1bitblock_0/a_2419_63# 1.63229f
C261 P0 1bitblock_0/a_9609_407# 0.10113f
C262 1bitblock_0/a_4650_n37# S0 0.00119f
C263 1bitblock$3_0/a_9609_407# 1bitblock$3_0/m2_7791_79# -0
C264 AND4_0/a_518_229# P3 0.05606f
C265 1bitblock$2_0/a_705_407# 1bitblock$3_0/a_510_63# 0
C266 1bitblock$2_0/m2_6151_79# S0 0.01608f
C267 1bitblock$1_0/a_705_407# A2 0
C268 P2 1bitblock$1_0/a_705_407# 0.00123f
C269 P0 Cin 0.08467f
C270 1bitblock$1_0/a_2419_63# VDD 0.00292f
C271 1bitblock$2_0/a_2861_3# 1bitblock$3_0/a_2419_63# 0
C272 1bitblock$1_0/a_9609_407# 1bitblock$1_0/m2_7791_79# -0
C273 P0 Y0 0.00489f
C274 MUX21_0/a_157_63# VDD 0.00149f
C275 P1 1bitblock$2_0/a_705_407# 0.00123f
C276 1bitblock$3_0/a_705_407# 1bitblock$2_0/a_160_63# 0
C277 P0 1bitblock_0/a_11922_3# 0.01214f
C278 1bitblock$3_0/a_5768_63# S0 0.01326f
C279 1bitblock$3_0/a_9800_n37# S1 0.0014f
C280 P0 1bitblock_0/a_8361_407# 0.03596f
C281 S0 1bitblock$2_0/a_3498_3# 0.05092f
C282 m1_12484_n953# 1bitblock$1_0/a_2419_63# 0.00245f
C283 S0 1bitblock_0/a_2419_63# 0.00862f
C284 1bitblock$2_0/a_6721_407# S0 0.01358f
C285 1bitblock$1_0/a_9408_n37# S1 0
C286 P0 1bitblock_0/a_7083_63# 0.00482f
C287 1bitblock$1_0/a_2419_63# m1_12486_242# -0.00165f
C288 1bitblock$3_0/a_705_407# VDD -0
C289 1bitblock$2_0/a_160_63# 1bitblock$3_0/a_510_63# 0
C290 P0 1bitblock$1_0/a_3498_3# 0
C291 BP VDD 0.16195f
C292 Cin 1bitblock_0/a_10906_466# 0.00242f
C293 P3 B2 0.0025f
C294 1bitblock$1_0/a_160_63# A2 0
C295 P3 1bitblock$3_0/m2_7791_79# 0.01676f
C296 P1 1bitblock$2_0/a_3498_3# 0.0012f
C297 P1 1bitblock_0/a_2419_63# 0.36366f
C298 P0 1bitblock_0/a_11922_391# 0.00712f
C299 B1 B2 0.00593f
C300 S0 VDD 0.18639f
C301 1bitblock$2_0/a_5768_63# S0 0.01877f
C302 P0 1bitblock_0/a_7410_63# 0.00163f
C303 m1_12484_n953# BP 0.10897f
C304 1bitblock$2_0/a_5042_407# S0 0.06277f
C305 1bitblock$3_0/m2_7791_79# 1bitblock$3_0/a_8723_63# 0
C306 P1 1bitblock$1_0/m2_7791_79# 0
C307 P0 1bitblock_0/a_8723_63# 0.0292f
C308 1bitblock$3_0/a_3498_3# VDD -0.0086f
C309 P3 1bitblock$2_0/a_11922_3# 0
C310 BP m1_12486_242# 0.00988f
C311 P2 1bitblock$1_0/a_1845_466# 0.0015f
C312 A0 VDD 0.01777f
C313 P3 1bitblock$3_0/a_9609_407# 0.10003f
C314 m1_12484_n953# S0 0.05387f
C315 P1 VDD 0.08054f
C316 1bitblock$1_0/a_1845_466# 1bitblock_0/a_1845_466# 0.00192f
C317 P0 1bitblock_0/a_10906_466# 0.01125f
C318 S0 m1_12486_242# 0.0535f
C319 P0 1bitblock$1_0/a_510_63# 0
C320 1bitblock$2_0/a_3940_63# S0 0.00421f
C321 1bitblock_0/a_5042_n37# S0 0
C322 m1_12484_n953# P1 0.00165f
C323 P3 1bitblock$3_0/a_8361_407# 0.03557f
C324 1bitblock_0/m2_7791_79# VDD -0
C325 P1 m1_12486_242# 0.92821f
C326 A3 1bitblock$3_0/a_3498_3# -0
C327 AND4_0/a_518_229# P2 0.05061f
C328 AND4_0/a_518_229# MUX21_0/a_718_407# 0
C329 S0 1bitblock$1_0/a_7083_63# 0.00187f
C330 1bitblock$3_0/a_160_63# 1bitblock$2_0/a_705_407# 0
C331 AND4_0/a_518_229# AND4_0/a_912_n441# -0
C332 Cin 1bitblock_0/a_2419_63# 0.07066f
C333 1bitblock$2_0/a_2419_63# m2_10721_n3315# 0.00198f
C334 1bitblock$3_0/m2_7791_79# S1 0.01998f
C335 1bitblock_0/m2_9431_79# S1 0.02012f
C336 1bitblock$1_0/a_9800_n37# S1 0.0014f
C337 P1 1bitblock$1_0/a_7083_63# 0.03418f
C338 Cin VDD 0.00249f
C339 P3 1bitblock$3_0/a_8723_63# 0.02911f
C340 1bitblock$2_0/a_6128_n37# S0 0
C341 1bitblock$1_0/a_3498_3# 1bitblock$2_0/a_3498_3# 0.01312f
C342 1bitblock$3_0/a_9609_407# S1 0.00145f
C343 1bitblock$3_0/m2_6151_79# VDD 0
C344 S1 1bitblock$2_0/a_9408_n37# 0
C345 1bitblock_0/a_705_407# P1 0
C346 1bitblock$3_0/a_160_63# 1bitblock$2_0/a_160_63# 0.0454f
C347 P0 1bitblock_0/a_2419_63# 0.07947f
C348 P2 B2 0.00194f
C349 1bitblock_0/a_11922_3# VDD 0
C350 1bitblock_0/a_3498_3# S0 0
C351 P1 1bitblock$1_0/a_8723_63# -0
C352 1bitblock$3_0/a_705_407# 1bitblock$3_0/a_2419_63# -0
C353 1bitblock$1_0/a_510_63# 1bitblock$2_0/a_705_407# 0
C354 1bitblock_0/a_1262_n37# P1 0
C355 B3 1bitblock$2_0/a_705_407# 0
C356 1bitblock$2_0/a_2419_63# 1bitblock$3_0/a_2861_3# 0
C357 Cin m1_12486_242# 1.92011f
C358 P2 1bitblock$1_0/a_2861_3# 0.01004f
C359 1bitblock$3_0/a_160_63# VDD 0.02548f
C360 1bitblock$1_0/a_3498_3# VDD 0.03072f
C361 1bitblock$2_0/a_11480_63# VDD 0
C362 1bitblock$3_0/a_8361_407# S1 0
C363 1bitblock$2_0/a_4290_63# VDD 0
C364 A0 1bitblock_0/a_3498_3# -0
C365 S0 1bitblock$3_0/a_2419_63# 0.00867f
C366 P2 1bitblock$2_0/a_11922_3# 0.01144f
C367 1bitblock_0/a_3498_3# P1 0
C368 P0 VDD 0.68409f
C369 S0 1bitblock$3_0/a_6520_n37# 0.00151f
C370 A1 B2 0
C371 1bitblock_0/a_11922_3# m1_12486_242# 0.01844f
C372 A0 1bitblock_0/a_160_63# -0
C373 1bitblock_0/a_160_63# P1 0.00109f
C374 1bitblock$3_0/m2_9431_79# VDD -0.00106f
C375 1bitblock$3_0/a_3498_3# 1bitblock$3_0/a_2419_63# -0
C376 1bitblock$1_0/a_6128_n37# S0 0
C377 1bitblock$3_0/a_4650_n37# S0 0.00118f
C378 m1_12484_n953# 1bitblock$2_0/a_11480_63# 0.0167f
C379 1bitblock$1_0/a_11922_3# BP 0.00533f
C380 P3 S1 0.01251f
C381 1bitblock_0/a_9050_63# S1 0.01686f
C382 1bitblock_0/a_8723_63# VDD -0.0053f
C383 B3 1bitblock$2_0/a_160_63# 0.00364f
C384 P2 1bitblock$2_0/a_11922_391# 0.00681f
C385 P0 m1_12486_242# 0.0897f
C386 1bitblock$3_0/a_5042_407# VDD 0
C387 1bitblock$3_0/a_705_407# 1bitblock$2_0/a_510_63# 0
C388 1bitblock$3_0/a_8723_63# S1 0.08003f
C389 1bitblock_0/a_11922_391# m1_12486_242# 0.00287f
C390 1bitblock$1_0/a_510_63# VDD 0
C391 B3 VDD 0
C392 1bitblock$2_0/a_9609_407# 1bitblock$2_0/m2_7791_79# -0
C393 1bitblock$1_0/a_10906_n37# m1_12486_242# 0.00484f
C394 1bitblock$1_0/a_11922_3# P1 0
C395 1bitblock$2_0/m2_7791_79# S1 0.02388f
C396 P3 A2 0.00392f
C397 P2 P3 0.33711f
C398 1bitblock$2_0/a_6520_n37# S0 0.00151f
C399 P2 1bitblock$2_0/a_10906_466# 0.01059f
C400 1bitblock$3_0/a_3940_63# VDD 0
C401 MUX21_0/m2_540_79# MUX21_0/a_157_63# 0
C402 1bitblock_0/a_10906_466# m1_12486_242# 0.00953f
C403 B1 P2 0
C404 S1 1bitblock$2_0/a_9800_n37# 0.0014f
C405 B1 A2 0
C406 P0 1bitblock_0/a_2861_391# 0.01608f
C407 1bitblock$1_0/a_10906_466# BP 0
C408 P0 1bitblock_0/a_705_407# 0.00558f
C409 1bitblock$3_0/a_705_407# 1bitblock$3_0/a_2861_391# -0
C410 1bitblock$2_0/a_705_407# VDD 0.00817f
C411 1bitblock$2_0/a_9609_407# S1 0.01866f
C412 P1 1bitblock$1_0/a_1845_n37# 0.00561f
C413 MUX21_0/m2_540_79# BP 0.00787f
C414 1bitblock$1_0/a_9050_63# P1 0
C415 P2 1bitblock$2_0/m2_7791_79# 0.01632f
C416 P3 1bitblock$3_0/a_11480_63# 0.0097f
C417 1bitblock$2_0/a_3940_63# 1bitblock$3_0/a_3940_63# 0.01104f
C418 Cin 1bitblock_0/a_10906_n37# 0.00266f
C419 1bitblock$2_0/a_2419_63# 1bitblock$1_0/a_2419_63# 0.00365f
C420 1bitblock_0/a_9408_n37# S1 0
C421 P0 1bitblock_0/a_3498_3# 1.79259f
C422 1bitblock$3_0/a_3498_3# 1bitblock$3_0/a_2861_391# -0
C423 1bitblock$1_0/a_6520_n37# S0 0.00151f
C424 1bitblock$3_0/a_5042_n37# S0 0
C425 1bitblock$2_0/a_3498_3# VDD 0.02184f
C426 1bitblock$1_0/a_10906_466# P1 0
C427 1bitblock$2_0/a_9050_63# 1bitblock$2_0/m2_7791_79# -0
C428 1bitblock$2_0/a_8361_407# S1 0.00891f
C429 1bitblock_0/a_2419_63# VDD 0
C430 P0 1bitblock_0/a_160_63# 0
C431 1bitblock$2_0/a_160_63# VDD 0.02629f
C432 1bitblock$1_0/a_510_63# 1bitblock_0/a_705_407# 0
C433 Cin 1bitblock$1_0/a_11922_3# 0
C434 A3 1bitblock$2_0/a_705_407# 0
C435 1bitblock$2_0/a_7083_63# S1 0.0547f
C436 P2 1bitblock$2_0/a_9609_407# 0.09632f
C437 1bitblock$2_0/m2_9431_79# VDD -0
C438 1bitblock$1_0/a_705_407# B0 0
C439 1bitblock$2_0/a_7410_63# VDD 0
C440 1bitblock$2_0/a_1845_466# 1bitblock$1_0/a_1845_466# 0.00145f
C441 1bitblock$1_0/m2_7791_79# VDD -0
C442 P3 m1_12480_n3815# 0.07257f
C443 P2 S1 0.09192f
C444 1bitblock$1_0/a_11922_3# 1bitblock_0/a_11922_3# 0.00177f
C445 P0 1bitblock_0/a_10906_n37# 0.00154f
C446 1bitblock$2_0/a_5768_63# VDD 0
C447 m1_12486_242# 1bitblock_0/a_2419_63# 0.05407f
C448 S0 1bitblock$2_0/a_2419_63# 0.00972f
C449 1bitblock$2_0/a_5042_407# VDD 0
C450 1bitblock$2_0/a_8723_63# S1 0.09622f
C451 P2 1bitblock$2_0/a_8361_407# 0.03425f
C452 1bitblock$2_0/a_9050_63# S1 0.02224f
C453 S1 1bitblock$1_0/m2_9431_79# 0.02467f
C454 1bitblock$1_0/a_510_63# 1bitblock_0/a_160_63# 0
C455 A3 1bitblock$2_0/a_160_63# 0.00419f
C456 m1_12484_n953# VDD 0.32612f
C457 m1_12484_n953# 1bitblock$2_0/a_10906_n37# 0.00483f
C458 P2 1bitblock$2_0/a_7083_63# 0.00471f
C459 1bitblock$3_0/a_870_n37# 1bitblock$2_0/a_160_63# 0.00135f
C460 1bitblock$1_0/a_160_63# B0 0.00372f
C461 P1 1bitblock$2_0/a_2419_63# 0
C462 m1_12486_242# VDD 0.12729f
C463 1bitblock$2_0/a_870_n37# 1bitblock$3_0/a_160_63# 0.00135f
C464 1bitblock$3_0/a_160_63# 1bitblock$2_0/a_510_63# 0
C465 P2 A2 0.00302f
C466 P2 MUX21_0/a_718_407# 0.00276f
C467 1bitblock$2_0/a_3940_63# VDD 0
C468 AND4_0/a_912_n441# P2 0.0044f
C469 A3 VDD 0.018f
C470 1bitblock$3_0/a_11922_3# VDD 0
C471 m1_12484_n953# m1_12486_242# 0.0157f
C472 P2 1bitblock$2_0/a_8723_63# 0.02885f
C473 1bitblock_0/a_705_407# 1bitblock_0/a_2419_63# -0
C474 Cin MUX21_0/m2_540_79# 0.00831f
C475 1bitblock$2_0/a_9050_63# P2 0.00483f
C476 1bitblock$1_0/a_7410_63# S1 0.00637f
C477 P2 1bitblock$1_0/m2_9431_79# 0.0203f
C478 P0 1bitblock$1_0/a_1845_n37# 0
C479 1bitblock$2_0/a_1262_n37# P3 0
C480 A1 P2 0
C481 1bitblock$1_0/a_7083_63# VDD 0
C482 A1 A2 0.0286f
C483 m1_12484_n953# 1bitblock$3_0/a_11922_3# 0
C484 P1 1bitblock_0/a_510_63# 0
C485 S0 1bitblock$1_0/a_5768_63# 0.01876f
C486 1bitblock$2_0/a_11922_3# m2_10721_n3315# 0.00359f
C487 1bitblock_0/a_9800_n37# S1 0.00139f
C488 1bitblock$3_0/m2_9431_79# 1bitblock$3_0/a_7410_63# -0
C489 1bitblock_0/a_705_407# VDD -0
C490 P3 1bitblock$3_0/a_1845_466# 0.01449f
C491 1bitblock$3_0/a_1262_n37# 1bitblock$2_0/a_705_407# 0
C492 1bitblock$1_0/a_510_63# 1bitblock$2_0/a_510_63# 0.00154f
C493 1bitblock_0/a_3498_3# 1bitblock_0/a_2419_63# -0
C494 P1 1bitblock$1_0/a_5768_63# 0
C495 1bitblock$1_0/a_8723_63# VDD -0.00527f
C496 P2 1bitblock$1_0/a_7410_63# 0.00161f
C497 P0 MUX21_0/m2_540_79# 0.01323f
C498 1bitblock$2_0/a_2861_3# 1bitblock$1_0/a_2861_3# 0
C499 1bitblock_0/a_3498_3# VDD -0.00886f
C500 m1_12480_n3815# MUX21_0/a_718_407# 0.00296f
C501 1bitblock$1_0/m2_6151_79# S0 0.01607f
C502 A0 1bitblock$1_0/a_705_407# 0
C503 1bitblock_0/a_160_63# VDD 0.02528f
C504 P3 m2_10721_n3315# 0.17094f
C505 1bitblock$1_0/a_3498_3# 1bitblock$2_0/a_2419_63# 0
C506 1bitblock$2_0/a_10906_466# m2_10721_n3315# 0
C507 1bitblock$3_0/a_2419_63# VDD 0
C508 1bitblock$1_0/a_11922_3# 1bitblock_0/a_2419_63# 0
C509 P1 1bitblock$1_0/m2_6151_79# 0
C510 1bitblock$1_0/a_6721_407# S0 0.01358f
C511 m1_12484_n953# 1bitblock$3_0/a_2419_63# 0.04408f
C512 1bitblock_0/a_705_407# 1bitblock_0/a_2861_391# -0
C513 P3 1bitblock$3_0/a_7083_63# 0.0048f
C514 A0 1bitblock$1_0/a_160_63# 0.00441f
C515 1bitblock$3_0/a_7768_n37# S1 0
C516 1bitblock$2_0/a_1845_466# P3 0.00178f
C517 1bitblock$1_0/a_160_63# P1 0
C518 1bitblock$1_0/a_3940_63# 1bitblock$1_0/a_2419_63# -0
C519 AND4_0/a_518_229# 1bitblock$1_0/a_2419_63# 0.00114f
C520 1bitblock$1_0/a_11922_3# VDD 0.00267f
C521 1bitblock$2_0/a_3940_63# 1bitblock$3_0/a_2419_63# 0
C522 1bitblock$2_0/a_2861_3# P3 0.00145f
C523 1bitblock_0/a_10906_n37# m1_12486_242# 0.00168f
C524 1bitblock_0/a_1262_n37# 1bitblock_0/a_705_407# 0
C525 P0 1bitblock_0/a_510_63# 0.00107f
C526 1bitblock$1_0/a_5042_407# S0 0.06275f
C527 P3 1bitblock$3_0/a_2861_3# 0.01984f
C528 VDD 1bitblock$2_0/a_510_63# 0
C529 m1_12484_n953# 1bitblock$1_0/a_11922_3# 0.01185f
C530 1bitblock$1_0/a_9050_63# 1bitblock$1_0/m2_7791_79# -0
C531 P2 1bitblock$1_0/a_11480_63# 0.00982f
C532 A0 1bitblock$1_0/a_1845_466# 0
C533 AND4_0/a_518_229# BP 0.01804f
C534 P1 1bitblock$1_0/a_1845_466# 0.01233f
C535 1bitblock$1_0/a_11922_3# m1_12486_242# 0.01722f
C536 P2 1bitblock$3_0/a_1845_466# 0.00179f
C537 1bitblock$3_0/a_3940_63# 1bitblock$2_0/a_2419_63# 0
C538 A2 1bitblock$3_0/a_1845_466# 0
C539 1bitblock$1_0/a_9050_63# VDD 0
C540 P1 1bitblock$1_0/a_5042_407# 0.02321f
C541 MUX21_0/a_517_n37# BP 0
C542 S1 m2_10721_n3315# 0.0463f
C543 1bitblock$1_0/a_3940_63# S0 0.00421f
C544 P2 1bitblock$3_0/a_1845_n37# 0.00179f
C545 m1_12484_n953# 1bitblock$1_0/a_11922_391# 0.00359f
C546 AND4_0/a_1120_n441# P3 0.0044f
C547 1bitblock$2_0/a_2419_63# 1bitblock$2_0/a_705_407# -0
C548 1bitblock$2_0/a_7768_n37# S1 0
C549 1bitblock$1_0/a_11922_391# m1_12486_242# 0.00397f
C550 1bitblock$1_0/a_10906_466# VDD 0.00111f
C551 1bitblock_0/m2_6151_79# S0 0.01043f
C552 AND4_0/a_518_229# P1 0.02153f
C553 P0 1bitblock$1_0/a_705_407# 0
C554 P1 1bitblock$1_0/a_3940_63# 0.00175f
C555 1bitblock$3_0/a_9050_63# 1bitblock$3_0/m2_9431_79# -0
C556 S1 1bitblock$3_0/a_7083_63# 0.0537f
C557 MUX21_0/m2_540_79# VDD -0.00173f
C558 B2 1bitblock$3_0/a_705_407# 0
C559 P2 m2_10721_n3315# 0.01658f
C560 m1_12484_n953# 1bitblock$1_0/a_10906_466# 0
C561 1bitblock$2_0/a_2419_63# 1bitblock$2_0/a_3498_3# -0
C562 1bitblock_0/m2_6151_79# P1 0
C563 1bitblock$1_0/a_10906_466# m1_12486_242# 0.0161f
C564 P2 1bitblock$2_0/a_2861_391# 0.01578f
C565 1bitblock$3_0/a_8160_n37# S1 0.00163f
C566 1bitblock$1_0/a_7768_n37# S1 0
C567 P0 1bitblock$1_0/a_160_63# 0.00107f
C568 1bitblock_0/a_3940_63# 1bitblock$1_0/a_2419_63# 0
C569 1bitblock$2_0/a_1845_466# P2 0.01396f
C570 P1 B2 0
C571 1bitblock$2_0/a_2419_63# VDD 0.00232f
C572 1bitblock$3_0/a_11480_63# m2_10721_n3315# 0.01269f
C573 1bitblock$2_0/a_2861_3# P2 0.01973f
C574 1bitblock_0/a_5042_407# S0 0.05822f
C575 1bitblock_0/m2_9431_79# P1 0
C576 P1 1bitblock$1_0/a_2861_3# 0
C577 P3 1bitblock$1_0/a_2419_63# 0
C578 P2 1bitblock$3_0/a_2861_3# 0.00145f
C579 Cin AND4_0/a_518_229# 0
C580 m1_12484_n953# 1bitblock$2_0/a_2419_63# 0.03322f
C581 P3 MUX21_0/a_157_63# 0
C582 P0 1bitblock$1_0/a_1845_466# 0.00183f
C583 Cin MUX21_0/a_517_n37# 0
C584 S0 1bitblock$1_0/a_4290_63# 0.00738f
C585 1bitblock_0/a_5042_407# P1 0.01787f
C586 1bitblock$1_0/a_705_407# 1bitblock$2_0/a_705_407# 0.04927f
C587 1bitblock_0/m2_7791_79# 1bitblock_0/m2_9431_79# -0.00444f
C588 1bitblock_0/a_3940_63# S0 0.00286f
C589 m1_12480_n3815# m2_10721_n3315# 0.02463f
C590 P3 1bitblock$3_0/a_705_407# 0.00558f
C591 1bitblock$3_0/a_11922_3# 1bitblock$2_0/a_2419_63# 0
C592 P3 BP 0.00988f
C593 P1 1bitblock$1_0/a_4290_63# 0
C594 AND4_0/a_1120_n441# P2 0
C595 VDD 1bitblock$1_0/a_5768_63# 0
C596 P3 S0 0.00329f
C597 P0 AND4_0/a_518_229# 0.01521f
C598 1bitblock_0/a_3940_63# P1 0.00164f
C599 P0 1bitblock$1_0/a_3940_63# 0
C600 P3 1bitblock$3_0/a_510_63# 0.00107f
C601 P0 MUX21_0/a_517_n37# 0
C602 1bitblock$1_0/a_705_407# 1bitblock$2_0/a_160_63# 0
C603 1bitblock$1_0/a_160_63# 1bitblock$2_0/a_705_407# 0
C604 P3 1bitblock$3_0/a_3498_3# 1.66674f
C605 1bitblock_0/a_5042_407# 1bitblock_0/a_4290_63# -0
C606 P3 P1 0.0051f
C607 1bitblock_0/a_9050_63# P1 0
C608 1bitblock$1_0/a_8160_n37# S1 0.00164f
C609 S1 1bitblock$1_0/a_2419_63# 0.00237f
C610 1bitblock$1_0/a_705_407# VDD 0.00876f
C611 B1 P1 0.00848f
C612 Cin 1bitblock_0/a_11480_63# 0
C613 1bitblock$3_0/a_160_63# B2 0.00362f
C614 1bitblock$2_0/a_4650_n37# S0 0.00119f
C615 P3 1bitblock$3_0/a_10906_n37# 0.00152f
C616 1bitblock$1_0/a_9609_407# S1 0.01871f
C617 1bitblock$1_0/m2_6151_79# VDD 0
C618 1bitblock_0/m2_7791_79# 1bitblock_0/a_9050_63# -0
C619 1bitblock$1_0/a_160_63# 1bitblock$2_0/a_160_63# 0.00196f
C620 1bitblock$3_0/m2_7791_79# 1bitblock$3_0/m2_9431_79# -0.00447f
C621 P0 1bitblock_0/m2_9431_79# 0.02029f
C622 S0 1bitblock$2_0/a_5243_407# 0.01246f
C623 P0 1bitblock$1_0/a_2861_3# 0.00149f
C624 1bitblock_0/a_870_n37# 1bitblock$1_0/a_160_63# 0.00138f
C625 1bitblock$2_0/a_2419_63# 1bitblock$3_0/a_2419_63# 1.31417f
C626 P2 1bitblock$1_0/a_2419_63# 0.01135f
C627 1bitblock$1_0/a_160_63# VDD 0.0263f
C628 1bitblock_0/m2_9431_79# 1bitblock_0/a_7410_63# -0
C629 P2 MUX21_0/a_157_63# 0
C630 1bitblock$1_0/a_8361_407# S1 0.00891f
C631 S0 S1 0.00777f
C632 1bitblock_0/m2_9431_79# 1bitblock_0/a_8723_63# -0
C633 P0 1bitblock_0/a_11480_63# 0.00995f
C634 1bitblock$2_0/a_1845_n37# P3 0.00179f
C635 P2 1bitblock$1_0/a_9609_407# 0.1012f
C636 Cin P3 0
C637 1bitblock$3_0/a_3498_3# S1 0.0014f
C638 1bitblock$1_0/a_510_63# B2 0
C639 1bitblock$1_0/a_4650_n37# S0 0.00119f
C640 P2 1bitblock$3_0/a_705_407# 0
C641 1bitblock$2_0/a_1845_466# 1bitblock$3_0/a_1845_466# 0.00184f
C642 P1 S1 0.03255f
C643 A2 1bitblock$3_0/a_705_407# 0
C644 P2 BP 0.00583f
C645 1bitblock$1_0/a_1845_466# VDD 0.00107f
C646 1bitblock$2_0/a_7083_63# S0 0.00187f
C647 AND4_0/a_912_n441# BP 0.00402f
C648 1bitblock$1_0/a_5042_407# VDD 0
C649 P0 1bitblock_0/a_3940_63# 0
C650 S1 Y2 0.00192f
C651 1bitblock$1_0/a_3940_63# 1bitblock_0/a_2419_63# 0
C652 P2 S0 0.06231f
C653 P2 1bitblock$1_0/a_8361_407# 0.03598f
C654 P2 1bitblock$3_0/a_510_63# 0
C655 1bitblock$3_0/a_160_63# P3 0
C656 1bitblock_0/a_1262_n37# 1bitblock$1_0/a_705_407# 0
C657 1bitblock_0/m2_7791_79# S1 0.01993f
C658 P2 1bitblock$3_0/a_3498_3# 0
C659 B2 1bitblock$2_0/a_705_407# -0
C660 P0 1bitblock_0/a_9050_63# 0.0052f
C661 P1 MUX21_0/a_718_407# 0
C662 P2 P1 1.22078f
C663 P1 A2 0
C664 P3 1bitblock$3_0/m2_9431_79# 0.0201f
C665 1bitblock$1_0/a_3940_63# VDD 0
C666 AND4_0/a_518_229# VDD 0.0239f
C667 1bitblock$2_0/a_5042_n37# S0 0
C668 P0 B1 0.00256f
C669 P1 1bitblock_0/a_1845_466# 0.00247f
C670 S1 1bitblock_0/a_9609_407# 0.00143f
C671 AND4_0/a_912_n441# P1 0.01194f
C672 S1 1bitblock$2_0/a_8160_n37# 0.00164f
C673 1bitblock_0/a_705_407# 1bitblock$1_0/a_160_63# 0
C674 1bitblock_0/a_160_63# 1bitblock$1_0/a_705_407# 0
C675 P3.t9 GND 0.02297f
C676 P3.t11 GND 0.04489f
C677 P3.n0 GND 0.08227f
C678 P3.t8 GND 0.00266f
C679 P3.t7 GND 0.03957f
C680 P3.t6 GND 0.25735f
C681 P3.t4 GND 0.04166f
C682 P3.t5 GND 0.0714f
C683 P3.n1 GND 0.43155f
C684 P3.t2 GND 0.28161f
C685 P3.n2 GND 0.0633f
C686 P3.n3 GND 0.36965f
C687 P3.t3 GND 0.00778f
C688 P3.t10 GND 0.05304f
C689 P3.n4 GND 0.06976f
C690 P3.n5 GND 0.1171f
C691 P3.t0 GND 0.04923f
C692 P3.t1 GND 0.02213f
C693 P3.n6 GND 0.92889f
C694 P3.n7 GND 2.27461f
C695 P0.t0 GND 0.10443f
C696 P0.t12 GND 0.04006f
C697 P0.t10 GND 0.02049f
C698 P0.n0 GND 0.07342f
C699 P0.t8 GND 0.03531f
C700 P0.t7 GND 0.22967f
C701 P0.t5 GND 0.03718f
C702 P0.t6 GND 0.06372f
C703 P0.n1 GND 0.38513f
C704 P0.t3 GND 0.25132f
C705 P0.t9 GND 0.00237f
C706 P0.n2 GND 0.05649f
C707 P0.n3 GND 0.32989f
C708 P0.t11 GND 0.04733f
C709 P0.t4 GND 0.00694f
C710 P0.n4 GND 0.06226f
C711 P0.n5 GND 0.10373f
C712 P0.t2 GND 0.04393f
C713 P0.t1 GND 0.01975f
C714 P0.n6 GND 0.84745f
C715 P0.n7 GND 2.38347f
C716 P0.n8 GND 0.14845f
C717 P1.t9 GND 0.02339f
C718 P1.t11 GND 0.04572f
C719 P1.n0 GND 0.08378f
C720 P1.t8 GND 0.0027f
C721 P1.t7 GND 0.04029f
C722 P1.t6 GND 0.26207f
C723 P1.t4 GND 0.04243f
C724 P1.t5 GND 0.07271f
C725 P1.n1 GND 0.43945f
C726 P1.t2 GND 0.28678f
C727 P1.n2 GND 0.06446f
C728 P1.n3 GND 0.37643f
C729 P1.t3 GND 0.00792f
C730 P1.t10 GND 0.05401f
C731 P1.n4 GND 0.07104f
C732 P1.n5 GND 0.17542f
C733 P1.t1 GND 0.05013f
C734 P1.t0 GND 0.02254f
C735 P1.n6 GND 0.93786f
C736 P1.n7 GND 1.80682f
C737 S0.t20 GND -0.01496f
C738 S0.t17 GND -0.00236f
C739 S0.t23 GND 0.05847f
C740 S0.t22 GND 0.04183f
C741 S0.n0 GND 0.08406f
C742 S0.n1 GND 0.1608f
C743 S0.t9 GND -0.00236f
C744 S0.t12 GND -0.01496f
C745 S0.t14 GND 0.04183f
C746 S0.t15 GND 0.05847f
C747 S0.n2 GND 0.08406f
C748 S0.n3 GND 0.1608f
C749 S0.t8 GND -0.00236f
C750 S0.t10 GND -0.01496f
C751 S0.t11 GND 0.03059f
C752 S0.t13 GND 0.05847f
C753 S0.n4 GND 0.0842f
C754 S0.n5 GND 0.10497f
C755 S0.n6 GND 0.90414f
C756 S0.t4 GND -0.01496f
C757 S0.t1 GND -0.00236f
C758 S0.t7 GND 0.05847f
C759 S0.t6 GND 0.04183f
C760 S0.n7 GND 0.08406f
C761 S0.n8 GND 0.1608f
C762 S0.t2 GND -0.01496f
C763 S0.t0 GND -0.00236f
C764 S0.t5 GND 0.05847f
C765 S0.t3 GND 0.03059f
C766 S0.n9 GND 0.0842f
C767 S0.n10 GND 0.10497f
C768 S0.n11 GND 0.83933f
C769 S0.n12 GND 0.48167f
C770 S0.t25 GND -0.00236f
C771 S0.t28 GND -0.01496f
C772 S0.t30 GND 0.04183f
C773 S0.t31 GND 0.05847f
C774 S0.n13 GND 0.08406f
C775 S0.n14 GND 0.1608f
C776 S0.t24 GND -0.00236f
C777 S0.t26 GND -0.01496f
C778 S0.t27 GND 0.03059f
C779 S0.t29 GND 0.05847f
C780 S0.n15 GND 0.0842f
C781 S0.n16 GND 0.10497f
C782 S0.n17 GND 0.83933f
C783 S0.n18 GND 0.47798f
C784 S0.n19 GND 0.87511f
C785 S0.t18 GND -0.01496f
C786 S0.t16 GND -0.00236f
C787 S0.t21 GND 0.05847f
C788 S0.t19 GND 0.03059f
C789 S0.n20 GND 0.0842f
C790 S0.n21 GND 0.09629f
C791 S0.n22 GND 0.02372f
C792 S1.t5 GND 0.03825f
C793 S1.t7 GND 0.05347f
C794 S1.n0 GND 0.0759f
C795 S1.t4 GND 0.00247f
C796 S1.n1 GND 0.04906f
C797 S1.t6 GND 0.02581f
C798 S1.n2 GND 0.0741f
C799 S1.t2 GND 0.02488f
C800 S1.t3 GND 0.05347f
C801 S1.t1 GND 0.03825f
C802 S1.n3 GND 0.0759f
C803 S1.t0 GND 0.00247f
C804 S1.n4 GND 0.04999f
C805 S1.n5 GND 0.0525f
C806 S1.n6 GND 0.53591f
C807 S1.t13 GND 0.03825f
C808 S1.t15 GND 0.05347f
C809 S1.n7 GND 0.0759f
C810 S1.t12 GND 0.00247f
C811 S1.n8 GND 0.0503f
C812 S1.t14 GND 0.02458f
C813 S1.n9 GND 0.0525f
C814 S1.n10 GND 0.49355f
C815 S1.t10 GND 0.02591f
C816 S1.t11 GND 0.05347f
C817 S1.t9 GND 0.03825f
C818 S1.n11 GND 0.0759f
C819 S1.t8 GND 0.00247f
C820 S1.n12 GND 0.04896f
C821 S1.n13 GND 0.03659f
C822 S1.n14 GND 0.06493f
C823 P2.t9 GND 0.03552f
C824 P2.t7 GND 0.01817f
C825 P2.n0 GND 0.06511f
C826 P2.t5 GND 0.03131f
C827 P2.t4 GND 0.20365f
C828 P2.t2 GND 0.03297f
C829 P2.t3 GND 0.0565f
C830 P2.n1 GND 0.3415f
C831 P2.t0 GND 0.22285f
C832 P2.t6 GND 0.0021f
C833 P2.n2 GND 0.05009f
C834 P2.n3 GND 0.29252f
C835 P2.t8 GND 0.04197f
C836 P2.t1 GND 0.00615f
C837 P2.n4 GND 0.05521f
C838 P2.n5 GND 0.09191f
C839 P2.t11 GND 0.03896f
C840 P2.t10 GND 0.01752f
C841 P2.n6 GND 0.58884f
C842 P2.n7 GND 1.93146f
C843 Cin.t7 GND 0.01651f
C844 Cin.t0 GND 0.04534f
C845 Cin.t1 GND 0.14238f
C846 Cin.t2 GND 0.02073f
C847 Cin.t4 GND 0.00888f
C848 Cin.n0 GND 0.03897f
C849 Cin.n1 GND 1.66827f
C850 Cin.t3 GND 0.10641f
C851 Cin.t6 GND 0.03136f
C852 Cin.t5 GND 0.01783f
C853 Cin.n2 GND 0.04122f
C854 Cin.n3 GND 0.04605f
C855 VDD.n0 GND 0.00904f
C856 VDD.n1 GND 0.02715f
C857 VDD.n2 GND 0.15029f
C858 VDD.t13 GND 0.00887f
C859 VDD.n3 GND 0
C860 VDD.n4 GND 0.01152f
C861 VDD.n5 GND 0.03081f
C862 VDD.n6 GND 0.01101f
C863 VDD.n7 GND 0.03274f
C864 VDD.n8 GND 0.02679f
C865 VDD.n9 GND 0.03411f
C866 VDD.n10 GND 0.00904f
C867 VDD.n11 GND 0.04025f
C868 VDD.t15 GND 0.02369f
C869 VDD.n12 GND 0.04026f
C870 VDD.t20 GND 0.00795f
C871 VDD.n13 GND 0.00766f
C872 VDD.n14 GND 0.01687f
C873 VDD.n15 GND 0.00728f
C874 VDD.t22 GND 0.00795f
C875 VDD.n16 GND 0.00766f
C876 VDD.n17 GND 0.01687f
C877 VDD.n18 GND 0.00728f
C878 VDD.t4 GND 0.00795f
C879 VDD.n19 GND 0.00766f
C880 VDD.n20 GND 0.01687f
C881 VDD.n21 GND 0.03005f
C882 VDD.n22 GND 0.15215f
C883 VDD.n23 GND 0.11819f
C884 VDD.t9 GND 0.11931f
C885 VDD.n24 GND 0.14695f
C886 VDD.n25 GND 0.1065f
C887 VDD.t6 GND 0.12821f
C888 VDD.t11 GND 0.10409f
C889 VDD.n26 GND 0.07273f
C890 VDD.t19 GND 0.07273f
C891 VDD.n27 GND 0.10446f
C892 VDD.n28 GND 0.12784f
C893 VDD.n29 GND 0.1271f
C894 VDD.t5 GND 0.10372f
C895 VDD.n30 GND 0.07273f
C896 VDD.t21 GND 0.07273f
C897 VDD.n31 GND 0.10446f
C898 VDD.n32 GND 0.12784f
C899 VDD.n33 GND 0.1271f
C900 VDD.t0 GND 0.10372f
C901 VDD.n34 GND 0.07273f
C902 VDD.t3 GND 0.07273f
C903 VDD.n35 GND 0.10446f
C904 VDD.n36 GND 0.08127f
C905 VDD.n37 GND 0.10538f
C906 VDD.n38 GND 0.05678f
C907 VDD.n39 GND 0.0346f
C908 VDD.n40 GND 0.03524f
C909 VDD.n41 GND 0.03425f
C910 VDD.n42 GND 0.03524f
C911 VDD.n43 GND 0.0355f
C912 VDD.n44 GND 0.02606f
C913 VDD.n45 GND 0.08898f
C914 VDD.n46 GND 0.05121f
C915 VDD.t1 GND 0.07273f
C916 VDD.n47 GND 0.07273f
C917 VDD.t14 GND 0.10409f
C918 VDD.n48 GND 0.13174f
C919 VDD.n49 GND 0.14695f
C920 VDD.n50 GND 0.16291f
C921 VDD.n51 GND 0.11819f
C922 VDD.t10 GND 0.11931f
C923 VDD.n52 GND 0.14695f
C924 VDD.n53 GND 0.1065f
C925 VDD.t16 GND 0.07106f
C926 VDD.n54 GND 0.07014f
C927 VDD.n55 GND 0.06717f
C928 VDD.n56 GND 0.03729f
C929 VDD.t2 GND 0.03859f
C930 VDD.n57 GND 0.07051f
C931 VDD.t12 GND 0.07329f
C932 VDD.n58 GND 0.07162f
C933 VDD.n59 GND 0.10205f
C934 VDD.n60 GND 0.15215f
C935 VDD.n61 GND 1.14295f
C936 m1_12486_242# GND 3.28362f
C937 1bitblock$1_0/a_7083_63# GND 0.85222f
C938 1bitblock$1_0/a_8723_63# GND 0.40722f
C939 1bitblock$1_0/m2_9431_79# GND 0.62597f
C940 1bitblock$1_0/m2_7791_79# GND 0.61991f
C941 1bitblock$1_0/a_9609_407# GND 0.11896f
C942 1bitblock$1_0/a_8361_407# GND 0.05045f
C943 1bitblock$1_0/m2_6151_79# GND 0.6012f
C944 1bitblock$1_0/a_6721_407# GND 0.01523f
C945 1bitblock$1_0/a_5042_407# GND 0.79698f
C946 1bitblock$1_0/a_3940_63# GND 0.46873f
C947 P1 GND 7.8355f
C948 1bitblock$1_0/a_160_63# GND 0.60582f
C949 1bitblock$1_0/a_5243_407# GND 0.01459f
C950 1bitblock$1_0/a_705_407# GND 0.14113f
C951 1bitblock$1_0/a_3498_3# GND 1.27913f
C952 1bitblock$1_0/a_10906_n37# GND 0.02232f
C953 1bitblock$1_0/a_9800_n37# GND 0.01742f
C954 1bitblock$1_0/a_9408_n37# GND 0.01326f
C955 1bitblock$1_0/a_8160_n37# GND 0.01743f
C956 1bitblock$1_0/a_7768_n37# GND 0.01327f
C957 1bitblock$1_0/a_6520_n37# GND 0.01743f
C958 1bitblock$1_0/a_6128_n37# GND 0.01327f
C959 1bitblock$1_0/a_5042_n37# GND 0.01422f
C960 1bitblock$1_0/a_4650_n37# GND 0.01569f
C961 1bitblock$1_0/a_11922_3# GND 0.64605f
C962 1bitblock$1_0/a_11922_391# GND 0.00119f
C963 1bitblock$1_0/a_10906_466# GND 0.59827f
C964 1bitblock$1_0/a_11480_63# GND 0.42359f
C965 Y1 GND 0.13924f
C966 1bitblock$1_0/a_9050_63# GND 0.55145f
C967 1bitblock$1_0/a_7410_63# GND 0.55612f
C968 1bitblock$1_0/a_5768_63# GND 0.55881f
C969 1bitblock$1_0/a_1845_n37# GND 0.01974f
C970 1bitblock$1_0/a_1262_n37# GND 0.0127f
C971 1bitblock$1_0/a_870_n37# GND 0.01586f
C972 1bitblock$1_0/a_4290_63# GND 0.59067f
C973 1bitblock$1_0/a_2861_3# GND 0.62907f
C974 1bitblock$1_0/a_1845_466# GND 0.59871f
C975 1bitblock$1_0/a_2419_63# GND 6.60418f
C976 1bitblock$1_0/a_510_63# GND 0.58168f
C977 B1 GND 1.37799f
C978 A1 GND 1.73478f
C979 Cin GND 4.55052f
C980 1bitblock_0/a_7083_63# GND 0.85222f
C981 1bitblock_0/a_8723_63# GND 0.40569f
C982 1bitblock_0/m2_9431_79# GND 0.62597f
C983 1bitblock_0/m2_7791_79# GND 0.61991f
C984 1bitblock_0/a_8361_407# GND 0.05045f
C985 1bitblock_0/m2_6151_79# GND 0.6012f
C986 1bitblock_0/a_6721_407# GND 0.01523f
C987 1bitblock_0/a_5042_407# GND 0.79698f
C988 1bitblock_0/a_3940_63# GND 0.46873f
C989 P0 GND 4.02595f
C990 1bitblock_0/a_160_63# GND 0.59457f
C991 1bitblock_0/a_5243_407# GND 0.01459f
C992 1bitblock_0/a_705_407# GND 0.13654f
C993 1bitblock_0/a_3498_3# GND 1.27913f
C994 1bitblock_0/a_10906_n37# GND 0.02232f
C995 1bitblock_0/a_9800_n37# GND 0.01742f
C996 1bitblock_0/a_9408_n37# GND 0.01326f
C997 1bitblock_0/a_8160_n37# GND 0.01743f
C998 1bitblock_0/a_7768_n37# GND 0.01327f
C999 1bitblock_0/a_6520_n37# GND 0.01743f
C1000 1bitblock_0/a_6128_n37# GND 0.01327f
C1001 1bitblock_0/a_5042_n37# GND 0.01422f
C1002 1bitblock_0/a_4650_n37# GND 0.01569f
C1003 1bitblock_0/a_11922_3# GND 0.64588f
C1004 1bitblock_0/a_11922_391# GND 0.00119f
C1005 1bitblock_0/a_10906_466# GND 0.59827f
C1006 1bitblock_0/a_11480_63# GND 0.42359f
C1007 Y0 GND 0.13924f
C1008 1bitblock_0/a_9050_63# GND 0.55145f
C1009 1bitblock_0/a_7410_63# GND 0.55612f
C1010 1bitblock_0/a_5768_63# GND 0.55881f
C1011 1bitblock_0/a_1845_n37# GND 0.01974f
C1012 1bitblock_0/a_1262_n37# GND 0.0127f
C1013 1bitblock_0/a_870_n37# GND 0.01517f
C1014 1bitblock_0/a_4290_63# GND 0.59067f
C1015 1bitblock_0/a_2861_3# GND 0.62907f
C1016 1bitblock_0/a_1845_466# GND 0.5987f
C1017 1bitblock_0/a_2419_63# GND 6.63957f
C1018 1bitblock_0/a_510_63# GND 0.58009f
C1019 B0 GND 1.3862f
C1020 1bitblock_0/a_9609_407# GND 0.11896f
C1021 A0 GND 1.78415f
C1022 m2_10721_n3315# GND 3.37517f
C1023 1bitblock$3_0/a_7083_63# GND 0.85964f
C1024 1bitblock$3_0/a_8723_63# GND 0.40583f
C1025 1bitblock$3_0/m2_9431_79# GND 0.62602f
C1026 1bitblock$3_0/m2_7791_79# GND 0.61996f
C1027 1bitblock$3_0/a_9609_407# GND 0.11896f
C1028 1bitblock$3_0/a_8361_407# GND 0.05045f
C1029 1bitblock$3_0/m2_6151_79# GND 0.60126f
C1030 1bitblock$3_0/a_6721_407# GND 0.01523f
C1031 1bitblock$3_0/a_5042_407# GND 0.80196f
C1032 1bitblock$3_0/a_3940_63# GND 0.46874f
C1033 P3 GND 3.8759f
C1034 1bitblock$3_0/a_160_63# GND 0.59446f
C1035 1bitblock$3_0/a_5243_407# GND 0.01459f
C1036 1bitblock$3_0/a_705_407# GND 0.13654f
C1037 1bitblock$3_0/a_3498_3# GND 1.27919f
C1038 1bitblock$3_0/a_10906_n37# GND 0.02232f
C1039 1bitblock$3_0/a_9800_n37# GND 0.01742f
C1040 1bitblock$3_0/a_9408_n37# GND 0.01326f
C1041 1bitblock$3_0/a_8160_n37# GND 0.01743f
C1042 1bitblock$3_0/a_7768_n37# GND 0.01327f
C1043 1bitblock$3_0/a_6520_n37# GND 0.01743f
C1044 1bitblock$3_0/a_6128_n37# GND 0.01327f
C1045 1bitblock$3_0/a_5042_n37# GND 0.01422f
C1046 1bitblock$3_0/a_4650_n37# GND 0.01569f
C1047 m1_12480_n3815# GND 2.92174f
C1048 1bitblock$3_0/a_11922_3# GND 0.64588f
C1049 1bitblock$3_0/a_11922_391# GND 0.00119f
C1050 1bitblock$3_0/a_10906_466# GND 0.59833f
C1051 1bitblock$3_0/a_11480_63# GND 0.42359f
C1052 Y3 GND 0.13924f
C1053 1bitblock$3_0/a_9050_63# GND 0.55151f
C1054 1bitblock$3_0/a_7410_63# GND 0.55618f
C1055 1bitblock$3_0/a_5768_63# GND 0.55887f
C1056 1bitblock$3_0/a_1845_n37# GND 0.01974f
C1057 1bitblock$3_0/a_1262_n37# GND 0.0127f
C1058 1bitblock$3_0/a_870_n37# GND 0.01517f
C1059 1bitblock$3_0/a_4290_63# GND 0.59072f
C1060 1bitblock$3_0/a_2861_3# GND 0.62907f
C1061 1bitblock$3_0/a_1845_466# GND 0.59877f
C1062 1bitblock$3_0/a_2419_63# GND 6.72858f
C1063 1bitblock$3_0/a_510_63# GND 0.58009f
C1064 B3 GND 1.38584f
C1065 A3 GND 1.79932f
C1066 AND4_0/a_1120_n441# GND 0.02626f
C1067 AND4_0/a_912_n441# GND 0.02949f
C1068 AND4_0/a_704_n441# GND 0.03642f
C1069 BP GND 2.96054f
C1070 AND4_0/a_518_229# GND 0.81913f
C1071 m1_12484_n953# GND 3.35772f
C1072 1bitblock$2_0/a_7083_63# GND 0.85965f
C1073 1bitblock$2_0/a_8723_63# GND 0.40727f
C1074 1bitblock$2_0/m2_9431_79# GND 0.62602f
C1075 1bitblock$2_0/m2_7791_79# GND 0.61996f
C1076 1bitblock$2_0/a_9609_407# GND 0.11896f
C1077 1bitblock$2_0/a_8361_407# GND 0.05045f
C1078 1bitblock$2_0/m2_6151_79# GND 0.60126f
C1079 1bitblock$2_0/a_6721_407# GND 0.01523f
C1080 1bitblock$2_0/a_5042_407# GND 0.80196f
C1081 1bitblock$2_0/a_3940_63# GND 0.46875f
C1082 P2 GND 3.94205f
C1083 1bitblock$2_0/a_160_63# GND 0.60571f
C1084 1bitblock$2_0/a_5243_407# GND 0.01459f
C1085 1bitblock$2_0/a_705_407# GND 0.14113f
C1086 1bitblock$2_0/a_3498_3# GND 1.27919f
C1087 1bitblock$2_0/a_10906_n37# GND 0.02232f
C1088 1bitblock$2_0/a_9800_n37# GND 0.01742f
C1089 1bitblock$2_0/a_9408_n37# GND 0.01326f
C1090 1bitblock$2_0/a_8160_n37# GND 0.01743f
C1091 1bitblock$2_0/a_7768_n37# GND 0.01327f
C1092 1bitblock$2_0/a_6520_n37# GND 0.01743f
C1093 1bitblock$2_0/a_6128_n37# GND 0.01327f
C1094 1bitblock$2_0/a_5042_n37# GND 0.01422f
C1095 1bitblock$2_0/a_4650_n37# GND 0.01569f
C1096 1bitblock$2_0/a_11922_3# GND 0.64587f
C1097 1bitblock$2_0/a_11922_391# GND 0.00119f
C1098 1bitblock$2_0/a_10906_466# GND 0.59833f
C1099 1bitblock$2_0/a_11480_63# GND 0.42359f
C1100 Y2 GND 0.13924f
C1101 1bitblock$2_0/a_9050_63# GND 0.55151f
C1102 S1 GND 2.91491f
C1103 1bitblock$2_0/a_7410_63# GND 0.55618f
C1104 1bitblock$2_0/a_5768_63# GND 0.55887f
C1105 1bitblock$2_0/a_1845_n37# GND 0.01974f
C1106 1bitblock$2_0/a_1262_n37# GND 0.0127f
C1107 1bitblock$2_0/a_870_n37# GND 0.01586f
C1108 1bitblock$2_0/a_4290_63# GND 0.59072f
C1109 1bitblock$2_0/a_2861_3# GND 0.62907f
C1110 1bitblock$2_0/a_1845_466# GND 0.59875f
C1111 1bitblock$2_0/a_2419_63# GND 6.72858f
C1112 1bitblock$2_0/a_510_63# GND 0.58168f
C1113 B2 GND 1.37761f
C1114 VDD GND 0.13295p
C1115 A2 GND 1.74931f
C1116 S0 GND 5.26f
C1117 MUX21_0/m2_540_79# GND 0.82007f
C1118 MUX21_0/a_718_407# GND 0.15145f
C1119 MUX21_0/a_909_n37# GND 0.01743f
C1120 MUX21_0/a_517_n37# GND 0.01327f
C1121 Cout GND 0.17252f
C1122 MUX21_0/a_157_63# GND 0.65278f
.ends
